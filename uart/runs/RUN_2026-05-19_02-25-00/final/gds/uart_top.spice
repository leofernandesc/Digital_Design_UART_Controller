* NGSPICE file created from uart_top.ext - technology: ihp-sg13g2

.subckt sg13g2_nand4_1 VDD Y B C VSS A D a_350_122# a_146_122# a_248_122#
X0 Y D VDD VDD sg13_lv_pmos ad=0.2128p pd=1.5u as=0.3808p ps=2.92u w=1.12u l=0.13u
X1 VDD C Y VDD sg13_lv_pmos ad=0.2128p pd=1.5u as=0.2128p ps=1.5u w=1.12u l=0.13u
X2 Y B VDD VDD sg13_lv_pmos ad=0.2128p pd=1.5u as=0.2128p ps=1.5u w=1.12u l=0.13u
X3 VDD A Y VDD sg13_lv_pmos ad=0.3808p pd=2.92u as=0.2128p ps=1.5u w=1.12u l=0.13u
X4 a_146_122# D VSS VSS sg13_lv_nmos ad=0.1406p pd=1.12u as=0.2516p ps=2.16u w=0.74u l=0.13u
X5 a_248_122# C a_146_122# VSS sg13_lv_nmos ad=0.1406p pd=1.12u as=0.1406p ps=1.12u w=0.74u l=0.13u
X6 a_350_122# B a_248_122# VSS sg13_lv_nmos ad=0.1406p pd=1.12u as=0.1406p ps=1.12u w=0.74u l=0.13u
X7 Y A a_350_122# VSS sg13_lv_nmos ad=0.2516p pd=2.16u as=0.1406p ps=1.12u w=0.74u l=0.13u
C0 a_146_122# A 0.00255f
C1 a_350_122# B 0
C2 C a_146_122# 0.00463f
C3 a_146_122# Y 0
C4 a_350_122# A 0.01498f
C5 a_248_122# B 0.00894f
C6 VDD B 0.06422f
C7 a_350_122# Y 0.0034f
C8 a_248_122# A 0.00438f
C9 B A 0.15921f
C10 VDD A 0.06841f
C11 D B 0.00119f
C12 VDD D 0.10815f
C13 a_248_122# Y 0.00116f
C14 B Y 0.03997f
C15 D A 0
C16 C B 0.0968f
C17 VDD Y 0.65519f
C18 VDD C 0.06231f
C19 A Y 0.19155f
C20 C A 0.00144f
C21 D Y 0.00615f
C22 D C 0.10021f
C23 C Y 0.04534f
C24 a_146_122# B 0.00217f
C25 VDD a_146_122# 0
C26 Y VSS 0.11884f
C27 A VSS 0.28662f
C28 B VSS 0.25681f
C29 C VSS 0.23783f
C30 D VSS 0.31842f
C31 VDD VSS 0.1856f
C32 a_350_122# VSS 0.00326f
C33 a_248_122# VSS 0.00787f
C34 a_146_122# VSS 0.01185f
.ends

.subckt sg13g2_o21ai_1 VSS VDD Y B1 A2 A1 a_22_110# a_120_432#
X0 VSS A1 a_22_110# VSS sg13_lv_nmos ad=0.1406p pd=1.12u as=0.2516p ps=2.16u w=0.74u l=0.15u
X1 a_120_432# A1 VDD VDD sg13_lv_pmos ad=0.2128p pd=1.5u as=0.3808p ps=2.92u w=1.12u l=0.15u
X2 a_22_110# A2 VSS VSS sg13_lv_nmos ad=0.1406p pd=1.12u as=0.1406p ps=1.12u w=0.74u l=0.15u
X3 Y B1 a_22_110# VSS sg13_lv_nmos ad=0.2516p pd=2.16u as=0.1406p ps=1.12u w=0.74u l=0.15u
X4 Y A2 a_120_432# VDD sg13_lv_pmos ad=0.2128p pd=1.5u as=0.2128p ps=1.5u w=1.12u l=0.15u
X5 VDD B1 Y VDD sg13_lv_pmos ad=0.3808p pd=2.92u as=0.2128p ps=1.5u w=1.12u l=0.15u
C0 Y A2 0.00831f
C1 a_120_432# Y 0.01075f
C2 VDD Y 0.25563f
C3 Y B1 0.14887f
C4 a_22_110# A1 0.08993f
C5 A1 A2 0.16466f
C6 a_22_110# A2 0.07347f
C7 a_22_110# a_120_432# 0.00202f
C8 VDD A1 0.10532f
C9 a_22_110# B1 0.0343f
C10 a_22_110# VDD 0.01054f
C11 a_120_432# A2 0.00412f
C12 A2 B1 0.13775f
C13 VDD A2 0.07355f
C14 VDD a_120_432# 0.01765f
C15 VDD B1 0.07683f
C16 Y A1 0.00415f
C17 a_22_110# Y 0.09468f
C18 Y VSS 0.1332f
C19 B1 VSS 0.26491f
C20 A2 VSS 0.23928f
C21 A1 VSS 0.29152f
C22 VDD VSS 0.15947f
C23 a_22_110# VSS 0.23844f
.ends

.subckt sg13g2_nand2_1 Y VDD A VSS B a_154_118#
X0 a_154_118# B VSS VSS sg13_lv_nmos ad=0.1406p pd=1.12u as=0.2516p ps=2.16u w=0.74u l=0.13u
X1 Y A a_154_118# VSS sg13_lv_nmos ad=0.2516p pd=2.16u as=0.1406p ps=1.12u w=0.74u l=0.13u
X2 Y B VDD VDD sg13_lv_pmos ad=0.2128p pd=1.5u as=0.3808p ps=2.92u w=1.12u l=0.13u
X3 VDD A Y VDD sg13_lv_pmos ad=0.3808p pd=2.92u as=0.2128p ps=1.5u w=1.12u l=0.13u
C0 Y B 0.09606f
C1 a_154_118# Y 0.01478f
C2 Y A 0.18104f
C3 VDD B 0.13471f
C4 a_154_118# VDD 0
C5 VDD A 0.13631f
C6 B A 0.03549f
C7 Y VDD 0.35534f
C8 Y VSS 0.14921f
C9 A VSS 0.27833f
C10 B VSS 0.34136f
C11 VDD VSS 0.18798f
C12 a_154_118# VSS 0.00954f
.ends

.subckt sg13g2_nor4_1 VSS VDD B C Y A D a_252_412# a_354_412# a_150_412#
X0 a_252_412# B a_150_412# VDD sg13_lv_pmos ad=0.2128p pd=1.5u as=0.2128p ps=1.5u w=1.12u l=0.13u
X1 VSS D Y VSS sg13_lv_nmos ad=0.23757p pd=2.16u as=0.1406p ps=1.12u w=0.74u l=0.13u
X2 a_354_412# C a_252_412# VDD sg13_lv_pmos ad=0.2128p pd=1.5u as=0.2128p ps=1.5u w=1.12u l=0.13u
X3 Y D a_354_412# VDD sg13_lv_pmos ad=0.4368p pd=3.02u as=0.2128p ps=1.5u w=1.12u l=0.13u
X4 Y A VSS VSS sg13_lv_nmos ad=0.1406p pd=1.12u as=0.2516p ps=2.16u w=0.74u l=0.13u
X5 a_150_412# A VDD VDD sg13_lv_pmos ad=0.2128p pd=1.5u as=0.3808p ps=2.92u w=1.12u l=0.13u
X6 VSS B Y VSS sg13_lv_nmos ad=0.1406p pd=1.12u as=0.1406p ps=1.12u w=0.74u l=0.13u
X7 Y C VSS VSS sg13_lv_nmos ad=0.1406p pd=1.12u as=0.1406p ps=1.12u w=0.74u l=0.13u
C0 D B 0.00137f
C1 A VDD 0.10226f
C2 A C 0.00143f
C3 a_150_412# B 0.00654f
C4 Y A 0.00424f
C5 D a_354_412# 0.01872f
C6 B VDD 0.06451f
C7 B C 0.13277f
C8 D a_150_412# 0.00257f
C9 B Y 0.07201f
C10 a_354_412# VDD 0.00639f
C11 D VDD 0.08653f
C12 D a_252_412# 0.00484f
C13 C a_354_412# 0.00109f
C14 D C 0.17586f
C15 a_150_412# VDD 0.01693f
C16 Y a_354_412# 0.00721f
C17 D Y 0.29969f
C18 a_150_412# C 0.00293f
C19 a_252_412# VDD 0.0114f
C20 B A 0.13275f
C21 a_150_412# Y 0.00183f
C22 C VDD 0.07676f
C23 a_252_412# C 0.01274f
C24 Y VDD 0.06531f
C25 a_252_412# Y 0.00319f
C26 D A 0
C27 Y C 0.06437f
C28 Y VSS 0.52358f
C29 D VSS 0.25802f
C30 C VSS 0.23959f
C31 B VSS 0.22965f
C32 A VSS 0.32252f
C33 VDD VSS 0.15278f
C34 a_150_412# VSS 0
.ends

.subckt sg13g2_nor2_1 A VDD Y VSS B a_170_412#
X0 Y A VSS VSS sg13_lv_nmos ad=0.1406p pd=1.12u as=0.2516p ps=2.16u w=0.74u l=0.13u
X1 a_170_412# A VDD VDD sg13_lv_pmos ad=0.1176p pd=1.33u as=0.4032p ps=2.96u w=1.12u l=0.13u
X2 VSS B Y VSS sg13_lv_nmos ad=0.2516p pd=2.16u as=0.1406p ps=1.12u w=0.74u l=0.13u
X3 Y B a_170_412# VDD sg13_lv_pmos ad=0.3808p pd=2.92u as=0.1176p ps=1.33u w=1.12u l=0.13u
C0 A VDD 0.10369f
C1 A Y 0.0857f
C2 B VDD 0.06787f
C3 B Y 0.12405f
C4 a_170_412# VDD 0.00784f
C5 Y a_170_412# 0.01284f
C6 B A 0.05647f
C7 Y VDD 0.14531f
C8 Y VSS 0.30197f
C9 B VSS 0.30701f
C10 A VSS 0.31971f
C11 VDD VSS 0.14884f
C12 a_170_412# VSS 0
.ends

.subckt sg13g2_dlygate4sd3_1 A VDD VSS X a_56_118# a_326_118# a_438_182#
X0 VDD A a_56_118# VDD sg13_lv_pmos ad=0.1523p pd=1.38u as=0.1428p ps=1.52u w=0.42u l=0.13u
X1 VSS a_326_118# a_438_182# VSS sg13_lv_nmos ad=0.1426p pd=1.16u as=0.1428p ps=1.52u w=0.42u l=0.5u
X2 VDD a_326_118# a_438_182# VDD sg13_lv_pmos ad=0.2254p pd=1.53u as=0.34p ps=2.68u w=1u l=0.5u
X3 X a_438_182# VDD VDD sg13_lv_pmos ad=0.4256p pd=3u as=0.2254p ps=1.53u w=1.12u l=0.13u
X4 a_326_118# a_56_118# VDD VDD sg13_lv_pmos ad=0.34p pd=2.68u as=0.1523p ps=1.38u w=1u l=0.5u
X5 VSS A a_56_118# VSS sg13_lv_nmos ad=79.8f pd=0.8u as=0.1428p ps=1.52u w=0.42u l=0.13u
X6 X a_438_182# VSS VSS sg13_lv_nmos ad=0.2516p pd=2.16u as=0.1426p ps=1.16u w=0.74u l=0.13u
X7 a_326_118# a_56_118# VSS VSS sg13_lv_nmos ad=0.1428p pd=1.52u as=79.8f ps=0.8u w=0.42u l=0.5u
C0 VDD a_56_118# 0.29986f
C1 X VDD 0.14188f
C2 VDD a_326_118# 0.21855f
C3 VDD a_438_182# 0.18056f
C4 VDD A 0.09104f
C5 a_56_118# a_326_118# 0.26306f
C6 X a_326_118# 0.0066f
C7 a_56_118# a_438_182# 0.00311f
C8 X a_438_182# 0.15526f
C9 A a_56_118# 0.38085f
C10 a_326_118# a_438_182# 0.55452f
C11 A a_326_118# 0
C12 X VSS 0.18594f
C13 A VSS 0.22317f
C14 VDD VSS 0.18416f
C15 a_438_182# VSS 0.37543f
C16 a_326_118# VSS 0.31678f
C17 a_56_118# VSS 0.48098f
.ends

.subckt sg13g2_buf_8 X VDD A VSS a_27_118#
X0 VSS A a_27_118# VSS sg13_lv_nmos ad=0.1406p pd=1.12u as=0.1406p ps=1.12u w=0.74u l=0.13u
X1 VSS A a_27_118# VSS sg13_lv_nmos ad=0.1406p pd=1.12u as=0.2553p ps=2.17u w=0.74u l=0.13u
X2 VDD A a_27_118# VDD sg13_lv_pmos ad=0.2128p pd=1.5u as=0.2128p ps=1.5u w=1.12u l=0.13u
X3 X a_27_118# VSS VSS sg13_lv_nmos ad=0.1406p pd=1.12u as=0.1406p ps=1.12u w=0.74u l=0.13u
X4 VDD A a_27_118# VDD sg13_lv_pmos ad=0.2128p pd=1.5u as=0.3808p ps=2.92u w=1.12u l=0.13u
X5 X a_27_118# VDD VDD sg13_lv_pmos ad=0.2128p pd=1.5u as=0.2128p ps=1.5u w=1.12u l=0.13u
X6 VSS a_27_118# X VSS sg13_lv_nmos ad=0.1406p pd=1.12u as=0.1406p ps=1.12u w=0.74u l=0.13u
X7 VDD a_27_118# X VDD sg13_lv_pmos ad=0.2128p pd=1.5u as=0.2128p ps=1.5u w=1.12u l=0.13u
X8 X a_27_118# VSS VSS sg13_lv_nmos ad=0.1406p pd=1.12u as=0.1406p ps=1.12u w=0.74u l=0.13u
X9 VSS a_27_118# X VSS sg13_lv_nmos ad=0.1406p pd=1.12u as=0.1406p ps=1.12u w=0.74u l=0.13u
X10 X a_27_118# VDD VDD sg13_lv_pmos ad=0.2128p pd=1.5u as=0.2128p ps=1.5u w=1.12u l=0.13u
X11 X a_27_118# VSS VSS sg13_lv_nmos ad=0.1406p pd=1.12u as=0.1406p ps=1.12u w=0.74u l=0.13u
X12 VDD a_27_118# X VDD sg13_lv_pmos ad=0.2128p pd=1.5u as=0.2128p ps=1.5u w=1.12u l=0.13u
X13 X a_27_118# VDD VDD sg13_lv_pmos ad=0.2128p pd=1.5u as=0.2128p ps=1.5u w=1.12u l=0.13u
X14 VSS a_27_118# X VSS sg13_lv_nmos ad=0.1406p pd=1.12u as=0.1406p ps=1.12u w=0.74u l=0.13u
X15 VDD a_27_118# X VDD sg13_lv_pmos ad=0.2128p pd=1.5u as=0.2128p ps=1.5u w=1.12u l=0.13u
X16 X a_27_118# VSS VSS sg13_lv_nmos ad=0.1406p pd=1.12u as=0.1406p ps=1.12u w=0.74u l=0.13u
X17 VSS a_27_118# X VSS sg13_lv_nmos ad=0.2516p pd=2.16u as=0.1406p ps=1.12u w=0.74u l=0.13u
X18 X a_27_118# VDD VDD sg13_lv_pmos ad=0.2128p pd=1.5u as=0.2128p ps=1.5u w=1.12u l=0.13u
X19 VDD a_27_118# X VDD sg13_lv_pmos ad=0.3864p pd=2.93u as=0.2128p ps=1.5u w=1.12u l=0.13u
X20 a_27_118# A VSS VSS sg13_lv_nmos ad=0.1406p pd=1.12u as=0.1406p ps=1.12u w=0.74u l=0.13u
X21 a_27_118# A VDD VDD sg13_lv_pmos ad=0.2128p pd=1.5u as=0.2128p ps=1.5u w=1.12u l=0.13u
C0 X a_27_118# 0.85609f
C1 A VDD 0.18614f
C2 X VDD 1.1647f
C3 a_27_118# VDD 1.02912f
C4 X A 0.00116f
C5 A a_27_118# 0.38802f
C6 X VSS 0.80804f
C7 A VSS 0.73542f
C8 VDD VSS 0.24105f
C9 a_27_118# VSS 2.34974f
.ends

.subckt sg13g2_inv_1 Y A VSS VDD
X0 Y A VSS VSS sg13_lv_nmos ad=0.2516p pd=2.16u as=0.2516p ps=2.16u w=0.74u l=0.13u
X1 Y A VDD VDD sg13_lv_pmos ad=0.3808p pd=2.92u as=0.3808p ps=2.92u w=1.12u l=0.13u
C0 Y VDD 0.17546f
C1 Y A 0.07236f
C2 VDD A 0.11028f
C3 Y VSS 0.21734f
C4 A VSS 0.34374f
C5 VDD VSS 0.13996f
.ends

.subckt sg13g2_decap_4 VDD VSS
X0 VDD VSS VDD VDD sg13_lv_pmos ad=0.34p pd=2.68u as=2.4331p ps=11.58u w=1u l=1u
X1 VSS VDD VSS VSS sg13_lv_nmos ad=0.1428p pd=1.52u as=1.84612p ps=9.32u w=0.42u l=1u
C0 VDD VSS 1.02143f
.ends

.subckt sg13g2_dfrbpq_1 VDD D Q CLK VSS RESET_B a_2002_114# a_741_93# a_612_127# a_2250_412#
+ a_1840_334# a_1785_429# a_843_236# a_132_114# a_681_505# a_38_114# a_324_432# a_1583_191#
+ a_1489_191# a_550_127# a_298_337#
X0 VSS RESET_B a_132_114# VSS sg13_lv_nmos ad=0.1626p pd=1.415u as=60.89999f ps=0.71u w=0.42u l=0.13u
X1 a_550_127# RESET_B VSS VSS sg13_lv_nmos ad=37.8f pd=0.6u as=0.1701p ps=1.65u w=0.42u l=0.13u
X2 a_298_337# a_741_93# a_681_505# VDD sg13_lv_pmos ad=79.8f pd=0.8u as=63f ps=0.72u w=0.42u l=0.13u
X3 a_1840_334# a_1583_191# a_2002_114# VSS sg13_lv_nmos ad=0.1428p pd=1.52u as=37.8f ps=0.6u w=0.42u l=0.13u
X4 a_38_114# a_843_236# a_298_337# VDD sg13_lv_pmos ad=0.1428p pd=1.52u as=79.8f ps=0.8u w=0.42u l=0.13u
X5 a_741_93# CLK VSS VSS sg13_lv_nmos ad=0.2516p pd=2.16u as=2.26778p ps=14.665u w=0.74u l=0.13u
X6 a_38_114# D VDD VDD sg13_lv_pmos ad=79.8f pd=0.8u as=0.1428p ps=1.52u w=0.42u l=0.13u
X7 a_741_93# CLK VDD VDD sg13_lv_pmos ad=0.4088p pd=2.97u as=1.12285p ps=7.26u w=1.12u l=0.13u
X8 VSS a_741_93# a_843_236# VSS sg13_lv_nmos ad=2.26778p pd=14.665u as=0.2516p ps=2.16u w=0.74u l=0.13u
X9 VSS a_1840_334# a_1489_191# VSS sg13_lv_nmos ad=79.8f pd=0.8u as=0.1428p ps=1.52u w=0.42u l=0.13u
X10 VDD RESET_B a_38_114# VDD sg13_lv_pmos ad=0.36237p pd=2.605u as=79.8f ps=0.8u w=0.42u l=0.13u
X11 a_324_432# a_298_337# VSS VSS sg13_lv_nmos ad=0.2516p pd=2.16u as=0.1626p ps=1.415u w=0.74u l=0.13u
X12 VDD a_741_93# a_843_236# VDD sg13_lv_pmos ad=1.12285p pd=7.26u as=0.3864p ps=2.93u w=1.12u l=0.13u
X13 a_2002_114# RESET_B VSS VSS sg13_lv_nmos ad=37.8f pd=0.6u as=79.8f ps=0.8u w=0.42u l=0.13u
X14 VDD a_1583_191# a_2250_412# VDD sg13_lv_pmos ad=0.2128p pd=1.5u as=0.3864p ps=2.93u w=1.12u l=0.13u
X15 Q a_2250_412# VDD VDD sg13_lv_pmos ad=0.3808p pd=2.92u as=0.2128p ps=1.5u w=1.12u l=0.13u
X16 a_132_114# D a_38_114# VSS sg13_lv_nmos ad=60.89999f pd=0.71u as=0.1428p ps=1.52u w=0.42u l=0.13u
X17 a_1785_429# a_843_236# a_1583_191# VDD sg13_lv_pmos ad=93.45f pd=0.865u as=0.2048p ps=1.63u w=0.42u l=0.13u
X18 VDD a_1583_191# a_1840_334# VDD sg13_lv_pmos ad=1.12285p pd=7.26u as=79.8f ps=0.8u w=0.42u l=0.13u
X19 a_1583_191# a_741_93# a_324_432# VDD sg13_lv_pmos ad=0.2048p pd=1.63u as=0.34p ps=2.68u w=1u l=0.13u
X20 a_1583_191# a_741_93# a_1489_191# VSS sg13_lv_nmos ad=0.12665p pd=1.145u as=0.1428p ps=1.52u w=0.42u l=0.13u
X21 VDD a_1840_334# a_1785_429# VDD sg13_lv_pmos ad=1.12285p pd=7.26u as=93.45f ps=0.865u w=0.42u l=0.13u
X22 a_1840_334# RESET_B VDD VDD sg13_lv_pmos ad=79.8f pd=0.8u as=1.12285p ps=7.26u w=0.42u l=0.13u
X23 a_324_432# a_843_236# a_1583_191# VSS sg13_lv_nmos ad=0.3473p pd=2.71u as=0.12665p ps=1.145u w=0.74u l=0.13u
X24 a_298_337# a_741_93# a_38_114# VSS sg13_lv_nmos ad=79.8f pd=0.8u as=0.1296p ps=1.52u w=0.42u l=0.13u
X25 a_612_127# a_324_432# a_550_127# VSS sg13_lv_nmos ad=0.1428p pd=1.52u as=37.8f ps=0.6u w=0.42u l=0.13u
X26 a_681_505# a_324_432# VDD VDD sg13_lv_pmos ad=63f pd=0.72u as=0.1563p ps=1.22u w=0.42u l=0.13u
X27 a_612_127# a_843_236# a_298_337# VSS sg13_lv_nmos ad=0.2373p pd=1.97u as=79.8f ps=0.8u w=0.42u l=0.13u
X28 VSS a_1583_191# a_2250_412# VSS sg13_lv_nmos ad=0.1406p pd=1.12u as=0.2516p ps=2.16u w=0.74u l=0.13u
X29 a_324_432# a_298_337# VDD VDD sg13_lv_pmos ad=0.34p pd=2.68u as=0.36237p ps=2.605u w=1u l=0.13u
X30 Q a_2250_412# VSS VSS sg13_lv_nmos ad=0.2516p pd=2.16u as=0.1406p ps=1.12u w=0.74u l=0.13u
X31 VDD RESET_B a_298_337# VDD sg13_lv_pmos ad=0.1563p pd=1.22u as=0.147p ps=1.54u w=0.42u l=0.13u
C0 a_612_127# RESET_B 0
C1 a_612_127# a_741_93# 0.01562f
C2 RESET_B D 0.06252f
C3 VDD CLK 0.05935f
C4 CLK a_324_432# 0.06169f
C5 a_1489_191# a_1840_334# 0.008f
C6 RESET_B a_38_114# 0.0806f
C7 a_741_93# a_38_114# 0.02454f
C8 a_1840_334# RESET_B 0.10165f
C9 a_1840_334# a_741_93# 0
C10 a_1785_429# a_843_236# 0
C11 a_1489_191# VDD 0
C12 a_1489_191# a_324_432# 0.43239f
C13 a_843_236# a_298_337# 0.01f
C14 VDD RESET_B 1.12721f
C15 RESET_B a_324_432# 0.36792f
C16 VDD a_741_93# 0.23491f
C17 a_741_93# a_324_432# 0.3749f
C18 a_1583_191# a_843_236# 0.26905f
C19 a_2250_412# RESET_B 0
C20 a_612_127# a_843_236# 0.12701f
C21 a_1489_191# a_2002_114# 0
C22 a_843_236# a_38_114# 0.097f
C23 a_1583_191# Q 0.00144f
C24 a_1840_334# a_843_236# 0.02979f
C25 a_1785_429# a_1583_191# 0.00689f
C26 a_843_236# VDD 0.20377f
C27 a_843_236# a_324_432# 0.34114f
C28 a_612_127# a_298_337# 0.00463f
C29 a_1785_429# a_1840_334# 0.00412f
C30 a_298_337# a_38_114# 0.75507f
C31 a_132_114# a_38_114# 0.00716f
C32 VDD Q 0.21822f
C33 RESET_B CLK 0.00606f
C34 CLK a_741_93# 0.231f
C35 a_1583_191# a_38_114# 0
C36 a_2250_412# Q 0.11397f
C37 a_1785_429# VDD 0
C38 a_612_127# a_38_114# 0.31978f
C39 D a_38_114# 0.25543f
C40 a_1583_191# a_1840_334# 0.34468f
C41 a_612_127# a_550_127# 0
C42 VDD a_298_337# 0.09361f
C43 a_132_114# VDD 0
C44 a_298_337# a_324_432# 0.36952f
C45 a_1489_191# RESET_B 0
C46 a_1489_191# a_741_93# 0.01058f
C47 a_1583_191# VDD 0.16747f
C48 a_1583_191# a_324_432# 0.01529f
C49 a_612_127# VDD 0.00534f
C50 a_612_127# a_324_432# 0.43707f
C51 VDD D 0.08992f
C52 RESET_B a_741_93# 0.03432f
C53 a_1583_191# a_2250_412# 0.0894f
C54 a_681_505# a_298_337# 0.00333f
C55 VDD a_38_114# 0.7744f
C56 a_38_114# a_324_432# 0.41329f
C57 a_843_236# CLK 0.00754f
C58 a_1840_334# VDD 0.16819f
C59 a_1840_334# a_324_432# 0.00242f
C60 a_550_127# a_324_432# 0.0052f
C61 a_1840_334# a_2250_412# 0.10373f
C62 a_1583_191# a_2002_114# 0.00174f
C63 a_681_505# a_38_114# 0.00801f
C64 a_1489_191# a_843_236# 0.00647f
C65 VDD a_324_432# 0.07206f
C66 a_2250_412# VDD 0.37641f
C67 a_843_236# RESET_B 0.42048f
C68 a_843_236# a_741_93# 0.47622f
C69 a_1840_334# a_2002_114# 0.00188f
C70 a_1583_191# CLK 0
C71 a_612_127# CLK 0
C72 a_2250_412# a_2002_114# 0
C73 a_1785_429# RESET_B 0.00351f
C74 CLK a_38_114# 0
C75 a_1489_191# a_1583_191# 0.28931f
C76 RESET_B a_298_337# 0.23212f
C77 a_741_93# a_298_337# 0.02242f
C78 a_1583_191# RESET_B 0.13292f
C79 a_1583_191# a_741_93# 0.00332f
C80 Q VSS 0.24298f
C81 CLK VSS 0.23486f
C82 D VSS 0.22538f
C83 RESET_B VSS 0.72089f
C84 VDD VSS 0.51338f
C85 a_2002_114# VSS 0.00329f
C86 a_1489_191# VSS 0.09495f
C87 a_612_127# VSS 0.03671f
C88 a_2250_412# VSS 0.4394f
C89 a_1840_334# VSS 0.24725f
C90 a_1583_191# VSS 0.54231f
C91 a_132_114# VSS 0
C92 a_843_236# VSS 0.37915f
C93 a_741_93# VSS 0.84197f
C94 a_324_432# VSS 1.59655f
C95 a_38_114# VSS 0.19333f
C96 a_298_337# VSS 0.24243f
.ends

.subckt sg13g2_decap_8 VDD VSS
X0 VDD VSS VDD VDD sg13_lv_pmos ad=0.34p pd=2.68u as=4.13118p ps=17.18u w=1u l=1u
X1 VSS VDD VSS VSS sg13_lv_nmos ad=0.1428p pd=1.52u as=3.1269p ps=15.58u w=0.42u l=1u
X2 VDD VSS VDD VDD sg13_lv_pmos ad=0.19p pd=1.38u as=0 ps=0 w=1u l=1u
X3 VSS VDD VSS VSS sg13_lv_nmos ad=79.8f pd=0.8u as=0 ps=0 w=0.42u l=1u
C0 VDD VSS 1.70328f
.ends

.subckt sg13g2_buf_1 A X VDD VSS a_40_152#
X0 X a_40_152# VSS VSS sg13_lv_nmos ad=0.2886p pd=2.26u as=0.14875p ps=1.16u w=0.74u l=0.13u
X1 X a_40_152# VDD VDD sg13_lv_pmos ad=0.42p pd=2.99u as=0.2114p ps=1.54u w=1.12u l=0.13u
X2 VDD A a_40_152# VDD sg13_lv_pmos ad=0.2114p pd=1.54u as=0.2856p ps=2.36u w=0.84u l=0.13u
X3 VSS A a_40_152# VSS sg13_lv_nmos ad=0.14875p pd=1.16u as=0.187p ps=1.78u w=0.55u l=0.13u
C0 VDD A 0.0816f
C1 a_40_152# A 0.23529f
C2 VDD X 0.09007f
C3 a_40_152# X 0.24411f
C4 a_40_152# VDD 0.21522f
C5 A X 0.00143f
C6 X VSS 0.19609f
C7 A VSS 0.22324f
C8 VDD VSS 0.12141f
C9 a_40_152# VSS 0.4249f
.ends

.subckt sg13g2_and4_1 X B A VDD VSS C D a_277_118# a_379_118# a_175_118# a_81_118#
X0 VDD D a_81_118# VDD sg13_lv_pmos ad=0.2044p pd=1.53u as=0.1848p ps=1.28u w=0.84u l=0.13u
X1 a_175_118# A a_81_118# VSS sg13_lv_nmos ad=0.1216p pd=1.02u as=0.2176p ps=1.96u w=0.64u l=0.13u
X2 a_277_118# B a_175_118# VSS sg13_lv_nmos ad=0.1216p pd=1.02u as=0.1216p ps=1.02u w=0.64u l=0.13u
X3 a_379_118# C a_277_118# VSS sg13_lv_nmos ad=0.1408p pd=1.08u as=0.1216p ps=1.02u w=0.64u l=0.13u
X4 VSS D a_379_118# VSS sg13_lv_nmos ad=0.1447p pd=1.15u as=0.1408p ps=1.08u w=0.64u l=0.13u
X5 X a_81_118# VSS VSS sg13_lv_nmos ad=0.3552p pd=2.44u as=0.1447p ps=1.15u w=0.74u l=0.13u
X6 X a_81_118# VDD VDD sg13_lv_pmos ad=0.5376p pd=3.2u as=0.2044p ps=1.53u w=1.12u l=0.13u
X7 a_81_118# A VDD VDD sg13_lv_pmos ad=0.1596p pd=1.22u as=0.2856p ps=2.36u w=0.84u l=0.13u
X8 VDD B a_81_118# VDD sg13_lv_pmos ad=0.1596p pd=1.22u as=0.1596p ps=1.22u w=0.84u l=0.13u
X9 a_81_118# C VDD VDD sg13_lv_pmos ad=0.1848p pd=1.28u as=0.1596p ps=1.22u w=0.84u l=0.13u
C0 a_81_118# VDD 0.70737f
C1 C a_81_118# 0.0563f
C2 a_81_118# a_379_118# 0.00418f
C3 a_277_118# X 0
C4 a_81_118# D 0.21557f
C5 C VDD 0.06933f
C6 B a_277_118# 0.00265f
C7 a_81_118# a_175_118# 0.00762f
C8 a_81_118# X 0.13893f
C9 a_81_118# A 0.18162f
C10 VDD D 0.07245f
C11 C a_379_118# 0.00228f
C12 B a_81_118# 0.06186f
C13 C D 0.11708f
C14 VDD X 0.13007f
C15 a_379_118# D 0
C16 VDD A 0.07959f
C17 C X 0
C18 B VDD 0.0702f
C19 a_379_118# X 0
C20 D X 0.00401f
C21 C B 0.14215f
C22 D A 0
C23 a_81_118# a_277_118# 0.00512f
C24 a_175_118# X 0
C25 B D 0
C26 a_175_118# A 0.00311f
C27 X A 0
C28 B X 0
C29 B A 0.15375f
C30 X VSS 0.21264f
C31 D VSS 0.23191f
C32 C VSS 0.20595f
C33 B VSS 0.20625f
C34 A VSS 0.23908f
C35 VDD VSS 0.18071f
C36 a_379_118# VSS 0.01293f
C37 a_277_118# VSS 0.00842f
C38 a_175_118# VSS 0.00695f
C39 a_81_118# VSS 0.4151f
.ends

.subckt sg13g2_a21oi_1 VDD VSS A2 A1 B1 Y a_155_412# a_257_140#
X0 Y B1 VSS VSS sg13_lv_nmos ad=0.1406p pd=1.12u as=0.2516p ps=2.16u w=0.74u l=0.13u
X1 a_257_140# A1 Y VSS sg13_lv_nmos ad=0.1406p pd=1.12u as=0.1406p ps=1.12u w=0.74u l=0.13u
X2 VSS A2 a_257_140# VSS sg13_lv_nmos ad=0.2516p pd=2.16u as=0.1406p ps=1.12u w=0.74u l=0.13u
X3 a_155_412# B1 Y VDD sg13_lv_pmos ad=0.2128p pd=1.5u as=0.3808p ps=2.92u w=1.12u l=0.13u
X4 VDD A1 a_155_412# VDD sg13_lv_pmos ad=0.2128p pd=1.5u as=0.2128p ps=1.5u w=1.12u l=0.13u
X5 a_155_412# A2 VDD VDD sg13_lv_pmos ad=0.3808p pd=2.92u as=0.2128p ps=1.5u w=1.12u l=0.13u
C0 VDD B1 0.06738f
C1 A2 a_155_412# 0.07418f
C2 Y VDD 0.05624f
C3 A2 A1 0.1231f
C4 A1 a_155_412# 0.03234f
C5 a_155_412# a_257_140# 0
C6 A1 a_257_140# 0.00719f
C7 a_155_412# B1 0.00414f
C8 A2 Y 0.00366f
C9 A1 B1 0.03191f
C10 a_155_412# Y 0.15622f
C11 A1 Y 0.09773f
C12 Y a_257_140# 0.00663f
C13 A2 VDD 0.06857f
C14 Y B1 0.1687f
C15 a_155_412# VDD 0.2347f
C16 A1 VDD 0.0594f
C17 Y VSS 0.15002f
C18 A2 VSS 0.33944f
C19 A1 VSS 0.24294f
C20 B1 VSS 0.30991f
C21 VDD VSS 0.13819f
C22 a_257_140# VSS 0.01118f
C23 a_155_412# VSS 0.03831f
.ends

.subckt sg13g2_nor3_1 A Y B C VDD VSS a_165_412# a_279_412#
X0 Y A VSS VSS sg13_lv_nmos ad=0.1694p pd=1.21u as=0.2618p ps=2.22u w=0.77u l=0.13u
X1 a_165_412# A VDD VDD sg13_lv_pmos ad=0.2464p pd=1.56u as=0.3808p ps=2.92u w=1.12u l=0.13u
X2 VSS B Y VSS sg13_lv_nmos ad=0.1463p pd=1.15u as=0.1694p ps=1.21u w=0.77u l=0.13u
X3 Y C VSS VSS sg13_lv_nmos ad=0.2618p pd=2.22u as=0.1463p ps=1.15u w=0.77u l=0.13u
X4 a_279_412# B a_165_412# VDD sg13_lv_pmos ad=0.2128p pd=1.5u as=0.2464p ps=1.56u w=1.12u l=0.13u
X5 Y C a_279_412# VDD sg13_lv_pmos ad=0.3808p pd=2.92u as=0.2128p ps=1.5u w=1.12u l=0.13u
C0 a_279_412# Y 0.02655f
C1 VDD C 0.05605f
C2 C Y 0.08229f
C3 B a_279_412# 0.00165f
C4 A VDD 0.1048f
C5 A Y 0.0512f
C6 VDD Y 0.14949f
C7 C B 0.11131f
C8 VDD a_165_412# 0.01349f
C9 A B 0.03265f
C10 Y a_165_412# 0.02315f
C11 VDD B 0.05343f
C12 B Y 0.15497f
C13 VDD a_279_412# 0.00716f
C14 Y VSS 0.38592f
C15 C VSS 0.27786f
C16 B VSS 0.24155f
C17 A VSS 0.33054f
C18 VDD VSS 0.154f
C19 a_165_412# VSS 0
.ends

.subckt sg13g2_nand3_1 VDD Y B C A VSS a_146_122# a_248_122#
X0 Y C VDD VDD sg13_lv_pmos ad=0.2128p pd=1.5u as=0.3808p ps=2.92u w=1.12u l=0.13u
X1 VDD B Y VDD sg13_lv_pmos ad=0.2128p pd=1.5u as=0.2128p ps=1.5u w=1.12u l=0.13u
X2 Y A VDD VDD sg13_lv_pmos ad=0.3808p pd=2.92u as=0.2128p ps=1.5u w=1.12u l=0.13u
X3 a_146_122# C VSS VSS sg13_lv_nmos ad=0.1406p pd=1.12u as=0.2886p ps=2.26u w=0.74u l=0.13u
X4 a_248_122# B a_146_122# VSS sg13_lv_nmos ad=0.1406p pd=1.12u as=0.1406p ps=1.12u w=0.74u l=0.13u
X5 Y A a_248_122# VSS sg13_lv_nmos ad=0.2516p pd=2.16u as=0.1406p ps=1.12u w=0.74u l=0.13u
C0 Y B 0.14198f
C1 Y a_146_122# 0.00609f
C2 C B 0.12786f
C3 VDD Y 0.50606f
C4 A B 0.03712f
C5 C VDD 0.10125f
C6 A VDD 0.07823f
C7 a_146_122# B 0.00482f
C8 VDD B 0.06219f
C9 C Y 0.00893f
C10 VDD a_146_122# 0
C11 A Y 0.19738f
C12 a_248_122# Y 0.01426f
C13 Y VSS 0.1568f
C14 A VSS 0.27778f
C15 B VSS 0.23887f
C16 C VSS 0.31404f
C17 VDD VSS 0.15692f
C18 a_248_122# VSS 0.00708f
C19 a_146_122# VSS 0.01185f
.ends

.subckt sg13g2_mux4_1 X A1 A2 S0 VDD VSS S1 A0 A3 a_1453_124# a_500_118# a_805_385#
+ a_1023_118# a_589_385# a_382_118# a_1377_160# a_295_385# a_810_118# a_71_118# a_1109_431#
+ a_886_118# a_308_118#
X0 a_886_118# a_71_118# a_810_118# VSS sg13_lv_nmos ad=0.1776p pd=1.195u as=80f ps=0.89u w=0.64u l=0.13u
X1 VDD S0 a_71_118# VDD sg13_lv_pmos ad=0.22315p pd=1.555u as=0.34p ps=2.68u w=1u l=0.13u
X2 X a_1377_160# VSS VSS sg13_lv_nmos ad=0.2516p pd=2.16u as=0.1543p ps=1.18u w=0.74u l=0.13u
X3 X a_1377_160# VDD VDD sg13_lv_pmos ad=0.3808p pd=2.92u as=0.34367p ps=1.775u w=1.12u l=0.13u
X4 a_1023_118# S0 a_886_118# VSS sg13_lv_nmos ad=76.8f pd=0.88u as=0.1776p ps=1.195u w=0.64u l=0.13u
X5 VSS S1 a_1453_124# VSS sg13_lv_nmos ad=0.1543p pd=1.18u as=0.2304p ps=2u w=0.64u l=0.13u
X6 VSS A3 a_1023_118# VSS sg13_lv_nmos ad=0.2176p pd=1.96u as=76.8f ps=0.88u w=0.64u l=0.13u
X7 VSS S0 a_71_118# VSS sg13_lv_nmos ad=0.1872p pd=1.225u as=0.2176p ps=1.96u w=0.64u l=0.13u
X8 a_810_118# A2 VSS VSS sg13_lv_nmos ad=80f pd=0.89u as=0.1824p ps=1.21u w=0.64u l=0.13u
X9 a_886_118# S0 a_805_385# VDD sg13_lv_pmos ad=0.4425p pd=1.885u as=0.20762p ps=1.605u w=1u l=0.13u
X10 VDD S1 a_1453_124# VDD sg13_lv_pmos ad=0.34367p pd=1.775u as=0.34p ps=2.68u w=1u l=0.13u
X11 a_382_118# S0 a_295_385# VDD sg13_lv_pmos ad=0.19p pd=1.38u as=0.415p ps=1.83u w=1u l=0.13u
X12 VDD A1 a_589_385# VDD sg13_lv_pmos ad=0.29275p pd=1.785u as=0.16p ps=1.32u w=1u l=0.13u
X13 a_1109_431# a_71_118# a_886_118# VDD sg13_lv_pmos ad=0.135p pd=1.27u as=0.4425p ps=1.885u w=1u l=0.13u
X14 a_295_385# A0 VDD VDD sg13_lv_pmos ad=0.415p pd=1.83u as=0.22315p ps=1.555u w=1u l=0.13u
X15 a_1377_160# S1 a_382_118# VDD sg13_lv_pmos ad=0.2225p pd=1.445u as=0.34p ps=2.68u w=1u l=0.13u
X16 a_308_118# A0 VSS VSS sg13_lv_nmos ad=76.8f pd=0.88u as=0.1872p ps=1.225u w=0.64u l=0.13u
X17 a_500_118# S0 a_382_118# VSS sg13_lv_nmos ad=0.2304p pd=1.36u as=0.1472p ps=1.1u w=0.64u l=0.13u
X18 a_589_385# a_71_118# a_382_118# VDD sg13_lv_pmos ad=0.16p pd=1.32u as=0.19p ps=1.38u w=1u l=0.13u
X19 a_1377_160# S1 a_886_118# VSS sg13_lv_nmos ad=0.1216p pd=1.02u as=0.54188p ps=3.42u w=0.64u l=0.13u
X20 a_382_118# a_71_118# a_308_118# VSS sg13_lv_nmos ad=0.1472p pd=1.1u as=76.8f ps=0.88u w=0.64u l=0.13u
X21 VSS A1 a_500_118# VSS sg13_lv_nmos ad=0.1824p pd=1.21u as=0.2304p ps=1.36u w=0.64u l=0.13u
X22 VDD A3 a_1109_431# VDD sg13_lv_pmos ad=0.34p pd=2.68u as=0.135p ps=1.27u w=1u l=0.13u
X23 a_382_118# a_1453_124# a_1377_160# VSS sg13_lv_nmos ad=0.2176p pd=1.96u as=0.1216p ps=1.02u w=0.64u l=0.13u
X24 a_805_385# A2 VDD VDD sg13_lv_pmos ad=0.20762p pd=1.605u as=0.29275p ps=1.785u w=1u l=0.13u
X25 a_886_118# a_1453_124# a_1377_160# VDD sg13_lv_pmos ad=0.34p pd=2.68u as=0.2225p ps=1.445u w=1u l=0.13u
C0 a_1377_160# S1 0.14457f
C1 a_1453_124# VDD 0.11819f
C2 A3 S1 0.01889f
C3 A1 A2 0.21938f
C4 a_1453_124# S1 0.21448f
C5 VDD S1 0.12827f
C6 A2 VDD 0.06277f
C7 a_71_118# a_805_385# 0.00361f
C8 a_1377_160# X 0.17802f
C9 a_71_118# a_308_118# 0.01005f
C10 a_382_118# a_805_385# 0.01916f
C11 a_589_385# a_886_118# 0
C12 a_1453_124# X 0.00621f
C13 X VDD 0.10163f
C14 X S1 0.0026f
C15 a_589_385# A1 0.00404f
C16 a_71_118# a_382_118# 0.42566f
C17 a_589_385# VDD 0.00197f
C18 a_805_385# a_886_118# 0.00545f
C19 a_1109_431# a_382_118# 0.01223f
C20 a_71_118# S0 0.34178f
C21 a_71_118# a_295_385# 0.01062f
C22 a_308_118# A0 0
C23 a_382_118# S0 0.06033f
C24 a_382_118# a_295_385# 0.02523f
C25 a_71_118# a_810_118# 0.00674f
C26 a_71_118# A0 0.17236f
C27 a_71_118# a_886_118# 0.43413f
C28 a_382_118# a_810_118# 0
C29 a_382_118# A0 0.00998f
C30 a_382_118# a_886_118# 0.85574f
C31 a_308_118# VDD 0
C32 a_805_385# A2 0.00419f
C33 a_1109_431# a_886_118# 0.00734f
C34 a_71_118# a_1023_118# 0
C35 a_71_118# A3 0.0458f
C36 a_71_118# A1 0.14811f
C37 a_382_118# a_1377_160# 0.41984f
C38 a_71_118# VDD 0.3406f
C39 S0 A0 0.15955f
C40 a_886_118# S0 0.02641f
C41 a_295_385# A0 0.00232f
C42 a_382_118# A3 0.13069f
C43 a_382_118# A1 0.11259f
C44 a_382_118# a_1453_124# 0.00979f
C45 a_71_118# A2 0.15938f
C46 a_382_118# VDD 0.744f
C47 a_810_118# a_886_118# 0.00256f
C48 a_1109_431# VDD 0
C49 a_71_118# a_500_118# 0.0287f
C50 S0 A3 0.02476f
C51 A1 S0 0.01671f
C52 a_382_118# S1 0.02853f
C53 a_382_118# A2 0.09263f
C54 a_1109_431# A2 0
C55 a_382_118# a_500_118# 0.0036f
C56 VDD S0 0.56794f
C57 a_295_385# VDD 0.02405f
C58 a_1377_160# a_886_118# 0.32904f
C59 S0 S1 0
C60 a_1023_118# a_886_118# 0.00918f
C61 a_886_118# A3 0.18247f
C62 A2 S0 0.01443f
C63 a_886_118# A1 0
C64 a_1453_124# a_886_118# 0.35001f
C65 VDD A0 0.0679f
C66 a_886_118# VDD 0.02984f
C67 a_810_118# A2 0
C68 a_71_118# a_589_385# 0.0024f
C69 a_886_118# S1 0.02622f
C70 a_886_118# A2 0.01087f
C71 a_1453_124# a_1377_160# 0.22938f
C72 a_1377_160# VDD 0.61806f
C73 a_500_118# a_886_118# 0
C74 a_382_118# a_589_385# 0.01949f
C75 VDD A3 0.08809f
C76 A1 VDD 0.05664f
C77 X VSS 0.29321f
C78 A2 VSS 0.20503f
C79 A1 VSS 0.20768f
C80 S1 VSS 0.66234f
C81 A3 VSS 0.27632f
C82 A0 VSS 0.20294f
C83 S0 VSS 0.73014f
C84 VDD VSS 0.35536f
C85 a_1023_118# VSS 0
C86 a_810_118# VSS 0.00424f
C87 a_500_118# VSS 0.00614f
C88 a_308_118# VSS 0.00348f
C89 a_1377_160# VSS 0.29006f
C90 a_886_118# VSS 0.68706f
C91 a_382_118# VSS 0.01962f
C92 a_1453_124# VSS 0.35661f
C93 a_71_118# VSS 1.0703f
.ends

.subckt sg13g2_a21o_1 B1 X VDD VSS A1 A2 a_358_436# a_115_308# a_494_160#
X0 VSS a_115_308# X VSS sg13_lv_nmos ad=0.15745p pd=1.175u as=0.2351p ps=2.16u w=0.74u l=0.13u
X1 VDD A1 a_358_436# VDD sg13_lv_pmos ad=0.19p pd=1.38u as=0.2125p ps=1.425u w=1u l=0.13u
X2 VSS A2 a_494_160# VSS sg13_lv_nmos ad=0.2176p pd=1.96u as=81.6f ps=0.895u w=0.64u l=0.13u
X3 a_358_436# A2 VDD VDD sg13_lv_pmos ad=0.34p pd=2.68u as=0.19p ps=1.38u w=1u l=0.13u
X4 a_115_308# B1 VSS VSS sg13_lv_nmos ad=0.1216p pd=1.02u as=0.15745p ps=1.175u w=0.64u l=0.13u
X5 a_494_160# A1 a_115_308# VSS sg13_lv_nmos ad=81.6f pd=0.895u as=0.1216p ps=1.02u w=0.64u l=0.13u
X6 a_358_436# B1 a_115_308# VDD sg13_lv_pmos ad=0.2125p pd=1.425u as=0.35p ps=2.7u w=1u l=0.13u
X7 VDD a_115_308# X VDD sg13_lv_pmos ad=0.3808p pd=2.92u as=0.3808p ps=2.92u w=1.12u l=0.13u
C0 A1 a_358_436# 0.06636f
C1 VDD B1 0.07268f
C2 A1 A2 0.05923f
C3 A1 a_494_160# 0
C4 VDD A1 0.06624f
C5 B1 A1 0.13988f
C6 X a_115_308# 0.17404f
C7 X VDD 0.20523f
C8 a_115_308# a_358_436# 0.13617f
C9 A2 a_115_308# 0.00148f
C10 X B1 0
C11 a_115_308# a_494_160# 0
C12 VDD a_115_308# 0.32255f
C13 A2 a_358_436# 0.01543f
C14 a_358_436# a_494_160# 0
C15 B1 a_115_308# 0.20007f
C16 VDD a_358_436# 0.29318f
C17 A2 a_494_160# 0
C18 VDD A2 0.05852f
C19 A1 a_115_308# 0.00476f
C20 B1 a_358_436# 0.04481f
C21 X VSS 0.17763f
C22 A2 VSS 0.57948f
C23 A1 VSS 0.24618f
C24 B1 VSS 0.2056f
C25 VDD VSS 0.15504f
C26 a_494_160# VSS 0.01069f
C27 a_358_436# VSS 0.05587f
C28 a_115_308# VSS 0.53611f
.ends

.subckt sg13g2_xor2_1 X VDD B A VSS a_209_168# a_177_436# a_380_412# a_474_130#
X0 VSS a_209_168# X VSS sg13_lv_nmos ad=0.3108p pd=2.32u as=0.1628p ps=1.18u w=0.74u l=0.13u
X1 VDD A a_380_412# VDD sg13_lv_pmos ad=0.2128p pd=1.5u as=0.3808p ps=2.92u w=1.12u l=0.13u
X2 a_380_412# B VDD VDD sg13_lv_pmos ad=0.2128p pd=1.5u as=0.2128p ps=1.5u w=1.12u l=0.13u
X3 X a_209_168# a_380_412# VDD sg13_lv_pmos ad=0.3808p pd=2.92u as=0.2128p ps=1.5u w=1.12u l=0.13u
X4 a_177_436# A VDD VDD sg13_lv_pmos ad=0.1225p pd=1.245u as=0.36p ps=2.72u w=1u l=0.13u
X5 a_209_168# A VSS VSS sg13_lv_nmos ad=0.17462p pd=1.185u as=0.374p ps=2.46u w=0.55u l=0.13u
X6 a_209_168# B a_177_436# VDD sg13_lv_pmos ad=0.34p pd=2.68u as=0.1225p ps=1.245u w=1u l=0.13u
X7 VSS B a_209_168# VSS sg13_lv_nmos ad=0.15245p pd=1.17u as=0.17462p ps=1.185u w=0.55u l=0.13u
X8 a_474_130# A VSS VSS sg13_lv_nmos ad=88.8f pd=0.98u as=0.15245p ps=1.17u w=0.74u l=0.13u
X9 X B a_474_130# VSS sg13_lv_nmos ad=0.1628p pd=1.18u as=88.8f ps=0.98u w=0.74u l=0.13u
C0 a_209_168# X 0.21684f
C1 VDD X 0.0411f
C2 a_474_130# B 0.00427f
C3 X a_380_412# 0.09723f
C4 a_209_168# VDD 0.20368f
C5 a_209_168# a_380_412# 0.37141f
C6 X B 0.01747f
C7 X A 0.00304f
C8 VDD a_380_412# 0.20664f
C9 a_209_168# B 0.29617f
C10 a_209_168# A 0.07768f
C11 VDD B 0.14698f
C12 a_209_168# a_177_436# 0.00976f
C13 VDD A 0.1728f
C14 a_380_412# B 0.01121f
C15 VDD a_177_436# 0.01058f
C16 A a_380_412# 0.01008f
C17 X a_474_130# 0.00465f
C18 A B 0.13385f
C19 a_209_168# a_474_130# 0
C20 X VSS 0.2595f
C21 B VSS 0.5003f
C22 A VSS 0.70302f
C23 VDD VSS 0.19336f
C24 a_474_130# VSS 0.0076f
C25 a_380_412# VSS 0
C26 a_177_436# VSS 0
C27 a_209_168# VSS 0.38837f
.ends

.subckt sg13g2_xnor2_1 Y B VDD A VSS a_155_160# a_192_429# a_435_412# a_341_118#
X0 a_192_429# A VDD VDD sg13_lv_pmos ad=0.1596p pd=1.22u as=0.4536p ps=2.76u w=0.84u l=0.13u
X1 VSS A a_341_118# VSS sg13_lv_nmos ad=0.1898p pd=1.36u as=0.2516p ps=2.16u w=0.74u l=0.13u
X2 VDD B a_192_429# VDD sg13_lv_pmos ad=0.2891p pd=1.695u as=0.1596p ps=1.22u w=0.84u l=0.13u
X3 a_435_412# A VDD VDD sg13_lv_pmos ad=0.1428p pd=1.375u as=0.2891p ps=1.695u w=1.12u l=0.13u
X4 a_155_160# A VSS VSS sg13_lv_nmos ad=78.39999f pd=0.885u as=0.2272p ps=1.99u w=0.64u l=0.13u
X5 a_341_118# B VSS VSS sg13_lv_nmos ad=0.1406p pd=1.12u as=0.1898p ps=1.36u w=0.74u l=0.13u
X6 Y a_192_429# a_341_118# VSS sg13_lv_nmos ad=0.2516p pd=2.16u as=0.1406p ps=1.12u w=0.74u l=0.13u
X7 VDD a_192_429# Y VDD sg13_lv_pmos ad=0.3808p pd=2.92u as=0.2408p ps=1.55u w=1.12u l=0.13u
X8 Y B a_435_412# VDD sg13_lv_pmos ad=0.2408p pd=1.55u as=0.1428p ps=1.375u w=1.12u l=0.13u
X9 a_192_429# B a_155_160# VSS sg13_lv_nmos ad=0.2176p pd=1.96u as=78.39999f ps=0.885u w=0.64u l=0.13u
C0 a_192_429# A 0.1113f
C1 VDD A 0.1336f
C2 a_341_118# a_155_160# 0
C3 Y a_341_118# 0.0358f
C4 Y B 0.05406f
C5 B a_341_118# 0.00621f
C6 a_155_160# a_192_429# 0.00964f
C7 a_155_160# VDD 0
C8 Y a_435_412# 0.00656f
C9 Y a_192_429# 0.18925f
C10 Y VDD 0.26194f
C11 B a_435_412# 0.00878f
C12 a_341_118# a_192_429# 0.33493f
C13 B a_192_429# 0.31161f
C14 B VDD 0.20802f
C15 Y A 0.00383f
C16 a_341_118# A 0.00894f
C17 a_192_429# a_435_412# 0.00105f
C18 B A 0.33597f
C19 VDD a_435_412# 0.00887f
C20 a_192_429# VDD 0.21893f
C21 Y VSS 0.10604f
C22 B VSS 0.42551f
C23 A VSS 0.61266f
C24 VDD VSS 0.22015f
C25 a_341_118# VSS 0.13901f
C26 a_155_160# VSS 0.00114f
C27 a_192_429# VSS 0.46697f
.ends

.subckt sg13g2_and2_1 X VSS VDD B A a_139_160# a_45_160#
X0 X a_45_160# VDD VDD sg13_lv_pmos ad=0.3808p pd=2.92u as=0.1918p ps=1.5u w=1.12u l=0.13u
X1 X a_45_160# VSS VSS sg13_lv_nmos ad=0.2516p pd=2.16u as=0.1331p ps=1.12u w=0.74u l=0.13u
X2 a_45_160# A VDD VDD sg13_lv_pmos ad=0.1596p pd=1.22u as=0.2856p ps=2.36u w=0.84u l=0.13u
X3 VDD B a_45_160# VDD sg13_lv_pmos ad=0.1918p pd=1.5u as=0.1596p ps=1.22u w=0.84u l=0.13u
X4 a_139_160# A a_45_160# VSS sg13_lv_nmos ad=0.1216p pd=1.02u as=0.2176p ps=1.96u w=0.64u l=0.13u
X5 VSS B a_139_160# VSS sg13_lv_nmos ad=0.1331p pd=1.12u as=0.1216p ps=1.02u w=0.64u l=0.13u
C0 X a_45_160# 0.10327f
C1 B A 0.05836f
C2 B X 0.0079f
C3 VDD a_45_160# 0.38085f
C4 VDD B 0.06801f
C5 B a_45_160# 0.24247f
C6 a_139_160# A 0.00353f
C7 a_139_160# X 0.00153f
C8 A X 0
C9 VDD A 0.07535f
C10 a_139_160# a_45_160# 0.0038f
C11 VDD X 0.16207f
C12 A a_45_160# 0.10387f
C13 a_139_160# B 0.00545f
C14 X VSS 0.20509f
C15 B VSS 0.20389f
C16 A VSS 0.49014f
C17 VDD VSS 0.14267f
C18 a_139_160# VSS 0.00643f
C19 a_45_160# VSS 0.32896f
.ends

.subckt sg13g2_buf_16 A VDD VSS X a_116_82#
X0 VSS a_116_82# X VSS sg13_lv_nmos ad=0.1406p pd=1.12u as=0.1406p ps=1.12u w=0.74u l=0.13u
X1 VDD a_116_82# X VDD sg13_lv_pmos ad=0.2128p pd=1.5u as=0.2128p ps=1.5u w=1.12u l=0.13u
X2 X a_116_82# VSS VSS sg13_lv_nmos ad=0.1406p pd=1.12u as=0.1406p ps=1.12u w=0.74u l=0.13u
X3 X a_116_82# VDD VDD sg13_lv_pmos ad=0.2128p pd=1.5u as=0.2128p ps=1.5u w=1.12u l=0.13u
X4 VSS a_116_82# X VSS sg13_lv_nmos ad=0.1406p pd=1.12u as=0.1406p ps=1.12u w=0.74u l=0.13u
X5 X a_116_82# VSS VSS sg13_lv_nmos ad=0.1406p pd=1.12u as=0.1406p ps=1.12u w=0.74u l=0.13u
X6 VDD a_116_82# X VDD sg13_lv_pmos ad=0.2128p pd=1.5u as=0.2128p ps=1.5u w=1.12u l=0.13u
X7 X a_116_82# VDD VDD sg13_lv_pmos ad=0.2128p pd=1.5u as=0.2128p ps=1.5u w=1.12u l=0.13u
X8 VSS a_116_82# X VSS sg13_lv_nmos ad=0.1406p pd=1.12u as=0.1406p ps=1.12u w=0.74u l=0.13u
X9 VDD a_116_82# X VDD sg13_lv_pmos ad=0.2128p pd=1.5u as=0.2128p ps=1.5u w=1.12u l=0.13u
X10 X a_116_82# VSS VSS sg13_lv_nmos ad=0.1406p pd=1.12u as=0.1406p ps=1.12u w=0.74u l=0.13u
X11 VSS A a_116_82# VSS sg13_lv_nmos ad=0.1406p pd=1.12u as=0.1406p ps=1.12u w=0.74u l=0.13u
X12 X a_116_82# VDD VDD sg13_lv_pmos ad=0.2128p pd=1.5u as=0.2128p ps=1.5u w=1.12u l=0.13u
X13 VDD A a_116_82# VDD sg13_lv_pmos ad=0.2128p pd=1.5u as=0.2128p ps=1.5u w=1.12u l=0.13u
X14 VSS a_116_82# X VSS sg13_lv_nmos ad=0.1406p pd=1.12u as=0.1406p ps=1.12u w=0.74u l=0.13u
X15 a_116_82# A VSS VSS sg13_lv_nmos ad=0.1406p pd=1.12u as=0.1406p ps=1.12u w=0.74u l=0.13u
X16 VDD a_116_82# X VDD sg13_lv_pmos ad=0.2128p pd=1.5u as=0.2128p ps=1.5u w=1.12u l=0.13u
X17 a_116_82# A VDD VDD sg13_lv_pmos ad=0.2128p pd=1.5u as=0.2128p ps=1.5u w=1.12u l=0.13u
X18 a_116_82# A VSS VSS sg13_lv_nmos ad=0.1406p pd=1.12u as=0.1406p ps=1.12u w=0.74u l=0.13u
X19 VSS A a_116_82# VSS sg13_lv_nmos ad=0.1406p pd=1.12u as=0.1406p ps=1.12u w=0.74u l=0.13u
X20 VSS A a_116_82# VSS sg13_lv_nmos ad=0.2516p pd=2.16u as=0.1406p ps=1.12u w=0.74u l=0.13u
X21 a_116_82# A VDD VDD sg13_lv_pmos ad=0.2128p pd=1.5u as=0.2128p ps=1.5u w=1.12u l=0.13u
X22 VDD A a_116_82# VDD sg13_lv_pmos ad=0.2128p pd=1.5u as=0.2128p ps=1.5u w=1.12u l=0.13u
X23 VDD A a_116_82# VDD sg13_lv_pmos ad=0.3808p pd=2.92u as=0.2128p ps=1.5u w=1.12u l=0.13u
X24 a_116_82# A VSS VSS sg13_lv_nmos ad=0.1406p pd=1.12u as=0.1406p ps=1.12u w=0.74u l=0.13u
X25 X a_116_82# VSS VSS sg13_lv_nmos ad=0.1406p pd=1.12u as=0.2516p ps=2.16u w=0.74u l=0.13u
X26 a_116_82# A VDD VDD sg13_lv_pmos ad=0.2128p pd=1.5u as=0.2128p ps=1.5u w=1.12u l=0.13u
X27 X a_116_82# VDD VDD sg13_lv_pmos ad=0.2128p pd=1.5u as=0.3976p ps=2.95u w=1.12u l=0.13u
X28 VSS a_116_82# X VSS sg13_lv_nmos ad=0.1406p pd=1.12u as=0.1406p ps=1.12u w=0.74u l=0.13u
X29 X a_116_82# VSS VSS sg13_lv_nmos ad=0.1406p pd=1.12u as=0.1406p ps=1.12u w=0.74u l=0.13u
X30 VDD a_116_82# X VDD sg13_lv_pmos ad=0.2128p pd=1.5u as=0.2128p ps=1.5u w=1.12u l=0.13u
X31 X a_116_82# VDD VDD sg13_lv_pmos ad=0.2128p pd=1.5u as=0.2128p ps=1.5u w=1.12u l=0.13u
X32 VSS a_116_82# X VSS sg13_lv_nmos ad=0.1406p pd=1.12u as=0.1406p ps=1.12u w=0.74u l=0.13u
X33 X a_116_82# VSS VSS sg13_lv_nmos ad=0.1406p pd=1.12u as=0.1406p ps=1.12u w=0.74u l=0.13u
X34 VDD a_116_82# X VDD sg13_lv_pmos ad=0.2128p pd=1.5u as=0.2128p ps=1.5u w=1.12u l=0.13u
X35 VSS a_116_82# X VSS sg13_lv_nmos ad=0.1406p pd=1.12u as=0.1406p ps=1.12u w=0.74u l=0.13u
X36 X a_116_82# VDD VDD sg13_lv_pmos ad=0.2128p pd=1.5u as=0.2128p ps=1.5u w=1.12u l=0.13u
X37 VDD a_116_82# X VDD sg13_lv_pmos ad=0.2128p pd=1.5u as=0.2128p ps=1.5u w=1.12u l=0.13u
X38 X a_116_82# VSS VSS sg13_lv_nmos ad=0.1406p pd=1.12u as=0.1406p ps=1.12u w=0.74u l=0.13u
X39 VSS a_116_82# X VSS sg13_lv_nmos ad=0.1406p pd=1.12u as=0.1406p ps=1.12u w=0.74u l=0.13u
X40 X a_116_82# VDD VDD sg13_lv_pmos ad=0.2128p pd=1.5u as=0.2128p ps=1.5u w=1.12u l=0.13u
X41 VDD a_116_82# X VDD sg13_lv_pmos ad=0.2128p pd=1.5u as=0.2128p ps=1.5u w=1.12u l=0.13u
X42 X a_116_82# VSS VSS sg13_lv_nmos ad=0.1406p pd=1.12u as=0.1406p ps=1.12u w=0.74u l=0.13u
X43 X a_116_82# VDD VDD sg13_lv_pmos ad=0.2128p pd=1.5u as=0.2128p ps=1.5u w=1.12u l=0.13u
C0 A a_116_82# 0.45191f
C1 VDD X 2.42694f
C2 VDD A 0.38999f
C3 A X 0.00116f
C4 VDD a_116_82# 1.98497f
C5 X a_116_82# 1.15645f
C6 X VSS 1.74416f
C7 A VSS 1.45719f
C8 VDD VSS 0.42736f
C9 a_116_82# VSS 4.52746f
.ends

.subckt sg13g2_nand2b_1 VSS A_N Y B VDD a_27_156# a_229_118#
X0 VSS A_N a_27_156# VSS sg13_lv_nmos ad=0.14505p pd=1.15u as=0.187p ps=1.78u w=0.55u l=0.13u
X1 VDD a_27_156# Y VDD sg13_lv_pmos ad=0.3808p pd=2.92u as=0.2128p ps=1.5u w=1.12u l=0.13u
X2 a_229_118# B VSS VSS sg13_lv_nmos ad=0.1406p pd=1.12u as=0.14505p ps=1.15u w=0.74u l=0.13u
X3 VDD A_N a_27_156# VDD sg13_lv_pmos ad=0.2198p pd=1.53u as=0.2856p ps=2.36u w=0.84u l=0.13u
X4 Y B VDD VDD sg13_lv_pmos ad=0.2128p pd=1.5u as=0.2198p ps=1.53u w=1.12u l=0.13u
X5 Y a_27_156# a_229_118# VSS sg13_lv_nmos ad=0.333p pd=2.38u as=0.1406p ps=1.12u w=0.74u l=0.13u
C0 Y a_27_156# 0.28225f
C1 A_N B 0.0722f
C2 A_N Y 0
C3 VDD a_27_156# 0.23494f
C4 VDD A_N 0.05659f
C5 A_N a_27_156# 0.15334f
C6 a_229_118# Y 0.00593f
C7 B Y 0.00619f
C8 VDD B 0.062f
C9 a_229_118# a_27_156# 0.01117f
C10 VDD Y 0.26206f
C11 B a_27_156# 0.24426f
C12 Y VSS 0.141f
C13 A_N VSS 0.2227f
C14 B VSS 0.23878f
C15 VDD VSS 0.14601f
C16 a_229_118# VSS 0.00844f
C17 a_27_156# VSS 0.42941f
.ends

.subckt sg13g2_and3_1 X B VDD VSS C A a_272_160# a_170_160# a_76_160#
X0 a_170_160# A a_76_160# VSS sg13_lv_nmos ad=0.1216p pd=1.02u as=0.2176p ps=1.96u w=0.64u l=0.13u
X1 a_272_160# B a_170_160# VSS sg13_lv_nmos ad=0.1216p pd=1.02u as=0.1216p ps=1.02u w=0.64u l=0.13u
X2 VSS C a_272_160# VSS sg13_lv_nmos ad=0.1371p pd=1.12u as=0.1216p ps=1.02u w=0.64u l=0.13u
X3 VDD A a_76_160# VDD sg13_lv_pmos ad=0.1596p pd=1.22u as=0.2856p ps=2.36u w=0.84u l=0.13u
X4 a_76_160# B VDD VDD sg13_lv_pmos ad=0.1596p pd=1.22u as=0.1596p ps=1.22u w=0.84u l=0.13u
X5 VDD C a_76_160# VDD sg13_lv_pmos ad=0.36195p pd=1.84u as=0.1596p ps=1.22u w=0.84u l=0.13u
X6 X a_76_160# VDD VDD sg13_lv_pmos ad=0.3808p pd=2.92u as=0.36195p ps=1.84u w=1.12u l=0.13u
X7 X a_76_160# VSS VSS sg13_lv_nmos ad=0.2516p pd=2.16u as=0.1371p ps=1.12u w=0.74u l=0.13u
C0 B a_76_160# 0.1676f
C1 A C 0.0043f
C2 A VDD 0.07492f
C3 a_272_160# X 0.00156f
C4 A B 0.11423f
C5 a_170_160# X 0
C6 X C 0.00787f
C7 X VDD 0.14408f
C8 X B 0
C9 a_272_160# C 0
C10 A a_76_160# 0.07944f
C11 a_272_160# B 0.00267f
C12 VDD C 0.07751f
C13 a_170_160# B 0.00303f
C14 B C 0.15081f
C15 VDD B 0.07365f
C16 X a_76_160# 0.15454f
C17 a_272_160# a_76_160# 0.00339f
C18 X A 0
C19 a_170_160# a_76_160# 0.00565f
C20 a_272_160# A 0.00761f
C21 a_76_160# C 0.19072f
C22 VDD a_76_160# 0.60974f
C23 a_170_160# A 0.01021f
C24 X VSS 0.18581f
C25 C VSS 0.22264f
C26 B VSS 0.18972f
C27 A VSS 0.54047f
C28 VDD VSS 0.1553f
C29 a_272_160# VSS 0.00339f
C30 a_170_160# VSS 0
C31 a_76_160# VSS 0.35416f
.ends

.subckt sg13g2_nor2b_1 A B_N VDD Y VSS a_268_412# a_46_156#
X0 VDD B_N a_46_156# VDD sg13_lv_pmos ad=0.2618p pd=1.63u as=0.2856p ps=2.36u w=0.84u l=0.13u
X1 VSS B_N a_46_156# VSS sg13_lv_nmos ad=0.17255p pd=1.25u as=0.187p ps=1.78u w=0.55u l=0.13u
X2 Y a_46_156# VSS VSS sg13_lv_nmos ad=0.1406p pd=1.12u as=0.17255p ps=1.25u w=0.74u l=0.13u
X3 a_268_412# a_46_156# VDD VDD sg13_lv_pmos ad=0.1176p pd=1.33u as=0.2618p ps=1.63u w=1.12u l=0.13u
X4 VSS A Y VSS sg13_lv_nmos ad=0.2516p pd=2.16u as=0.1406p ps=1.12u w=0.74u l=0.13u
X5 Y A a_268_412# VDD sg13_lv_pmos ad=0.3808p pd=2.92u as=0.1176p ps=1.33u w=1.12u l=0.13u
C0 A VDD 0.06635f
C1 a_46_156# a_268_412# 0
C2 a_46_156# Y 0.24618f
C3 a_46_156# B_N 0.24559f
C4 VDD a_268_412# 0.00696f
C5 VDD Y 0.09838f
C6 VDD B_N 0.06438f
C7 A Y 0.13551f
C8 VDD a_46_156# 0.1854f
C9 a_268_412# Y 0.01288f
C10 B_N Y 0.00119f
C11 A a_46_156# 0.05783f
C12 Y VSS 0.2199f
C13 B_N VSS 0.23149f
C14 A VSS 0.32277f
C15 VDD VSS 0.13707f
C16 a_268_412# VSS 0
C17 a_46_156# VSS 0.40145f
.ends

.subckt sg13g2_a221oi_1 C1 Y B2 B1 A2 VDD A1 VSS a_142_412# a_244_140# a_550_140#
+ a_244_412#
X0 a_550_140# A1 Y VSS sg13_lv_nmos ad=0.1406p pd=1.12u as=0.2516p ps=2.16u w=0.74u l=0.13u
X1 VSS A2 a_550_140# VSS sg13_lv_nmos ad=0.2516p pd=2.16u as=0.1406p ps=1.12u w=0.74u l=0.13u
X2 a_142_412# C1 Y VDD sg13_lv_pmos ad=0.2128p pd=1.5u as=0.3808p ps=2.92u w=1.12u l=0.13u
X3 a_244_412# B2 a_142_412# VDD sg13_lv_pmos ad=0.2128p pd=1.5u as=0.2128p ps=1.5u w=1.12u l=0.13u
X4 a_142_412# B1 a_244_412# VDD sg13_lv_pmos ad=0.3808p pd=2.92u as=0.2128p ps=1.5u w=1.12u l=0.13u
X5 a_244_412# A1 VDD VDD sg13_lv_pmos ad=0.2128p pd=1.5u as=0.3808p ps=2.92u w=1.12u l=0.13u
X6 VDD A2 a_244_412# VDD sg13_lv_pmos ad=0.3808p pd=2.92u as=0.2128p ps=1.5u w=1.12u l=0.13u
X7 VSS C1 Y VSS sg13_lv_nmos ad=0.1406p pd=1.12u as=0.2516p ps=2.16u w=0.74u l=0.13u
X8 a_244_140# B2 VSS VSS sg13_lv_nmos ad=0.1406p pd=1.12u as=0.1406p ps=1.12u w=0.74u l=0.13u
X9 Y B1 a_244_140# VSS sg13_lv_nmos ad=0.2516p pd=2.16u as=0.1406p ps=1.12u w=0.74u l=0.13u
C0 a_244_412# B1 0.00621f
C1 a_142_412# B2 0.01026f
C2 A2 a_550_140# 0.00136f
C3 VDD B1 0.06239f
C4 a_142_412# a_244_412# 0.20304f
C5 Y B1 0.11489f
C6 a_142_412# C1 0.0037f
C7 a_142_412# VDD 0.15372f
C8 Y a_142_412# 0.16061f
C9 A2 A1 0.08657f
C10 a_142_412# B1 0.00721f
C11 A1 B2 0
C12 A2 a_244_412# 0.00532f
C13 a_550_140# Y 0.01669f
C14 B2 a_244_140# 0
C15 A2 VDD 0.066f
C16 A1 a_244_412# 0.01014f
C17 A1 C1 0
C18 A2 Y 0.25898f
C19 B2 a_244_412# 0.00224f
C20 A1 VDD 0.07221f
C21 B2 C1 0.09617f
C22 A1 Y 0.10553f
C23 VDD B2 0.05138f
C24 Y a_244_140# 0.01657f
C25 Y B2 0.20204f
C26 a_244_412# C1 0
C27 VDD a_244_412# 0.25167f
C28 VDD C1 0.06546f
C29 A1 B1 0.08268f
C30 Y a_244_412# 0.41675f
C31 Y C1 0.15487f
C32 B1 a_244_140# 0
C33 B2 B1 0.11204f
C34 Y VDD 0.1487f
C35 A1 a_142_412# 0
C36 Y VSS 0.56284f
C37 A2 VSS 0.24801f
C38 A1 VSS 0.23869f
C39 B1 VSS 0.2344f
C40 B2 VSS 0.22563f
C41 C1 VSS 0.26901f
C42 VDD VSS 0.19988f
C43 a_550_140# VSS 0.00145f
C44 a_244_140# VSS 0.00145f
.ends

.subckt sg13g2_mux2_1 A1 X S VDD VSS A0 a_59_156# a_285_412# a_382_118# a_496_118#
+ a_285_118# a_559_412#
X0 a_382_118# A0 a_285_412# VDD sg13_lv_pmos ad=0.2225p pd=1.445u as=0.3325p ps=1.665u w=1u l=0.13u
X1 a_559_412# A1 a_382_118# VDD sg13_lv_pmos ad=0.2975p pd=1.595u as=0.2225p ps=1.445u w=1u l=0.13u
X2 VDD S a_59_156# VDD sg13_lv_pmos ad=0.253p pd=1.53u as=0.2856p ps=2.36u w=0.84u l=0.13u
X3 VSS S a_59_156# VSS sg13_lv_nmos ad=0.18945p pd=1.27u as=0.187p ps=1.78u w=0.55u l=0.13u
X4 X a_382_118# VSS VSS sg13_lv_nmos ad=0.4033p pd=2.57u as=0.148p ps=1.14u w=0.74u l=0.13u
X5 X a_382_118# VDD VDD sg13_lv_pmos ad=0.6048p pd=3.32u as=0.2198p ps=1.52u w=1.12u l=0.13u
X6 a_285_118# S VSS VSS sg13_lv_nmos ad=0.13135p pd=1.095u as=0.18945p ps=1.27u w=0.74u l=0.13u
X7 a_285_412# S VDD VDD sg13_lv_pmos ad=0.3325p pd=1.665u as=0.253p ps=1.53u w=1u l=0.13u
X8 VSS a_59_156# a_496_118# VSS sg13_lv_nmos ad=0.148p pd=1.14u as=0.3367p ps=1.65u w=0.74u l=0.13u
X9 a_382_118# A1 a_285_118# VSS sg13_lv_nmos ad=0.1628p pd=1.18u as=0.13135p ps=1.095u w=0.74u l=0.13u
X10 VDD a_59_156# a_559_412# VDD sg13_lv_pmos ad=0.2198p pd=1.52u as=0.2975p ps=1.595u w=1u l=0.13u
X11 a_496_118# A0 a_382_118# VSS sg13_lv_nmos ad=0.3367p pd=1.65u as=0.1628p ps=1.18u w=0.74u l=0.13u
C0 A1 a_559_412# 0.00478f
C1 A0 VDD 0.05762f
C2 a_559_412# a_382_118# 0.01057f
C3 a_496_118# X 0
C4 a_59_156# a_559_412# 0.03308f
C5 A0 A1 0.32591f
C6 A0 a_382_118# 0.06406f
C7 A0 a_59_156# 0.01438f
C8 X VDD 0.1967f
C9 X a_382_118# 0.2017f
C10 X a_59_156# 0.00874f
C11 S VDD 0.12659f
C12 a_496_118# A1 0.01616f
C13 a_496_118# a_382_118# 0.0308f
C14 a_285_412# VDD 0
C15 S A1 0.03197f
C16 a_496_118# a_59_156# 0.00116f
C17 a_285_118# A1 0.00528f
C18 S a_382_118# 0.10872f
C19 a_285_118# a_382_118# 0.01625f
C20 S a_59_156# 0.14226f
C21 A1 VDD 0.06716f
C22 a_285_412# A1 0
C23 a_382_118# VDD 0.09977f
C24 a_285_412# a_382_118# 0.02903f
C25 a_59_156# VDD 0.83253f
C26 a_59_156# a_285_412# 0.02726f
C27 A1 a_382_118# 0.48055f
C28 a_59_156# A1 0.10627f
C29 a_59_156# a_382_118# 0.43036f
C30 a_496_118# A0 0
C31 S A0 0.00891f
C32 X VSS 0.156f
C33 A1 VSS 0.25775f
C34 A0 VSS 0.22385f
C35 S VSS 0.47901f
C36 VDD VSS 0.21774f
C37 a_496_118# VSS 0.00142f
C38 a_285_118# VSS 0
C39 a_382_118# VSS 0.7136f
C40 a_59_156# VSS 0.38001f
.ends

.subckt sg13g2_or4_1 X C D VDD VSS A B a_72_436# a_268_436# a_411_436# a_166_436#
X0 a_72_436# B VSS VSS sg13_lv_nmos ad=0.1045p pd=0.93u as=0.16755p ps=1.165u w=0.55u l=0.13u
X1 VSS A a_72_436# VSS sg13_lv_nmos ad=0.14135p pd=1.14u as=0.1045p ps=0.93u w=0.55u l=0.13u
X2 a_166_436# D a_72_436# VDD sg13_lv_pmos ad=0.19p pd=1.38u as=0.34p ps=2.68u w=1u l=0.13u
X3 a_268_436# C a_166_436# VDD sg13_lv_pmos ad=0.2925p pd=1.585u as=0.19p ps=1.38u w=1u l=0.13u
X4 X a_72_436# VSS VSS sg13_lv_nmos ad=0.2516p pd=2.16u as=0.14135p ps=1.14u w=0.74u l=0.13u
X5 a_411_436# B a_268_436# VDD sg13_lv_pmos ad=0.19p pd=1.38u as=0.2925p ps=1.585u w=1u l=0.13u
X6 X a_72_436# VDD VDD sg13_lv_pmos ad=0.3808p pd=2.92u as=0.2144p ps=1.52u w=1.12u l=0.13u
X7 a_72_436# D VSS VSS sg13_lv_nmos ad=0.1045p pd=0.93u as=0.187p ps=1.78u w=0.55u l=0.13u
X8 VDD A a_411_436# VDD sg13_lv_pmos ad=0.2144p pd=1.52u as=0.19p ps=1.38u w=1u l=0.13u
X9 VSS C a_72_436# VSS sg13_lv_nmos ad=0.16755p pd=1.165u as=0.1045p ps=0.93u w=0.55u l=0.13u
C0 a_72_436# D 0.04471f
C1 C D 0.09295f
C2 a_72_436# a_411_436# 0.01978f
C3 a_72_436# C 0.1337f
C4 D VDD 0.06991f
C5 a_72_436# a_268_436# 0.03073f
C6 a_72_436# X 0.22685f
C7 a_411_436# X 0
C8 C a_268_436# 0.00218f
C9 a_72_436# VDD 0.29443f
C10 D a_166_436# 0
C11 a_72_436# A 0.27003f
C12 a_411_436# VDD 0.00888f
C13 a_72_436# B 0.10332f
C14 C VDD 0.06138f
C15 a_411_436# A 0
C16 a_72_436# a_166_436# 0.02107f
C17 VDD a_268_436# 0.00922f
C18 X VDD 0.13676f
C19 C B 0.11651f
C20 X A 0.0012f
C21 C a_166_436# 0
C22 B a_268_436# 0.00173f
C23 VDD A 0.0639f
C24 B VDD 0.06126f
C25 B A 0.11102f
C26 a_166_436# VDD 0.00487f
C27 X VSS 0.17615f
C28 A VSS 0.19981f
C29 B VSS 0.20299f
C30 C VSS 0.20438f
C31 D VSS 0.27203f
C32 VDD VSS 0.16498f
C33 a_166_436# VSS 0
C34 a_72_436# VSS 0.61717f
.ends

.subckt sg13g2_or3_1 VDD VSS C B A X a_167_412# a_73_118# a_269_412#
X0 VSS A a_73_118# VSS sg13_lv_nmos ad=0.13395p pd=1.12u as=0.198p ps=1.27u w=0.55u l=0.13u
X1 X a_73_118# VSS VSS sg13_lv_nmos ad=0.2516p pd=2.16u as=0.13395p ps=1.12u w=0.74u l=0.13u
X2 VDD A a_269_412# VDD sg13_lv_pmos ad=0.3822p pd=1.84u as=0.1575p ps=1.315u w=1u l=0.13u
X3 VSS C a_73_118# VSS sg13_lv_nmos ad=0.1045p pd=0.93u as=0.187p ps=1.78u w=0.55u l=0.13u
X4 a_167_412# C a_73_118# VDD sg13_lv_pmos ad=0.19p pd=1.38u as=0.34p ps=2.68u w=1u l=0.13u
X5 X a_73_118# VDD VDD sg13_lv_pmos ad=0.3808p pd=2.92u as=0.3822p ps=1.84u w=1.12u l=0.13u
X6 a_73_118# B VSS VSS sg13_lv_nmos ad=0.198p pd=1.27u as=0.1045p ps=0.93u w=0.55u l=0.13u
X7 a_269_412# B a_167_412# VDD sg13_lv_pmos ad=0.1575p pd=1.315u as=0.19p ps=1.38u w=1u l=0.13u
C0 a_73_118# B 0.22652f
C1 B VDD 0.05377f
C2 X a_167_412# 0
C3 A a_73_118# 0.26789f
C4 A VDD 0.0727f
C5 a_167_412# a_73_118# 0.02085f
C6 a_269_412# X 0
C7 a_167_412# VDD 0.0087f
C8 X C 0
C9 A B 0.13131f
C10 X a_73_118# 0.19606f
C11 a_269_412# a_73_118# 0.01473f
C12 X VDD 0.15678f
C13 a_269_412# VDD 0.00924f
C14 C a_73_118# 0.22185f
C15 a_167_412# B 0
C16 C VDD 0.06466f
C17 a_73_118# VDD 0.31785f
C18 X B 0
C19 a_269_412# B 0
C20 C B 0.10291f
C21 X A 0.00114f
C22 X VSS 0.16573f
C23 A VSS 0.22894f
C24 B VSS 0.21722f
C25 C VSS 0.26072f
C26 VDD VSS 0.15152f
C27 a_73_118# VSS 0.65534f
.ends

.subckt sg13g2_a22oi_1 Y A2 VDD B1 A1 VSS B2 a_127_436# a_127_96# a_398_96#
X0 Y B2 a_127_96# VSS sg13_lv_nmos ad=0.2664p pd=1.46u as=0.13875p ps=1.115u w=0.74u l=0.13u
X1 a_398_96# A1 Y VSS sg13_lv_nmos ad=96.2f pd=1u as=0.2664p ps=1.46u w=0.74u l=0.13u
X2 VDD A2 a_127_436# VDD sg13_lv_pmos ad=0.3808p pd=2.92u as=0.2744p ps=1.61u w=1.12u l=0.13u
X3 Y B1 a_127_436# VDD sg13_lv_pmos ad=0.2128p pd=1.5u as=0.2716p ps=1.605u w=1.12u l=0.13u
X4 a_127_436# B2 Y VDD sg13_lv_pmos ad=0.2744p pd=1.61u as=0.2128p ps=1.5u w=1.12u l=0.13u
X5 a_127_96# B1 VSS VSS sg13_lv_nmos ad=0.13875p pd=1.115u as=0.2553p ps=2.17u w=0.74u l=0.13u
X6 a_127_436# A1 VDD VDD sg13_lv_pmos ad=0.2716p pd=1.605u as=0.3808p ps=2.92u w=1.12u l=0.13u
X7 VSS A2 a_398_96# VSS sg13_lv_nmos ad=0.2516p pd=2.16u as=96.2f ps=1u w=0.74u l=0.13u
C0 A1 a_127_96# 0.01722f
C1 A1 a_398_96# 0.00818f
C2 VDD Y 0.02971f
C3 VDD B1 0.07987f
C4 VDD a_127_436# 0.30319f
C5 Y B1 0.09499f
C6 Y a_127_436# 0.15632f
C7 VDD A2 0.13699f
C8 VDD B2 0.0983f
C9 a_127_436# B1 0.04199f
C10 Y A2 0.01059f
C11 Y B2 0.17782f
C12 VDD A1 0.1439f
C13 a_127_436# A2 0.00339f
C14 B2 B1 0.07276f
C15 a_127_436# B2 0.06277f
C16 Y A1 0.3007f
C17 A1 B1 0.12371f
C18 A1 a_127_436# 0.00652f
C19 VDD a_127_96# 0
C20 A2 B2 0.09697f
C21 Y a_127_96# 0.00132f
C22 A1 A2 0.09069f
C23 VDD a_398_96# 0
C24 A1 B2 0.11175f
C25 a_127_96# B1 0.00187f
C26 a_127_436# a_127_96# 0
C27 Y VSS 0.01319f
C28 A2 VSS 0.36075f
C29 B2 VSS 0.27096f
C30 B1 VSS 0.28275f
C31 A1 VSS 0.74619f
C32 VDD VSS 0.19377f
C33 a_398_96# VSS 0.00557f
C34 a_127_436# VSS 0.00163f
.ends

.subckt uart_top VGND VPWR clk rst rx rx_data[0] rx_data[1] rx_data[2] rx_data[3]
+ rx_data[4] rx_data[5] rx_data[6] rx_data[7] rx_done tx tx_busy tx_data[0] tx_data[1]
+ tx_data[2] tx_data[3] tx_data[4] tx_data[5] tx_data[6] tx_data[7] tx_done tx_start
X_432_ VPWR _248_ net32 net25 VGND net35 _246_ _432_/a_350_122# _432_/a_146_122# _432_/a_248_122#
+ sg13g2_nand4_1
X_363_ VGND VPWR _196_ _194_ _173_ net34 _363_/a_22_110# _363_/a_120_432# sg13g2_o21ai_1
X_501_ _286_ VPWR net92 VGND net94 _501_/a_154_118# sg13g2_nand2_1
X_346_ VGND VPWR baud_inst.counter\[28\] baud_inst.counter\[31\] _179_ baud_inst.counter\[29\]
+ baud_inst.counter\[30\] _346_/a_252_412# _346_/a_354_412# _346_/a_150_412# sg13g2_nor4_1
X_415_ _170_ VPWR _234_ VGND _226_ _415_/a_170_412# sg13g2_nor2_1
Xhold170 tx_inst.data_reg\[6\] VPWR VGND net170 hold170/a_56_118# hold170/a_326_118#
+ hold170/a_438_182# sg13g2_dlygate4sd3_1
Xhold181 baud_inst.counter\[2\] VPWR VGND net181 hold181/a_56_118# hold181/a_326_118#
+ hold181/a_438_182# sg13g2_dlygate4sd3_1
Xclkbuf_4_12_0_clk clknet_4_12_0_clk VPWR clknet_0_clk VGND clkbuf_4_12_0_clk/a_27_118#
+ sg13g2_buf_8
X_329_ _163_ net177 VGND VPWR sg13g2_inv_1
XFILLER_2_154 VPWR VGND sg13g2_decap_4
X_680_ VPWR net136 baud_inst.counter\[8\] clknet_4_0_0_clk VGND _093_ _680_/a_2002_114#
+ _680_/a_741_93# _680_/a_612_127# _680_/a_2250_412# _680_/a_1840_334# _680_/a_1785_429#
+ _680_/a_843_236# _680_/a_132_114# _680_/a_681_505# _680_/a_38_114# _680_/a_324_432#
+ _680_/a_1583_191# _680_/a_1489_191# _680_/a_550_127# _680_/a_298_337# sg13g2_dfrbpq_1
XFILLER_29_117 VPWR VGND sg13g2_decap_8
XFILLER_29_96 VPWR VGND sg13g2_decap_8
Xhold52 rx_inst.bit_index\[0\] VPWR VGND net52 hold52/a_56_118# hold52/a_326_118#
+ hold52/a_438_182# sg13g2_dlygate4sd3_1
XFILLER_20_43 VPWR VGND sg13g2_decap_8
Xhold85 _125_ VPWR VGND net85 hold85/a_56_118# hold85/a_326_118# hold85/a_438_182#
+ sg13g2_dlygate4sd3_1
Xhold74 _126_ VPWR VGND net74 hold74/a_56_118# hold74/a_326_118# hold74/a_438_182#
+ sg13g2_dlygate4sd3_1
Xhold63 _079_ VPWR VGND net63 hold63/a_56_118# hold63/a_326_118# hold63/a_438_182#
+ sg13g2_dlygate4sd3_1
X_594_ _083_ net39 VGND VPWR sg13g2_inv_1
X_663_ VPWR _001_ tx_inst.state\[1\] clknet_4_7_0_clk VGND _075_ _663_/a_2002_114#
+ _663_/a_741_93# _663_/a_612_127# _663_/a_2250_412# _663_/a_1840_334# _663_/a_1785_429#
+ _663_/a_843_236# _663_/a_132_114# _663_/a_681_505# _663_/a_38_114# _663_/a_324_432#
+ _663_/a_1583_191# _663_/a_1489_191# _663_/a_550_127# _663_/a_298_337# sg13g2_dfrbpq_1
XFILLER_4_216 VPWR VGND sg13g2_decap_8
Xhold96 _037_ VPWR VGND net96 hold96/a_56_118# hold96/a_326_118# hold96/a_438_182#
+ sg13g2_dlygate4sd3_1
XFILLER_25_120 VPWR VGND sg13g2_decap_8
X_646_ VPWR net144 rx_inst.data_reg\[3\] clknet_4_12_0_clk VGND _057_ _646_/a_2002_114#
+ _646_/a_741_93# _646_/a_612_127# _646_/a_2250_412# _646_/a_1840_334# _646_/a_1785_429#
+ _646_/a_843_236# _646_/a_132_114# _646_/a_681_505# _646_/a_38_114# _646_/a_324_432#
+ _646_/a_1583_191# _646_/a_1489_191# _646_/a_550_127# _646_/a_298_337# sg13g2_dfrbpq_1
Xoutput20 net20 rx_done VPWR VGND output20/a_40_152# sg13g2_buf_1
X_577_ _064_ net42 VGND VPWR sg13g2_inv_1
XFILLER_22_145 VPWR VGND sg13g2_decap_8
XFILLER_11_0 VPWR VGND sg13g2_decap_4
XFILLER_26_75 VPWR VGND sg13g2_decap_4
X_431_ _247_ net32 net35 VPWR VGND net25 _246_ _431_/a_277_118# _431_/a_379_118# _431_/a_175_118#
+ _431_/a_81_118# sg13g2_and4_1
X_500_ VPWR VGND _283_ net92 net94 _285_ _500_/a_155_412# _500_/a_257_140# sg13g2_a21oi_1
X_362_ _195_ _194_ VGND VPWR sg13g2_inv_1
X_629_ _118_ net43 VGND VPWR sg13g2_inv_1
Xhold160 baud_inst.counter\[16\] VPWR VGND net160 hold160/a_56_118# hold160/a_326_118#
+ hold160/a_438_182# sg13g2_dlygate4sd3_1
Xhold182 baud_inst.counter\[4\] VPWR VGND net182 hold182/a_56_118# hold182/a_326_118#
+ hold182/a_438_182# sg13g2_dlygate4sd3_1
XFILLER_12_99 VPWR VGND sg13g2_decap_8
Xhold171 tx_inst.data_reg\[4\] VPWR VGND net171 hold171/a_56_118# hold171/a_326_118#
+ hold171/a_438_182# sg13g2_dlygate4sd3_1
X_345_ VGND VPWR baud_inst.counter\[20\] baud_inst.counter\[23\] _178_ baud_inst.counter\[21\]
+ baud_inst.counter\[22\] _345_/a_252_412# _345_/a_354_412# _345_/a_150_412# sg13g2_nor4_1
X_414_ net31 _233_ _228_ _231_ VPWR VGND _414_/a_165_412# _414_/a_279_412# sg13g2_nor3_1
X_328_ _162_ net182 VGND VPWR sg13g2_inv_1
XFILLER_0_14 VPWR VGND sg13g2_decap_8
Xclkbuf_4_11_0_clk clknet_4_11_0_clk VPWR clknet_0_clk VGND clkbuf_4_11_0_clk/a_27_118#
+ sg13g2_buf_8
XFILLER_29_53 VPWR VGND sg13g2_decap_4
Xhold53 _130_ VPWR VGND net53 hold53/a_56_118# hold53/a_326_118# hold53/a_438_182#
+ sg13g2_dlygate4sd3_1
Xhold75 baud_inst.counter\[23\] VPWR VGND net75 hold75/a_56_118# hold75/a_326_118#
+ hold75/a_438_182# sg13g2_dlygate4sd3_1
Xhold64 net12 VPWR VGND net64 hold64/a_56_118# hold64/a_326_118# hold64/a_438_182#
+ sg13g2_dlygate4sd3_1
Xhold86 baud_inst.counter\[1\] VPWR VGND net86 hold86/a_56_118# hold86/a_326_118#
+ hold86/a_438_182# sg13g2_dlygate4sd3_1
X_662_ VPWR _073_ _040_ clknet_4_5_0_clk VGND _074_ _662_/a_2002_114# _662_/a_741_93#
+ _662_/a_612_127# _662_/a_2250_412# _662_/a_1840_334# _662_/a_1785_429# _662_/a_843_236#
+ _662_/a_132_114# _662_/a_681_505# _662_/a_38_114# _662_/a_324_432# _662_/a_1583_191#
+ _662_/a_1489_191# _662_/a_550_127# _662_/a_298_337# sg13g2_dfrbpq_1
Xhold97 baud_inst.counter\[10\] VPWR VGND net97 hold97/a_56_118# hold97/a_326_118#
+ hold97/a_438_182# sg13g2_dlygate4sd3_1
X_593_ _082_ net44 VGND VPWR sg13g2_inv_1
X_645_ VPWR net151 rx_inst.data_reg\[2\] clknet_4_14_0_clk VGND _056_ _645_/a_2002_114#
+ _645_/a_741_93# _645_/a_612_127# _645_/a_2250_412# _645_/a_1840_334# _645_/a_1785_429#
+ _645_/a_843_236# _645_/a_132_114# _645_/a_681_505# _645_/a_38_114# _645_/a_324_432#
+ _645_/a_1583_191# _645_/a_1489_191# _645_/a_550_127# _645_/a_298_337# sg13g2_dfrbpq_1
X_576_ _063_ net42 VGND VPWR sg13g2_inv_1
Xoutput21 net21 tx VPWR VGND output21/a_40_152# sg13g2_buf_1
XFILLER_22_157 VPWR VGND sg13g2_decap_8
XFILLER_26_21 VPWR VGND sg13g2_decap_8
X_430_ rx_inst.bit_index\[1\] VPWR _246_ VGND net36 _430_/a_170_412# sg13g2_nor2_1
X_361_ VPWR _194_ tx_inst.bit_index\[1\] net34 net173 VGND _361_/a_146_122# _361_/a_248_122#
+ sg13g2_nand3_1
X_559_ _046_ net48 VGND VPWR sg13g2_inv_1
XFILLER_3_14 VPWR VGND sg13g2_decap_8
X_628_ _117_ net43 VGND VPWR sg13g2_inv_1
Xhold150 rx_inst.data_reg\[2\] VPWR VGND net150 hold150/a_56_118# hold150/a_326_118#
+ hold150/a_438_182# sg13g2_dlygate4sd3_1
Xhold161 _015_ VPWR VGND net161 hold161/a_56_118# hold161/a_326_118# hold161/a_438_182#
+ sg13g2_dlygate4sd3_1
XFILLER_10_138 VPWR VGND sg13g2_decap_8
Xhold172 tx_inst.state\[3\] VPWR VGND net172 hold172/a_56_118# hold172/a_326_118#
+ hold172/a_438_182# sg13g2_dlygate4sd3_1
Xhold183 tx_inst.bit_index\[1\] VPWR VGND net183 hold183/a_56_118# hold183/a_326_118#
+ hold183/a_438_182# sg13g2_dlygate4sd3_1
X_413_ net31 VPWR _232_ VGND _230_ _413_/a_170_412# sg13g2_nor2_1
X_344_ VGND VPWR baud_inst.counter\[24\] baud_inst.counter\[27\] _177_ baud_inst.counter\[25\]
+ baud_inst.counter\[26\] _344_/a_252_412# _344_/a_354_412# _344_/a_150_412# sg13g2_nor4_1
X_327_ _008_ net79 VGND VPWR sg13g2_inv_1
XFILLER_18_44 VPWR VGND sg13g2_decap_8
XFILLER_1_0 VPWR VGND sg13g2_decap_8
XFILLER_29_32 VPWR VGND sg13g2_decap_8
Xhold65 _273_ VPWR VGND net65 hold65/a_56_118# hold65/a_326_118# hold65/a_438_182#
+ sg13g2_dlygate4sd3_1
Xhold76 _023_ VPWR VGND net76 hold76/a_56_118# hold76/a_326_118# hold76/a_438_182#
+ sg13g2_dlygate4sd3_1
Xhold87 baud_inst.counter\[15\] VPWR VGND net87 hold87/a_56_118# hold87/a_326_118#
+ hold87/a_438_182# sg13g2_dlygate4sd3_1
X_592_ _081_ net42 VGND VPWR sg13g2_inv_1
X_661_ VPWR _151_ tx_inst.data_reg\[7\] clknet_4_1_0_clk VGND _072_ _661_/a_2002_114#
+ _661_/a_741_93# _661_/a_612_127# _661_/a_2250_412# _661_/a_1840_334# _661_/a_1785_429#
+ _661_/a_843_236# _661_/a_132_114# _661_/a_681_505# _661_/a_38_114# _661_/a_324_432#
+ _661_/a_1583_191# _661_/a_1489_191# _661_/a_550_127# _661_/a_298_337# sg13g2_dfrbpq_1
Xhold54 _040_ VPWR VGND net54 hold54/a_56_118# hold54/a_326_118# hold54/a_438_182#
+ sg13g2_dlygate4sd3_1
XFILLER_6_14 VPWR VGND sg13g2_decap_8
Xhold98 _009_ VPWR VGND net98 hold98/a_56_118# hold98/a_326_118# hold98/a_438_182#
+ sg13g2_dlygate4sd3_1
X_644_ VPWR net132 rx_inst.data_reg\[1\] clknet_4_14_0_clk VGND _055_ _644_/a_2002_114#
+ _644_/a_741_93# _644_/a_612_127# _644_/a_2250_412# _644_/a_1840_334# _644_/a_1785_429#
+ _644_/a_843_236# _644_/a_132_114# _644_/a_681_505# _644_/a_38_114# _644_/a_324_432#
+ _644_/a_1583_191# _644_/a_1489_191# _644_/a_550_127# _644_/a_298_337# sg13g2_dfrbpq_1
Xclkbuf_4_10_0_clk clknet_4_10_0_clk VPWR clknet_0_clk VGND clkbuf_4_10_0_clk/a_27_118#
+ sg13g2_buf_8
Xoutput22 net22 tx_busy VPWR VGND output22/a_40_152# sg13g2_buf_1
X_575_ _062_ net42 VGND VPWR sg13g2_inv_1
XFILLER_22_114 VPWR VGND sg13g2_decap_4
XFILLER_16_199 VPWR VGND sg13g2_decap_4
XFILLER_26_99 VPWR VGND sg13g2_decap_8
X_360_ _193_ tx_inst.data_reg\[4\] tx_inst.data_reg\[6\] tx_inst.bit_index\[1\] VPWR
+ VGND net184 tx_inst.data_reg\[2\] tx_inst.data_reg\[0\] _360_/a_1453_124# _360_/a_500_118#
+ _360_/a_805_385# _360_/a_1023_118# _360_/a_589_385# _360_/a_382_118# _360_/a_1377_160#
+ _360_/a_295_385# _360_/a_810_118# _360_/a_71_118# _360_/a_1109_431# _360_/a_886_118#
+ _360_/a_308_118# sg13g2_mux4_1
X_558_ _045_ net47 VGND VPWR sg13g2_inv_1
X_627_ _116_ net46 VGND VPWR sg13g2_inv_1
X_489_ net181 _279_ VPWR VGND net79 net86 _489_/a_358_436# _489_/a_115_308# _489_/a_494_160#
+ sg13g2_a21o_1
Xhold151 _135_ VPWR VGND net151 hold151/a_56_118# hold151/a_326_118# hold151/a_438_182#
+ sg13g2_dlygate4sd3_1
Xhold140 baud_inst.counter\[25\] VPWR VGND net140 hold140/a_56_118# hold140/a_326_118#
+ hold140/a_438_182# sg13g2_dlygate4sd3_1
Xhold162 baud_inst.counter\[24\] VPWR VGND net162 hold162/a_56_118# hold162/a_326_118#
+ hold162/a_438_182# sg13g2_dlygate4sd3_1
XFILLER_5_7 VPWR VGND sg13g2_decap_8
X_412_ VGND VPWR _231_ _227_ net28 _170_ _412_/a_22_110# _412_/a_120_432# sg13g2_o21ai_1
X_343_ VPWR VGND _173_ net34 _175_ _176_ _343_/a_155_412# _343_/a_257_140# sg13g2_a21oi_1
Xhold173 tx_inst.bit_index\[2\] VPWR VGND net173 hold173/a_56_118# hold173/a_326_118#
+ hold173/a_438_182# sg13g2_dlygate4sd3_1
Xhold184 tx_inst.bit_index\[2\] VPWR VGND net184 hold184/a_56_118# hold184/a_326_118#
+ hold184/a_438_182# sg13g2_dlygate4sd3_1
XFILLER_2_179 VPWR VGND sg13g2_decap_4
X_326_ _161_ net35 VGND VPWR sg13g2_inv_1
XFILLER_9_14 VPWR VGND sg13g2_decap_8
XFILLER_27_0 VPWR VGND sg13g2_decap_8
XFILLER_29_11 VPWR VGND sg13g2_decap_8
Xhold77 net13 VPWR VGND net77 hold77/a_56_118# hold77/a_326_118# hold77/a_438_182#
+ sg13g2_dlygate4sd3_1
Xhold66 _122_ VPWR VGND net66 hold66/a_56_118# hold66/a_326_118# hold66/a_438_182#
+ sg13g2_dlygate4sd3_1
Xhold99 baud_inst.counter\[26\] VPWR VGND net99 hold99/a_56_118# hold99/a_326_118#
+ hold99/a_438_182# sg13g2_dlygate4sd3_1
Xhold88 _297_ VPWR VGND net88 hold88/a_56_118# hold88/a_326_118# hold88/a_438_182#
+ sg13g2_dlygate4sd3_1
X_591_ _080_ net42 VGND VPWR sg13g2_inv_1
X_660_ VPWR _150_ tx_inst.data_reg\[6\] clknet_4_5_0_clk VGND _071_ _660_/a_2002_114#
+ _660_/a_741_93# _660_/a_612_127# _660_/a_2250_412# _660_/a_1840_334# _660_/a_1785_429#
+ _660_/a_843_236# _660_/a_132_114# _660_/a_681_505# _660_/a_38_114# _660_/a_324_432#
+ _660_/a_1583_191# _660_/a_1489_191# _660_/a_550_127# _660_/a_298_337# sg13g2_dfrbpq_1
Xhold55 net33 VPWR VGND net55 hold55/a_56_118# hold55/a_326_118# hold55/a_438_182#
+ sg13g2_dlygate4sd3_1
Xoutput12 net12 rx_data[0] VPWR VGND output12/a_40_152# sg13g2_buf_1
XFILLER_25_134 VPWR VGND sg13g2_decap_8
Xoutput23 net23 tx_done VPWR VGND output23/a_40_152# sg13g2_buf_1
XFILLER_0_233 VPWR VGND sg13g2_decap_4
X_643_ VPWR net112 rx_inst.data_reg\[0\] clknet_4_12_0_clk VGND _054_ _643_/a_2002_114#
+ _643_/a_741_93# _643_/a_612_127# _643_/a_2250_412# _643_/a_1840_334# _643_/a_1785_429#
+ _643_/a_843_236# _643_/a_132_114# _643_/a_681_505# _643_/a_38_114# _643_/a_324_432#
+ _643_/a_1583_191# _643_/a_1489_191# _643_/a_550_127# _643_/a_298_337# sg13g2_dfrbpq_1
X_574_ _061_ net48 VGND VPWR sg13g2_inv_1
XFILLER_16_134 VPWR VGND sg13g2_decap_4
X_557_ _044_ net47 VGND VPWR sg13g2_inv_1
X_626_ _115_ net45 VGND VPWR sg13g2_inv_1
X_488_ _019_ VPWR net86 net79 VGND _488_/a_209_168# _488_/a_177_436# _488_/a_380_412#
+ _488_/a_474_130# sg13g2_xor2_1
Xhold141 _309_ VPWR VGND net141 hold141/a_56_118# hold141/a_326_118# hold141/a_438_182#
+ sg13g2_dlygate4sd3_1
Xhold163 baud_inst.counter\[20\] VPWR VGND net163 hold163/a_56_118# hold163/a_326_118#
+ hold163/a_438_182# sg13g2_dlygate4sd3_1
X_411_ _228_ _230_ VPWR VGND rx_inst.state\[2\] net26 _411_/a_358_436# _411_/a_115_308#
+ _411_/a_494_160# sg13g2_a21o_1
Xhold130 _012_ VPWR VGND net130 hold130/a_56_118# hold130/a_326_118# hold130/a_438_182#
+ sg13g2_dlygate4sd3_1
X_342_ net34 VPWR _175_ VGND _174_ _342_/a_170_412# sg13g2_nor2_1
Xhold174 _194_ VPWR VGND net174 hold174/a_56_118# hold174/a_326_118# hold174/a_438_182#
+ sg13g2_dlygate4sd3_1
Xhold152 baud_inst.counter\[5\] VPWR VGND net152 hold152/a_56_118# hold152/a_326_118#
+ hold152/a_438_182# sg13g2_dlygate4sd3_1
X_609_ _098_ net40 VGND VPWR sg13g2_inv_1
XFILLER_2_114 VPWR VGND sg13g2_decap_4
XFILLER_29_4 VPWR VGND sg13g2_decap_8
X_325_ _160_ net111 VGND VPWR sg13g2_inv_1
XFILLER_0_28 VPWR VGND sg13g2_decap_8
Xclkload0 clkload0/Y clknet_4_3_0_clk VGND VPWR sg13g2_inv_1
Xhold78 _123_ VPWR VGND net78 hold78/a_56_118# hold78/a_326_118# hold78/a_438_182#
+ sg13g2_dlygate4sd3_1
XFILLER_29_89 VPWR VGND sg13g2_decap_8
XFILLER_28_121 VPWR VGND sg13g2_decap_8
Xhold67 baud_inst.counter\[30\] VPWR VGND net67 hold67/a_56_118# hold67/a_326_118#
+ hold67/a_438_182# sg13g2_dlygate4sd3_1
Xhold89 _014_ VPWR VGND net89 hold89/a_56_118# hold89/a_326_118# hold89/a_438_182#
+ sg13g2_dlygate4sd3_1
X_590_ _078_ net42 VGND VPWR sg13g2_inv_1
Xhold56 tx_inst.bit_index\[0\] VPWR VGND net56 hold56/a_56_118# hold56/a_326_118#
+ hold56/a_438_182# sg13g2_dlygate4sd3_1
Xoutput13 net13 rx_data[1] VPWR VGND output13/a_40_152# sg13g2_buf_1
XFILLER_25_146 VPWR VGND sg13g2_decap_4
XFILLER_25_113 VPWR VGND sg13g2_decap_8
X_573_ _060_ net48 VGND VPWR sg13g2_inv_1
X_642_ VPWR _132_ rx_inst.bit_index\[2\] clknet_4_12_0_clk VGND _053_ _642_/a_2002_114#
+ _642_/a_741_93# _642_/a_612_127# _642_/a_2250_412# _642_/a_1840_334# _642_/a_1785_429#
+ _642_/a_843_236# _642_/a_132_114# _642_/a_681_505# _642_/a_38_114# _642_/a_324_432#
+ _642_/a_1583_191# _642_/a_1489_191# _642_/a_550_127# _642_/a_298_337# sg13g2_dfrbpq_1
X_625_ _114_ net45 VGND VPWR sg13g2_inv_1
X_556_ _032_ _316_ VPWR net58 VGND _556_/a_155_160# _556_/a_192_429# _556_/a_435_412#
+ _556_/a_341_118# sg13g2_xnor2_1
X_487_ VPWR _152_ _200_ _275_ _166_ VGND _487_/a_146_122# _487_/a_248_122# sg13g2_nand3_1
Xhold131 rx_inst.data_reg\[1\] VPWR VGND net131 hold131/a_56_118# hold131/a_326_118#
+ hold131/a_438_182# sg13g2_dlygate4sd3_1
Xhold120 baud_inst.counter\[22\] VPWR VGND net120 hold120/a_56_118# hold120/a_326_118#
+ hold120/a_438_182# sg13g2_dlygate4sd3_1
Xhold175 rx_inst.bit_index\[1\] VPWR VGND net175 hold175/a_56_118# hold175/a_326_118#
+ hold175/a_438_182# sg13g2_dlygate4sd3_1
Xhold142 _025_ VPWR VGND net142 hold142/a_56_118# hold142/a_326_118# hold142/a_438_182#
+ sg13g2_dlygate4sd3_1
Xhold164 _020_ VPWR VGND net164 hold164/a_56_118# hold164/a_326_118# hold164/a_438_182#
+ sg13g2_dlygate4sd3_1
X_410_ VPWR VGND net26 rx_inst.state\[2\] _228_ _229_ _410_/a_155_412# _410_/a_257_140#
+ sg13g2_a21oi_1
X_341_ _174_ tx_inst.data_reg\[2\] tx_inst.data_reg\[4\] tx_inst.bit_index\[1\] VPWR
+ VGND tx_inst.bit_index\[2\] tx_inst.data_reg\[0\] tx_inst.data_reg\[6\] _341_/a_1453_124#
+ _341_/a_500_118# _341_/a_805_385# _341_/a_1023_118# _341_/a_589_385# _341_/a_382_118#
+ _341_/a_1377_160# _341_/a_295_385# _341_/a_810_118# _341_/a_71_118# _341_/a_1109_431#
+ _341_/a_886_118# _341_/a_308_118# sg13g2_mux4_1
Xhold153 _284_ VPWR VGND net153 hold153/a_56_118# hold153/a_326_118# hold153/a_438_182#
+ sg13g2_dlygate4sd3_1
X_539_ _307_ VGND VPWR _306_ _301_ _539_/a_139_160# _539_/a_45_160# sg13g2_and2_1
X_608_ _097_ net39 VGND VPWR sg13g2_inv_1
XFILLER_4_93 VPWR VGND sg13g2_decap_8
X_324_ _159_ net131 VGND VPWR sg13g2_inv_1
XFILLER_18_58 VPWR VGND sg13g2_decap_8
Xclkload1 clkload1/Y clknet_4_7_0_clk VGND VPWR sg13g2_inv_1
XFILLER_1_72 VPWR VGND sg13g2_decap_8
XFILLER_29_46 VPWR VGND sg13g2_decap_8
XFILLER_28_100 VPWR VGND sg13g2_decap_8
Xhold68 _031_ VPWR VGND net68 hold68/a_56_118# hold68/a_326_118# hold68/a_438_182#
+ sg13g2_dlygate4sd3_1
Xhold79 baud_inst.counter\[0\] VPWR VGND net79 hold79/a_56_118# hold79/a_326_118#
+ hold79/a_438_182# sg13g2_dlygate4sd3_1
Xhold57 _141_ VPWR VGND net57 hold57/a_56_118# hold57/a_326_118# hold57/a_438_182#
+ sg13g2_dlygate4sd3_1
Xoutput14 net14 rx_data[2] VPWR VGND output14/a_40_152# sg13g2_buf_1
X_572_ _059_ net49 VGND VPWR sg13g2_inv_1
X_641_ VPWR net176 rx_inst.bit_index\[1\] clknet_4_12_0_clk VGND _052_ _641_/a_2002_114#
+ _641_/a_741_93# _641_/a_612_127# _641_/a_2250_412# _641_/a_1840_334# _641_/a_1785_429#
+ _641_/a_843_236# _641_/a_132_114# _641_/a_681_505# _641_/a_38_114# _641_/a_324_432#
+ _641_/a_1583_191# _641_/a_1489_191# _641_/a_550_127# _641_/a_298_337# sg13g2_dfrbpq_1
XFILLER_26_14 VPWR VGND sg13g2_decap_8
XFILLER_21_161 VPWR VGND sg13g2_decap_4
X_624_ _113_ net45 VGND VPWR sg13g2_inv_1
X_555_ _031_ VPWR _314_ net67 VGND _555_/a_209_168# _555_/a_177_436# _555_/a_380_412#
+ _555_/a_474_130# sg13g2_xor2_1
X_486_ _231_ _002_ VPWR VGND net166 _205_ _486_/a_358_436# _486_/a_115_308# _486_/a_494_160#
+ sg13g2_a21o_1
XFILLER_12_194 VPWR VGND sg13g2_decap_8
Xhold132 _134_ VPWR VGND net132 hold132/a_56_118# hold132/a_326_118# hold132/a_438_182#
+ sg13g2_dlygate4sd3_1
Xhold121 _022_ VPWR VGND net121 hold121/a_56_118# hold121/a_326_118# hold121/a_438_182#
+ sg13g2_dlygate4sd3_1
Xhold143 rx_inst.data_reg\[3\] VPWR VGND net143 hold143/a_56_118# hold143/a_326_118#
+ hold143/a_438_182# sg13g2_dlygate4sd3_1
Xhold176 _131_ VPWR VGND net176 hold176/a_56_118# hold176/a_326_118# hold176/a_438_182#
+ sg13g2_dlygate4sd3_1
Xhold154 _035_ VPWR VGND net154 hold154/a_56_118# hold154/a_326_118# hold154/a_438_182#
+ sg13g2_dlygate4sd3_1
Xhold165 tx_inst.data_reg\[2\] VPWR VGND net165 hold165/a_56_118# hold165/a_326_118#
+ hold165/a_438_182# sg13g2_dlygate4sd3_1
Xhold110 _010_ VPWR VGND net110 hold110/a_56_118# hold110/a_326_118# hold110/a_438_182#
+ sg13g2_dlygate4sd3_1
X_538_ _306_ baud_inst.counter\[20\] baud_inst.counter\[21\] VPWR VGND baud_inst.counter\[23\]
+ baud_inst.counter\[22\] _538_/a_277_118# _538_/a_379_118# _538_/a_175_118# _538_/a_81_118#
+ sg13g2_and4_1
X_607_ _096_ net39 VGND VPWR sg13g2_inv_1
X_340_ _173_ _172_ VGND VPWR sg13g2_inv_1
X_469_ VGND VPWR _271_ net82 _264_ net30 _469_/a_22_110# _469_/a_120_432# sg13g2_o21ai_1
XFILLER_4_72 VPWR VGND sg13g2_decap_8
X_323_ _158_ net150 VGND VPWR sg13g2_inv_1
XFILLER_3_7 VPWR VGND sg13g2_decap_8
Xclkload2 clkload2/Y clknet_4_11_0_clk VGND VPWR sg13g2_inv_1
XFILLER_24_91 VPWR VGND sg13g2_decap_8
XFILLER_29_69 VPWR VGND sg13g2_decap_4
XFILLER_29_25 VPWR VGND sg13g2_decap_8
Xhold58 baud_inst.counter\[31\] VPWR VGND net58 hold58/a_56_118# hold58/a_326_118#
+ hold58/a_438_182# sg13g2_dlygate4sd3_1
Xhold69 net18 VPWR VGND net69 hold69/a_56_118# hold69/a_326_118# hold69/a_438_182#
+ sg13g2_dlygate4sd3_1
XFILLER_25_0 VPWR VGND sg13g2_decap_8
XFILLER_15_38 VPWR VGND sg13g2_decap_4
X_640_ VPWR net53 rx_inst.bit_index\[0\] clknet_4_14_0_clk VGND _051_ _640_/a_2002_114#
+ _640_/a_741_93# _640_/a_612_127# _640_/a_2250_412# _640_/a_1840_334# _640_/a_1785_429#
+ _640_/a_843_236# _640_/a_132_114# _640_/a_681_505# _640_/a_38_114# _640_/a_324_432#
+ _640_/a_1583_191# _640_/a_1489_191# _640_/a_550_127# _640_/a_298_337# sg13g2_dfrbpq_1
Xoutput15 net15 rx_data[3] VPWR VGND output15/a_40_152# sg13g2_buf_1
X_571_ _058_ net48 VGND VPWR sg13g2_inv_1
XFILLER_16_159 VPWR VGND sg13g2_decap_8
XFILLER_21_140 VPWR VGND sg13g2_decap_8
X_554_ VPWR _316_ baud_inst.counter\[28\] baud_inst.counter\[30\] VGND baud_inst.counter\[29\]
+ _313_ _554_/a_350_122# _554_/a_146_122# _554_/a_248_122# sg13g2_nand4_1
X_623_ _112_ net45 VGND VPWR sg13g2_inv_1
XFILLER_12_162 VPWR VGND sg13g2_decap_4
X_485_ VGND VPWR _003_ _278_ net37 net122 _485_/a_22_110# _485_/a_120_432# sg13g2_o21ai_1
Xhold133 baud_inst.counter\[28\] VPWR VGND net133 hold133/a_56_118# hold133/a_326_118#
+ hold133/a_438_182# sg13g2_dlygate4sd3_1
Xhold111 rx_inst.data_reg\[0\] VPWR VGND net111 hold111/a_56_118# hold111/a_326_118#
+ hold111/a_438_182# sg13g2_dlygate4sd3_1
Xhold100 _026_ VPWR VGND net100 hold100/a_56_118# hold100/a_326_118# hold100/a_438_182#
+ sg13g2_dlygate4sd3_1
Xhold144 _136_ VPWR VGND net144 hold144/a_56_118# hold144/a_326_118# hold144/a_438_182#
+ sg13g2_dlygate4sd3_1
Xhold166 rx_inst.state\[3\] VPWR VGND net166 hold166/a_56_118# hold166/a_326_118#
+ hold166/a_438_182# sg13g2_dlygate4sd3_1
Xhold177 baud_inst.counter\[12\] VPWR VGND net177 hold177/a_56_118# hold177/a_326_118#
+ hold177/a_438_182# sg13g2_dlygate4sd3_1
Xhold122 _041_ VPWR VGND net122 hold122/a_56_118# hold122/a_326_118# hold122/a_438_182#
+ sg13g2_dlygate4sd3_1
Xhold155 tx_inst.data_reg\[7\] VPWR VGND net155 hold155/a_56_118# hold155/a_326_118#
+ hold155/a_438_182# sg13g2_dlygate4sd3_1
X_537_ _023_ _305_ VPWR net75 VGND _537_/a_155_160# _537_/a_192_429# _537_/a_435_412#
+ _537_/a_341_118# sg13g2_xnor2_1
X_468_ VGND VPWR _125_ _270_ _266_ _157_ _468_/a_22_110# _468_/a_120_432# sg13g2_o21ai_1
X_399_ _220_ VPWR net183 VGND _216_ _399_/a_154_118# sg13g2_nand2_1
X_606_ _095_ net39 VGND VPWR sg13g2_inv_1
XFILLER_23_49 VPWR VGND sg13g2_decap_4
X_322_ _157_ net143 VGND VPWR sg13g2_inv_1
XFILLER_2_106 VPWR VGND sg13g2_decap_4
Xclkload3 clkload3/Y clknet_4_15_0_clk VGND VPWR sg13g2_inv_1
XFILLER_28_135 VPWR VGND sg13g2_decap_4
Xhold59 _032_ VPWR VGND net59 hold59/a_56_118# hold59/a_326_118# hold59/a_438_182#
+ sg13g2_dlygate4sd3_1
XFILLER_25_127 VPWR VGND sg13g2_decap_8
X_570_ _057_ net48 VGND VPWR sg13g2_inv_1
Xoutput16 net16 rx_data[4] VPWR VGND output16/a_40_152# sg13g2_buf_1
XFILLER_0_226 VPWR VGND sg13g2_decap_8
X_699_ VPWR net114 baud_inst.counter\[27\] clknet_4_8_0_clk VGND _112_ _699_/a_2002_114#
+ _699_/a_741_93# _699_/a_612_127# _699_/a_2250_412# _699_/a_1840_334# _699_/a_1785_429#
+ _699_/a_843_236# _699_/a_132_114# _699_/a_681_505# _699_/a_38_114# _699_/a_324_432#
+ _699_/a_1583_191# _699_/a_1489_191# _699_/a_550_127# _699_/a_298_337# sg13g2_dfrbpq_1
Xclkbuf_0_clk clk VPWR VGND clknet_0_clk clkbuf_0_clk/a_116_82# sg13g2_buf_16
X_553_ _314_ VPWR _029_ VGND net106 _553_/a_170_412# sg13g2_nor2_1
X_622_ _111_ net45 VGND VPWR sg13g2_inv_1
X_484_ _278_ VPWR rx_inst.state\[3\] VGND _191_ _484_/a_154_118# sg13g2_nand2_1
Xhold134 _028_ VPWR VGND net134 hold134/a_56_118# hold134/a_326_118# hold134/a_438_182#
+ sg13g2_dlygate4sd3_1
Xhold112 _133_ VPWR VGND net112 hold112/a_56_118# hold112/a_326_118# hold112/a_438_182#
+ sg13g2_dlygate4sd3_1
Xhold167 _002_ VPWR VGND net167 hold167/a_56_118# hold167/a_326_118# hold167/a_438_182#
+ sg13g2_dlygate4sd3_1
Xhold101 baud_inst.counter\[18\] VPWR VGND net101 hold101/a_56_118# hold101/a_326_118#
+ hold101/a_438_182# sg13g2_dlygate4sd3_1
Xhold123 _003_ VPWR VGND net123 hold123/a_56_118# hold123/a_326_118# hold123/a_438_182#
+ sg13g2_dlygate4sd3_1
Xhold156 baud_inst.counter\[17\] VPWR VGND net156 hold156/a_56_118# hold156/a_326_118#
+ hold156/a_438_182# sg13g2_dlygate4sd3_1
Xhold145 tx_inst.data_reg\[3\] VPWR VGND net145 hold145/a_56_118# hold145/a_326_118#
+ hold145/a_438_182# sg13g2_dlygate4sd3_1
Xhold178 _011_ VPWR VGND net178 hold178/a_56_118# hold178/a_326_118# hold178/a_438_182#
+ sg13g2_dlygate4sd3_1
X_536_ _022_ _304_ VPWR net120 VGND _536_/a_155_160# _536_/a_192_429# _536_/a_435_412#
+ _536_/a_341_118# sg13g2_xnor2_1
X_467_ VGND VPWR _270_ net84 _264_ net30 _467_/a_22_110# _467_/a_120_432# sg13g2_o21ai_1
X_605_ _094_ net38 VGND VPWR sg13g2_inv_1
X_398_ _219_ _143_ VPWR VGND net173 _216_ _398_/a_358_436# _398_/a_115_308# _398_/a_494_160#
+ sg13g2_a21o_1
X_321_ _156_ net138 VGND VPWR sg13g2_inv_1
Xfanout40 net49 net40 VPWR VGND fanout40/a_40_152# sg13g2_buf_1
X_519_ _296_ net128 baud_inst.counter\[12\] VPWR VGND _292_ _295_ _519_/a_277_118#
+ _519_/a_379_118# _519_/a_175_118# _519_/a_81_118# sg13g2_and4_1
XFILLER_1_86 VPWR VGND sg13g2_decap_4
XFILLER_28_114 VPWR VGND sg13g2_decap_8
XFILLER_19_114 VPWR VGND sg13g2_decap_4
Xoutput17 net17 rx_data[5] VPWR VGND output17/a_40_152# sg13g2_buf_1
XFILLER_25_106 VPWR VGND sg13g2_decap_8
XFILLER_21_61 VPWR VGND sg13g2_decap_4
XFILLER_26_28 VPWR VGND sg13g2_decap_8
X_698_ VPWR net100 baud_inst.counter\[26\] clknet_4_11_0_clk VGND _111_ _698_/a_2002_114#
+ _698_/a_741_93# _698_/a_612_127# _698_/a_2250_412# _698_/a_1840_334# _698_/a_1785_429#
+ _698_/a_843_236# _698_/a_132_114# _698_/a_681_505# _698_/a_38_114# _698_/a_324_432#
+ _698_/a_1583_191# _698_/a_1489_191# _698_/a_550_127# _698_/a_298_337# sg13g2_dfrbpq_1
XFILLER_29_231 VPWR VGND sg13g2_decap_4
X_552_ VPWR VGND _313_ baud_inst.counter\[28\] net105 _315_ _552_/a_155_412# _552_/a_257_140#
+ sg13g2_a21oi_1
XFILLER_21_120 VPWR VGND sg13g2_decap_8
X_621_ _110_ net46 VGND VPWR sg13g2_inv_1
X_483_ VGND VPWR _004_ _277_ net28 _168_ _483_/a_22_110# _483_/a_120_432# sg13g2_o21ai_1
Xhold124 rx_inst.data_reg\[5\] VPWR VGND net124 hold124/a_56_118# hold124/a_326_118#
+ hold124/a_438_182# sg13g2_dlygate4sd3_1
Xhold113 baud_inst.counter\[27\] VPWR VGND net113 hold113/a_56_118# hold113/a_326_118#
+ hold113/a_438_182# sg13g2_dlygate4sd3_1
Xhold102 _017_ VPWR VGND net102 hold102/a_56_118# hold102/a_326_118# hold102/a_438_182#
+ sg13g2_dlygate4sd3_1
Xhold157 _298_ VPWR VGND net157 hold157/a_56_118# hold157/a_326_118# hold157/a_438_182#
+ sg13g2_dlygate4sd3_1
Xhold179 tx_inst.data_reg\[0\] VPWR VGND net179 hold179/a_56_118# hold179/a_326_118#
+ hold179/a_438_182# sg13g2_dlygate4sd3_1
Xhold135 baud_inst.counter\[8\] VPWR VGND net135 hold135/a_56_118# hold135/a_326_118#
+ hold135/a_438_182# sg13g2_dlygate4sd3_1
XFILLER_5_149 VPWR VGND sg13g2_decap_8
Xhold168 tx_inst.state\[2\] VPWR VGND net168 hold168/a_56_118# hold168/a_326_118#
+ hold168/a_438_182# sg13g2_dlygate4sd3_1
Xhold146 tx_inst.state\[4\] VPWR VGND net146 hold146/a_56_118# hold146/a_326_118#
+ hold146/a_438_182# sg13g2_dlygate4sd3_1
X_535_ VPWR _305_ baud_inst.counter\[20\] baud_inst.counter\[22\] VGND baud_inst.counter\[21\]
+ _302_ _535_/a_350_122# _535_/a_146_122# _535_/a_248_122# sg13g2_nand4_1
X_466_ VGND VPWR _126_ _269_ _266_ _156_ _466_/a_22_110# _466_/a_120_432# sg13g2_o21ai_1
X_604_ _093_ net38 VGND VPWR sg13g2_inv_1
X_397_ _195_ _219_ _217_ _218_ VPWR VGND _397_/a_165_412# _397_/a_279_412# sg13g2_nor3_1
XFILLER_4_86 VPWR VGND sg13g2_decap_8
X_320_ _155_ net124 VGND VPWR sg13g2_inv_1
Xfanout30 _240_ net30 VPWR VGND fanout30/a_40_152# sg13g2_buf_1
Xfanout41 net43 net41 VPWR VGND fanout41/a_40_152# sg13g2_buf_1
XFILLER_8_0 VPWR VGND sg13g2_decap_8
X_449_ VGND _225_ _260_ net25 VPWR _449_/a_27_156# _449_/a_229_118# sg13g2_nand2b_1
X_518_ _295_ VGND VPWR baud_inst.counter\[14\] net87 _518_/a_139_160# _518_/a_45_160#
+ sg13g2_and2_1
XFILLER_1_7 VPWR VGND sg13g2_decap_8
XFILLER_1_21 VPWR VGND sg13g2_decap_8
XFILLER_29_39 VPWR VGND sg13g2_decap_8
Xoutput18 net18 rx_data[6] VPWR VGND output18/a_40_152# sg13g2_buf_1
XFILLER_23_0 VPWR VGND sg13g2_decap_4
X_697_ VPWR net142 baud_inst.counter\[25\] clknet_4_9_0_clk VGND _110_ _697_/a_2002_114#
+ _697_/a_741_93# _697_/a_612_127# _697_/a_2250_412# _697_/a_1840_334# _697_/a_1785_429#
+ _697_/a_843_236# _697_/a_132_114# _697_/a_681_505# _697_/a_38_114# _697_/a_324_432#
+ _697_/a_1583_191# _697_/a_1489_191# _697_/a_550_127# _697_/a_298_337# sg13g2_dfrbpq_1
X_551_ _314_ baud_inst.counter\[28\] VPWR VGND _313_ net105 _551_/a_272_160# _551_/a_170_160#
+ _551_/a_76_160# sg13g2_and3_1
XFILLER_21_154 VPWR VGND sg13g2_decap_8
X_620_ _109_ net46 VGND VPWR sg13g2_inv_1
X_482_ _277_ VPWR net28 VGND _234_ _482_/a_154_118# sg13g2_nand2_1
XFILLER_12_187 VPWR VGND sg13g2_decap_4
Xhold125 _138_ VPWR VGND net125 hold125/a_56_118# hold125/a_326_118# hold125/a_438_182#
+ sg13g2_dlygate4sd3_1
Xhold114 _027_ VPWR VGND net114 hold114/a_56_118# hold114/a_326_118# hold114/a_438_182#
+ sg13g2_dlygate4sd3_1
Xhold147 baud_inst.counter\[21\] VPWR VGND net147 hold147/a_56_118# hold147/a_326_118#
+ hold147/a_438_182# sg13g2_dlygate4sd3_1
Xhold103 baud_inst.counter\[19\] VPWR VGND net103 hold103/a_56_118# hold103/a_326_118#
+ hold103/a_438_182# sg13g2_dlygate4sd3_1
Xhold158 _016_ VPWR VGND net158 hold158/a_56_118# hold158/a_326_118# hold158/a_438_182#
+ sg13g2_dlygate4sd3_1
Xhold136 _038_ VPWR VGND net136 hold136/a_56_118# hold136/a_326_118# hold136/a_438_182#
+ sg13g2_dlygate4sd3_1
Xhold169 _274_ VPWR VGND net169 hold169/a_56_118# hold169/a_326_118# hold169/a_438_182#
+ sg13g2_dlygate4sd3_1
X_534_ net148 _304_ VPWR _021_ VGND _534_/a_268_412# _534_/a_46_156# sg13g2_nor2b_1
X_465_ VGND VPWR _269_ net73 _264_ net30 _465_/a_22_110# _465_/a_120_432# sg13g2_o21ai_1
X_603_ _092_ net38 VGND VPWR sg13g2_inv_1
X_396_ VPWR VGND net34 net183 net173 _218_ _396_/a_155_412# _396_/a_257_140# sg13g2_a21oi_1
XFILLER_4_21 VPWR VGND sg13g2_decap_8
Xfanout31 _224_ net31 VPWR VGND fanout31/a_40_152# sg13g2_buf_1
Xfanout42 net43 net42 VPWR VGND fanout42/a_40_152# sg13g2_buf_1
X_448_ _259_ _133_ _160_ _258_ _232_ VPWR _170_ VGND _448_/a_142_412# _448_/a_244_140#
+ _448_/a_550_140# _448_/a_244_412# sg13g2_a221oi_1
X_517_ _013_ VPWR _294_ net90 VGND _517_/a_209_168# _517_/a_177_436# _517_/a_380_412#
+ _517_/a_474_130# sg13g2_xor2_1
X_379_ net54 net9 VPWR _208_ VGND _379_/a_268_412# _379_/a_46_156# sg13g2_nor2b_1
XFILLER_27_7 VPWR VGND sg13g2_decap_8
XFILLER_29_18 VPWR VGND sg13g2_decap_8
Xoutput19 net19 rx_data[7] VPWR VGND output19/a_40_152# sg13g2_buf_1
X_696_ VPWR _024_ baud_inst.counter\[24\] clknet_4_8_0_clk VGND _109_ _696_/a_2002_114#
+ _696_/a_741_93# _696_/a_612_127# _696_/a_2250_412# _696_/a_1840_334# _696_/a_1785_429#
+ _696_/a_843_236# _696_/a_132_114# _696_/a_681_505# _696_/a_38_114# _696_/a_324_432#
+ _696_/a_1583_191# _696_/a_1489_191# _696_/a_550_127# _696_/a_298_337# sg13g2_dfrbpq_1
X_550_ _028_ VPWR _313_ net133 VGND _550_/a_209_168# _550_/a_177_436# _550_/a_380_412#
+ _550_/a_474_130# sg13g2_xor2_1
X_481_ VGND VPWR _005_ _276_ net26 _171_ _481_/a_22_110# _481_/a_120_432# sg13g2_o21ai_1
Xhold126 rx_inst.data_reg\[6\] VPWR VGND net126 hold126/a_56_118# hold126/a_326_118#
+ hold126/a_438_182# sg13g2_dlygate4sd3_1
Xhold148 _303_ VPWR VGND net148 hold148/a_56_118# hold148/a_326_118# hold148/a_438_182#
+ sg13g2_dlygate4sd3_1
Xhold104 _018_ VPWR VGND net104 hold104/a_56_118# hold104/a_326_118# hold104/a_438_182#
+ sg13g2_dlygate4sd3_1
Xhold159 tx_inst.data_reg\[1\] VPWR VGND net159 hold159/a_56_118# hold159/a_326_118#
+ hold159/a_438_182# sg13g2_dlygate4sd3_1
Xhold115 baud_inst.counter\[9\] VPWR VGND net115 hold115/a_56_118# hold115/a_326_118#
+ hold115/a_438_182# sg13g2_dlygate4sd3_1
X_679_ VPWR net96 baud_inst.counter\[7\] clknet_4_3_0_clk VGND _092_ _679_/a_2002_114#
+ _679_/a_741_93# _679_/a_612_127# _679_/a_2250_412# _679_/a_1840_334# _679_/a_1785_429#
+ _679_/a_843_236# _679_/a_132_114# _679_/a_681_505# _679_/a_38_114# _679_/a_324_432#
+ _679_/a_1583_191# _679_/a_1489_191# _679_/a_550_127# _679_/a_298_337# sg13g2_dfrbpq_1
Xhold137 tx_inst.data_reg\[5\] VPWR VGND net137 hold137/a_56_118# hold137/a_326_118#
+ hold137/a_438_182# sg13g2_dlygate4sd3_1
X_464_ VGND VPWR _127_ _268_ _266_ _155_ _464_/a_22_110# _464_/a_120_432# sg13g2_o21ai_1
X_533_ VPWR _304_ baud_inst.counter\[20\] _302_ net147 VGND _533_/a_146_122# _533_/a_248_122#
+ sg13g2_nand3_1
X_602_ _091_ net40 VGND VPWR sg13g2_inv_1
XFILLER_4_140 VPWR VGND sg13g2_decap_8
X_395_ VPWR _217_ net27 _215_ net168 VGND _395_/a_146_122# _395_/a_248_122# sg13g2_nand3_1
Xfanout32 _223_ net32 VPWR VGND fanout32/a_40_152# sg13g2_buf_1
Xfanout43 net49 net43 VPWR VGND fanout43/a_40_152# sg13g2_buf_1
X_447_ _259_ _223_ _167_ VPWR VGND net25 _257_ _447_/a_277_118# _447_/a_379_118# _447_/a_175_118#
+ _447_/a_81_118# sg13g2_and4_1
X_516_ net29 _012_ net129 _294_ VPWR VGND _516_/a_165_412# _516_/a_279_412# sg13g2_nor3_1
X_378_ _207_ _151_ _206_ VPWR VGND net155 _378_/a_59_156# _378_/a_285_412# _378_/a_382_118#
+ _378_/a_496_118# _378_/a_285_118# _378_/a_559_412# sg13g2_mux2_1
XFILLER_28_128 VPWR VGND sg13g2_decap_8
XFILLER_0_219 VPWR VGND sg13g2_decap_8
X_695_ VPWR net76 baud_inst.counter\[23\] clknet_4_10_0_clk VGND _108_ _695_/a_2002_114#
+ _695_/a_741_93# _695_/a_612_127# _695_/a_2250_412# _695_/a_1840_334# _695_/a_1785_429#
+ _695_/a_843_236# _695_/a_132_114# _695_/a_681_505# _695_/a_38_114# _695_/a_324_432#
+ _695_/a_1583_191# _695_/a_1489_191# _695_/a_550_127# _695_/a_298_337# sg13g2_dfrbpq_1
X_480_ VGND VPWR _276_ net168 net174 net26 _480_/a_22_110# _480_/a_120_432# sg13g2_o21ai_1
Xhold105 baud_inst.counter\[29\] VPWR VGND net105 hold105/a_56_118# hold105/a_326_118#
+ hold105/a_438_182# sg13g2_dlygate4sd3_1
Xhold127 _139_ VPWR VGND net127 hold127/a_56_118# hold127/a_326_118# hold127/a_438_182#
+ sg13g2_dlygate4sd3_1
Xhold149 _021_ VPWR VGND net149 hold149/a_56_118# hold149/a_326_118# hold149/a_438_182#
+ sg13g2_dlygate4sd3_1
Xhold138 rx_inst.data_reg\[4\] VPWR VGND net138 hold138/a_56_118# hold138/a_326_118#
+ hold138/a_438_182# sg13g2_dlygate4sd3_1
X_678_ VPWR net93 baud_inst.counter\[6\] clknet_4_1_0_clk VGND _091_ _678_/a_2002_114#
+ _678_/a_741_93# _678_/a_612_127# _678_/a_2250_412# _678_/a_1840_334# _678_/a_1785_429#
+ _678_/a_843_236# _678_/a_132_114# _678_/a_681_505# _678_/a_38_114# _678_/a_324_432#
+ _678_/a_1583_191# _678_/a_1489_191# _678_/a_550_127# _678_/a_298_337# sg13g2_dfrbpq_1
XFILLER_7_182 VPWR VGND sg13g2_decap_8
Xhold116 _289_ VPWR VGND net116 hold116/a_56_118# hold116/a_326_118# hold116/a_438_182#
+ sg13g2_dlygate4sd3_1
X_601_ _090_ net39 VGND VPWR sg13g2_inv_1
XFILLER_27_96 VPWR VGND sg13g2_decap_8
X_463_ VGND VPWR _268_ net71 _264_ net30 _463_/a_22_110# _463_/a_120_432# sg13g2_o21ai_1
X_532_ VPWR VGND _302_ baud_inst.counter\[20\] net147 _303_ _532_/a_155_412# _532_/a_257_140#
+ sg13g2_a21oi_1
X_394_ VGND VPWR _216_ _215_ _200_ net27 _394_/a_22_110# _394_/a_120_432# sg13g2_o21ai_1
Xfanout44 net46 net44 VPWR VGND fanout44/a_40_152# sg13g2_buf_1
Xfanout33 _040_ net33 VPWR VGND fanout33/a_40_152# sg13g2_buf_1
X_446_ VPWR _258_ net24 _257_ _223_ VGND _446_/a_146_122# _446_/a_248_122# sg13g2_nand3_1
X_515_ _294_ net128 VPWR VGND _292_ baud_inst.counter\[12\] _515_/a_272_160# _515_/a_170_160#
+ _515_/a_76_160# sg13g2_and3_1
X_377_ net55 net10 VPWR _207_ VGND _377_/a_268_412# _377_/a_46_156# sg13g2_nor2b_1
XFILLER_6_0 VPWR VGND sg13g2_decap_8
X_429_ _245_ _138_ _155_ _244_ _232_ VPWR _170_ VGND _429_/a_142_412# _429_/a_244_140#
+ _429_/a_550_140# _429_/a_244_412# sg13g2_a221oi_1
XFILLER_1_79 VPWR VGND sg13g2_decap_8
Xinput1 rst net1 VPWR VGND input1/a_40_152# sg13g2_buf_1
XFILLER_28_107 VPWR VGND sg13g2_decap_8
X_694_ VPWR net121 baud_inst.counter\[22\] clknet_4_10_0_clk VGND _107_ _694_/a_2002_114#
+ _694_/a_741_93# _694_/a_612_127# _694_/a_2250_412# _694_/a_1840_334# _694_/a_1785_429#
+ _694_/a_843_236# _694_/a_132_114# _694_/a_681_505# _694_/a_38_114# _694_/a_324_432#
+ _694_/a_1583_191# _694_/a_1489_191# _694_/a_550_127# _694_/a_298_337# sg13g2_dfrbpq_1
XFILLER_21_113 VPWR VGND sg13g2_decap_8
Xhold106 _315_ VPWR VGND net106 hold106/a_56_118# hold106/a_326_118# hold106/a_438_182#
+ sg13g2_dlygate4sd3_1
Xhold139 _137_ VPWR VGND net139 hold139/a_56_118# hold139/a_326_118# hold139/a_438_182#
+ sg13g2_dlygate4sd3_1
Xhold128 baud_inst.counter\[13\] VPWR VGND net128 hold128/a_56_118# hold128/a_326_118#
+ hold128/a_438_182# sg13g2_dlygate4sd3_1
Xhold117 _039_ VPWR VGND net117 hold117/a_56_118# hold117/a_326_118# hold117/a_438_182#
+ sg13g2_dlygate4sd3_1
X_677_ VPWR net154 baud_inst.counter\[5\] clknet_4_3_0_clk VGND _090_ _677_/a_2002_114#
+ _677_/a_741_93# _677_/a_612_127# _677_/a_2250_412# _677_/a_1840_334# _677_/a_1785_429#
+ _677_/a_843_236# _677_/a_132_114# _677_/a_681_505# _677_/a_38_114# _677_/a_324_432#
+ _677_/a_1583_191# _677_/a_1489_191# _677_/a_550_127# _677_/a_298_337# sg13g2_dfrbpq_1
XFILLER_27_42 VPWR VGND sg13g2_decap_4
X_462_ VGND VPWR _128_ _267_ _266_ _154_ _462_/a_22_110# _462_/a_120_432# sg13g2_o21ai_1
X_531_ _020_ VPWR _302_ net163 VGND _531_/a_209_168# _531_/a_177_436# _531_/a_380_412#
+ _531_/a_474_130# sg13g2_xor2_1
X_600_ _089_ net39 VGND VPWR sg13g2_inv_1
XFILLER_4_79 VPWR VGND sg13g2_decap_8
X_393_ net146 VPWR _215_ VGND net50 _393_/a_170_412# sg13g2_nor2_1
Xfanout45 net46 net45 VPWR VGND fanout45/a_40_152# sg13g2_buf_1
X_514_ VPWR VGND _292_ baud_inst.counter\[12\] net128 _293_ _514_/a_155_412# _514_/a_257_140#
+ sg13g2_a21oi_1
Xfanout34 net56 net34 VPWR VGND fanout34/a_40_152# sg13g2_buf_1
X_445_ rx_inst.bit_index\[2\] _257_ rx_inst.bit_index\[1\] net36 VPWR VGND _445_/a_165_412#
+ _445_/a_279_412# sg13g2_nor3_1
X_376_ _206_ _200_ VPWR VGND _073_ _166_ _376_/a_272_160# _376_/a_170_160# _376_/a_76_160#
+ sg13g2_and3_1
XFILLER_24_98 VPWR VGND sg13g2_decap_8
X_428_ VGND VPWR net31 _230_ _245_ net37 _243_ _428_/a_252_412# _428_/a_354_412# _428_/a_150_412#
+ sg13g2_nor4_1
XFILLER_1_14 VPWR VGND sg13g2_decap_8
X_359_ VGND VPWR _192_ net168 net27 _176_ _359_/a_22_110# _359_/a_120_432# sg13g2_o21ai_1
Xinput2 rx net2 VPWR VGND input2/a_40_152# sg13g2_buf_1
XFILLER_19_32 VPWR VGND sg13g2_decap_8
X_693_ VPWR net149 baud_inst.counter\[21\] clknet_4_10_0_clk VGND _106_ _693_/a_2002_114#
+ _693_/a_741_93# _693_/a_612_127# _693_/a_2250_412# _693_/a_1840_334# _693_/a_1785_429#
+ _693_/a_843_236# _693_/a_132_114# _693_/a_681_505# _693_/a_38_114# _693_/a_324_432#
+ _693_/a_1583_191# _693_/a_1489_191# _693_/a_550_127# _693_/a_298_337# sg13g2_dfrbpq_1
X_676_ VPWR _034_ baud_inst.counter\[4\] clknet_4_3_0_clk VGND _089_ _676_/a_2002_114#
+ _676_/a_741_93# _676_/a_612_127# _676_/a_2250_412# _676_/a_1840_334# _676_/a_1785_429#
+ _676_/a_843_236# _676_/a_132_114# _676_/a_681_505# _676_/a_38_114# _676_/a_324_432#
+ _676_/a_1583_191# _676_/a_1489_191# _676_/a_550_127# _676_/a_298_337# sg13g2_dfrbpq_1
Xhold107 _029_ VPWR VGND net107 hold107/a_56_118# hold107/a_326_118# hold107/a_438_182#
+ sg13g2_dlygate4sd3_1
Xhold118 rx_inst.data_reg\[7\] VPWR VGND net118 hold118/a_56_118# hold118/a_326_118#
+ hold118/a_438_182# sg13g2_dlygate4sd3_1
Xhold129 _293_ VPWR VGND net129 hold129/a_56_118# hold129/a_326_118# hold129/a_438_182#
+ sg13g2_dlygate4sd3_1
XFILLER_27_21 VPWR VGND sg13g2_decap_8
X_461_ VGND VPWR _267_ net69 _264_ net30 _461_/a_22_110# _461_/a_120_432# sg13g2_o21ai_1
X_530_ VPWR VGND _300_ _164_ _302_ _018_ _530_/a_155_412# _530_/a_257_140# sg13g2_a21oi_1
X_392_ _214_ _144_ _206_ VPWR VGND net179 _392_/a_59_156# _392_/a_285_412# _392_/a_382_118#
+ _392_/a_496_118# _392_/a_285_118# _392_/a_559_412# sg13g2_mux2_1
XFILLER_4_14 VPWR VGND sg13g2_decap_8
X_659_ VPWR _149_ tx_inst.data_reg\[5\] clknet_4_4_0_clk VGND _070_ _659_/a_2002_114#
+ _659_/a_741_93# _659_/a_612_127# _659_/a_2250_412# _659_/a_1840_334# _659_/a_1785_429#
+ _659_/a_843_236# _659_/a_132_114# _659_/a_681_505# _659_/a_38_114# _659_/a_324_432#
+ _659_/a_1583_191# _659_/a_1489_191# _659_/a_550_127# _659_/a_298_337# sg13g2_dfrbpq_1
Xfanout46 net49 net46 VPWR VGND fanout46/a_40_152# sg13g2_buf_1
Xfanout24 net25 net24 VPWR VGND fanout24/a_40_152# sg13g2_buf_1
Xfanout35 rx_inst.bit_index\[2\] net35 VPWR VGND fanout35/a_40_152# sg13g2_buf_1
X_444_ _256_ _134_ _159_ _255_ _232_ VPWR _170_ VGND _444_/a_142_412# _444_/a_244_140#
+ _444_/a_550_140# _444_/a_244_412# sg13g2_a221oi_1
X_513_ _011_ _292_ VPWR _163_ VGND _513_/a_155_160# _513_/a_192_429# _513_/a_435_412#
+ _513_/a_341_118# sg13g2_xnor2_1
X_375_ net50 VPWR _073_ VGND _199_ _375_/a_170_412# sg13g2_nor2_1
X_427_ VPWR _244_ net32 net24 VGND rx_inst.bit_index\[2\] _242_ _427_/a_350_122# _427_/a_146_122#
+ _427_/a_248_122# sg13g2_nand4_1
XFILLER_24_55 VPWR VGND sg13g2_decap_8
X_358_ _191_ _186_ _189_ VPWR VGND _180_ _182_ _358_/a_72_436# _358_/a_268_436# _358_/a_411_436#
+ _358_/a_166_436# sg13g2_or4_1
Xinput3 tx_data[0] net3 VPWR VGND input3/a_40_152# sg13g2_buf_1
XFILLER_27_131 VPWR VGND sg13g2_decap_4
XFILLER_24_112 VPWR VGND sg13g2_decap_8
X_692_ VPWR net164 baud_inst.counter\[20\] clknet_4_10_0_clk VGND _105_ _692_/a_2002_114#
+ _692_/a_741_93# _692_/a_612_127# _692_/a_2250_412# _692_/a_1840_334# _692_/a_1785_429#
+ _692_/a_843_236# _692_/a_132_114# _692_/a_681_505# _692_/a_38_114# _692_/a_324_432#
+ _692_/a_1583_191# _692_/a_1489_191# _692_/a_550_127# _692_/a_298_337# sg13g2_dfrbpq_1
XFILLER_15_112 VPWR VGND sg13g2_decap_4
XFILLER_20_170 VPWR VGND sg13g2_decap_8
X_675_ VPWR net61 baud_inst.counter\[3\] clknet_4_0_0_clk VGND _088_ _675_/a_2002_114#
+ _675_/a_741_93# _675_/a_612_127# _675_/a_2250_412# _675_/a_1840_334# _675_/a_1785_429#
+ _675_/a_843_236# _675_/a_132_114# _675_/a_681_505# _675_/a_38_114# _675_/a_324_432#
+ _675_/a_1583_191# _675_/a_1489_191# _675_/a_550_127# _675_/a_298_337# sg13g2_dfrbpq_1
Xhold119 _140_ VPWR VGND net119 hold119/a_56_118# hold119/a_326_118# hold119/a_438_182#
+ sg13g2_dlygate4sd3_1
XFILLER_11_192 VPWR VGND sg13g2_decap_4
Xhold108 baud_inst.counter\[11\] VPWR VGND net108 hold108/a_56_118# hold108/a_326_118#
+ hold108/a_438_182# sg13g2_dlygate4sd3_1
XFILLER_7_196 VPWR VGND sg13g2_decap_4
X_460_ VGND VPWR _129_ _265_ _266_ _153_ _460_/a_22_110# _460_/a_120_432# sg13g2_o21ai_1
X_391_ net54 net3 VPWR _214_ VGND _391_/a_268_412# _391_/a_46_156# sg13g2_nor2b_1
X_658_ VPWR _148_ tx_inst.data_reg\[4\] clknet_4_4_0_clk VGND _069_ _658_/a_2002_114#
+ _658_/a_741_93# _658_/a_612_127# _658_/a_2250_412# _658_/a_1840_334# _658_/a_1785_429#
+ _658_/a_843_236# _658_/a_132_114# _658_/a_681_505# _658_/a_38_114# _658_/a_324_432#
+ _658_/a_1583_191# _658_/a_1489_191# _658_/a_550_127# _658_/a_298_337# sg13g2_dfrbpq_1
XFILLER_4_48 VPWR VGND sg13g2_decap_4
X_589_ _077_ net43 VGND VPWR sg13g2_inv_1
Xfanout47 net48 net47 VPWR VGND fanout47/a_40_152# sg13g2_buf_1
Xfanout36 net52 net36 VPWR VGND fanout36/a_40_152# sg13g2_buf_1
Xfanout25 _229_ net25 VPWR VGND fanout25/a_40_152# sg13g2_buf_1
X_443_ VGND VPWR _224_ _230_ _256_ net2 _254_ _443_/a_252_412# _443_/a_354_412# _443_/a_150_412#
+ sg13g2_nor4_1
X_374_ net51 _079_ net62 _205_ _204_ VPWR net37 VGND _374_/a_142_412# _374_/a_244_140#
+ _374_/a_550_140# _374_/a_244_412# sg13g2_a221oi_1
X_512_ net29 _010_ net109 _292_ VPWR VGND _512_/a_165_412# _512_/a_279_412# sg13g2_nor3_1
XFILLER_5_80 VPWR VGND sg13g2_decap_4
X_426_ _243_ VPWR rx_inst.bit_index\[2\] VGND _242_ _426_/a_154_118# sg13g2_nand2_1
X_357_ VGND VPWR _182_ _186_ _190_ _180_ _189_ _357_/a_252_412# _357_/a_354_412# _357_/a_150_412#
+ sg13g2_nor4_1
Xinput4 tx_data[1] net4 VPWR VGND input4/a_40_152# sg13g2_buf_1
XFILLER_27_110 VPWR VGND sg13g2_decap_8
X_409_ VPWR VGND rx_inst.state\[3\] net51 net62 _228_ _409_/a_167_412# _409_/a_73_118#
+ _409_/a_269_412# sg13g2_or3_1
XFILLER_4_0 VPWR VGND sg13g2_decap_8
XFILLER_2_92 VPWR VGND sg13g2_decap_4
X_691_ VPWR net104 baud_inst.counter\[19\] clknet_4_8_0_clk VGND _104_ _691_/a_2002_114#
+ _691_/a_741_93# _691_/a_612_127# _691_/a_2250_412# _691_/a_1840_334# _691_/a_1785_429#
+ _691_/a_843_236# _691_/a_132_114# _691_/a_681_505# _691_/a_38_114# _691_/a_324_432#
+ _691_/a_1583_191# _691_/a_1489_191# _691_/a_550_127# _691_/a_298_337# sg13g2_dfrbpq_1
XFILLER_15_102 VPWR VGND sg13g2_decap_8
XFILLER_21_127 VPWR VGND sg13g2_decap_4
X_674_ VPWR _030_ baud_inst.counter\[2\] clknet_4_0_0_clk VGND _087_ _674_/a_2002_114#
+ _674_/a_741_93# _674_/a_612_127# _674_/a_2250_412# _674_/a_1840_334# _674_/a_1785_429#
+ _674_/a_843_236# _674_/a_132_114# _674_/a_681_505# _674_/a_38_114# _674_/a_324_432#
+ _674_/a_1583_191# _674_/a_1489_191# _674_/a_550_127# _674_/a_298_337# sg13g2_dfrbpq_1
XFILLER_8_109 VPWR VGND sg13g2_decap_8
XFILLER_11_182 VPWR VGND sg13g2_decap_8
XFILLER_11_171 VPWR VGND sg13g2_decap_4
Xhold109 _290_ VPWR VGND net109 hold109/a_56_118# hold109/a_326_118# hold109/a_438_182#
+ sg13g2_dlygate4sd3_1
X_390_ _213_ _145_ _206_ VPWR VGND net159 _390_/a_59_156# _390_/a_285_412# _390_/a_382_118#
+ _390_/a_496_118# _390_/a_285_118# _390_/a_559_412# sg13g2_mux2_1
X_588_ _076_ net41 VGND VPWR sg13g2_inv_1
X_657_ VPWR _147_ tx_inst.data_reg\[3\] clknet_4_1_0_clk VGND _068_ _657_/a_2002_114#
+ _657_/a_741_93# _657_/a_612_127# _657_/a_2250_412# _657_/a_1840_334# _657_/a_1785_429#
+ _657_/a_843_236# _657_/a_132_114# _657_/a_681_505# _657_/a_38_114# _657_/a_324_432#
+ _657_/a_1583_191# _657_/a_1489_191# _657_/a_550_127# _657_/a_298_337# sg13g2_dfrbpq_1
Xfanout48 net49 net48 VPWR VGND fanout48/a_40_152# sg13g2_buf_1
Xfanout26 _191_ net26 VPWR VGND fanout26/a_40_152# sg13g2_buf_1
Xfanout37 net2 net37 VPWR VGND fanout37/a_40_152# sg13g2_buf_1
X_442_ VPWR _255_ net32 net24 VGND _161_ _242_ _442_/a_350_122# _442_/a_146_122# _442_/a_248_122#
+ sg13g2_nand4_1
X_373_ net37 VPWR _205_ VGND net26 _373_/a_170_412# sg13g2_nor2_1
XFILLER_8_7 VPWR VGND sg13g2_decap_8
X_511_ VGND VPWR _282_ _286_ _292_ _182_ _291_ _511_/a_252_412# _511_/a_354_412# _511_/a_150_412#
+ sg13g2_nor4_1
X_425_ rx_inst.bit_index\[1\] net36 VPWR _242_ VGND _425_/a_268_412# _425_/a_46_156#
+ sg13g2_nor2b_1
X_356_ VPWR _189_ baud_inst.counter\[13\] _187_ VGND _163_ _188_ _356_/a_350_122#
+ _356_/a_146_122# _356_/a_248_122# sg13g2_nand4_1
Xinput5 tx_data[2] net5 VPWR VGND input5/a_40_152# sg13g2_buf_1
XFILLER_18_100 VPWR VGND sg13g2_decap_8
X_408_ _227_ VPWR net180 VGND _226_ _408_/a_154_118# sg13g2_nand2_1
X_339_ _172_ tx_inst.data_reg\[3\] tx_inst.data_reg\[5\] tx_inst.bit_index\[1\] VPWR
+ VGND tx_inst.bit_index\[2\] tx_inst.data_reg\[1\] tx_inst.data_reg\[7\] _339_/a_1453_124#
+ _339_/a_500_118# _339_/a_805_385# _339_/a_1023_118# _339_/a_589_385# _339_/a_382_118#
+ _339_/a_1377_160# _339_/a_295_385# _339_/a_810_118# _339_/a_71_118# _339_/a_1109_431#
+ _339_/a_886_118# _339_/a_308_118# sg13g2_mux4_1
X_690_ VPWR net102 baud_inst.counter\[18\] clknet_4_8_0_clk VGND _103_ _690_/a_2002_114#
+ _690_/a_741_93# _690_/a_612_127# _690_/a_2250_412# _690_/a_1840_334# _690_/a_1785_429#
+ _690_/a_843_236# _690_/a_132_114# _690_/a_681_505# _690_/a_38_114# _690_/a_324_432#
+ _690_/a_1583_191# _690_/a_1489_191# _690_/a_550_127# _690_/a_298_337# sg13g2_dfrbpq_1
Xclkbuf_4_9_0_clk clknet_4_9_0_clk VPWR clknet_0_clk VGND clkbuf_4_9_0_clk/a_27_118#
+ sg13g2_buf_8
XFILLER_20_194 VPWR VGND sg13g2_decap_4
X_673_ VPWR _019_ baud_inst.counter\[1\] clknet_4_1_0_clk VGND _086_ _673_/a_2002_114#
+ _673_/a_741_93# _673_/a_612_127# _673_/a_2250_412# _673_/a_1840_334# _673_/a_1785_429#
+ _673_/a_843_236# _673_/a_132_114# _673_/a_681_505# _673_/a_38_114# _673_/a_324_432#
+ _673_/a_1583_191# _673_/a_1489_191# _673_/a_550_127# _673_/a_298_337# sg13g2_dfrbpq_1
XFILLER_7_110 VPWR VGND sg13g2_decap_8
XFILLER_7_132 VPWR VGND sg13g2_decap_8
XFILLER_27_35 VPWR VGND sg13g2_decap_8
X_587_ _075_ net42 VGND VPWR sg13g2_inv_1
X_656_ VPWR _146_ tx_inst.data_reg\[2\] clknet_4_4_0_clk VGND _067_ _656_/a_2002_114#
+ _656_/a_741_93# _656_/a_612_127# _656_/a_2250_412# _656_/a_1840_334# _656_/a_1785_429#
+ _656_/a_843_236# _656_/a_132_114# _656_/a_681_505# _656_/a_38_114# _656_/a_324_432#
+ _656_/a_1583_191# _656_/a_1489_191# _656_/a_550_127# _656_/a_298_337# sg13g2_dfrbpq_1
XFILLER_4_28 VPWR VGND sg13g2_decap_8
Xfanout49 net1 net49 VPWR VGND fanout49/a_40_152# sg13g2_buf_1
Xfanout27 net29 net27 VPWR VGND fanout27/a_40_152# sg13g2_buf_1
Xfanout38 net40 net38 VPWR VGND fanout38/a_40_152# sg13g2_buf_1
X_441_ _254_ VPWR _161_ VGND _242_ _441_/a_154_118# sg13g2_nand2_1
X_372_ VGND VPWR _204_ _041_ net26 _169_ _372_/a_22_110# _372_/a_120_432# sg13g2_o21ai_1
X_510_ VPWR _291_ net135 net97 VGND net115 net108 _510_/a_350_122# _510_/a_146_122#
+ _510_/a_248_122# sg13g2_nand4_1
X_639_ VPWR net81 net19 clknet_4_13_0_clk VGND _050_ _639_/a_2002_114# _639_/a_741_93#
+ _639_/a_612_127# _639_/a_2250_412# _639_/a_1840_334# _639_/a_1785_429# _639_/a_843_236#
+ _639_/a_132_114# _639_/a_681_505# _639_/a_38_114# _639_/a_324_432# _639_/a_1583_191#
+ _639_/a_1489_191# _639_/a_550_127# _639_/a_298_337# sg13g2_dfrbpq_1
X_424_ _239_ _139_ _154_ _238_ _232_ VPWR _170_ VGND _424_/a_142_412# _424_/a_244_140#
+ _424_/a_550_140# _424_/a_244_412# sg13g2_a221oi_1
X_355_ VGND VPWR baud_inst.counter\[16\] baud_inst.counter\[19\] _188_ baud_inst.counter\[17\]
+ baud_inst.counter\[18\] _355_/a_252_412# _355_/a_354_412# _355_/a_150_412# sg13g2_nor4_1
Xinput6 tx_data[3] net6 VPWR VGND input6/a_40_152# sg13g2_buf_1
XFILLER_24_126 VPWR VGND sg13g2_decap_8
X_338_ _043_ net47 VGND VPWR sg13g2_inv_1
X_407_ VPWR _226_ net175 net36 net35 VGND _407_/a_146_122# _407_/a_248_122# sg13g2_nand3_1
X_672_ VPWR _008_ baud_inst.counter\[0\] clknet_4_0_0_clk VGND _085_ _672_/a_2002_114#
+ _672_/a_741_93# _672_/a_612_127# _672_/a_2250_412# _672_/a_1840_334# _672_/a_1785_429#
+ _672_/a_843_236# _672_/a_132_114# _672_/a_681_505# _672_/a_38_114# _672_/a_324_432#
+ _672_/a_1583_191# _672_/a_1489_191# _672_/a_550_127# _672_/a_298_337# sg13g2_dfrbpq_1
XFILLER_27_14 VPWR VGND sg13g2_decap_8
Xclkbuf_4_8_0_clk clknet_4_8_0_clk VPWR clknet_0_clk VGND clkbuf_4_8_0_clk/a_27_118#
+ sg13g2_buf_8
XFILLER_4_147 VPWR VGND sg13g2_decap_4
X_586_ _074_ net41 VGND VPWR sg13g2_inv_1
X_655_ VPWR _145_ tx_inst.data_reg\[1\] clknet_4_1_0_clk VGND _066_ _655_/a_2002_114#
+ _655_/a_741_93# _655_/a_612_127# _655_/a_2250_412# _655_/a_1840_334# _655_/a_1785_429#
+ _655_/a_843_236# _655_/a_132_114# _655_/a_681_505# _655_/a_38_114# _655_/a_324_432#
+ _655_/a_1583_191# _655_/a_1489_191# _655_/a_550_127# _655_/a_298_337# sg13g2_dfrbpq_1
X_440_ _253_ _135_ _158_ _252_ _232_ VPWR _170_ VGND _440_/a_142_412# _440_/a_244_140#
+ _440_/a_550_140# _440_/a_244_412# sg13g2_a221oi_1
Xfanout28 net29 net28 VPWR VGND fanout28/a_40_152# sg13g2_buf_1
Xfanout39 net40 net39 VPWR VGND fanout39/a_40_152# sg13g2_buf_1
X_371_ _198_ VPWR _119_ VGND _203_ _371_/a_170_412# sg13g2_nor2_1
X_569_ _056_ net47 VGND VPWR sg13g2_inv_1
X_638_ VPWR net70 net18 clknet_4_15_0_clk VGND _049_ _638_/a_2002_114# _638_/a_741_93#
+ _638_/a_612_127# _638_/a_2250_412# _638_/a_1840_334# _638_/a_1785_429# _638_/a_843_236#
+ _638_/a_132_114# _638_/a_681_505# _638_/a_38_114# _638_/a_324_432# _638_/a_1583_191#
+ _638_/a_1489_191# _638_/a_550_127# _638_/a_298_337# sg13g2_dfrbpq_1
X_707_ VPWR net51 net20 clknet_4_7_0_clk VGND _121_ _707_/a_2002_114# _707_/a_741_93#
+ _707_/a_612_127# _707_/a_2250_412# _707_/a_1840_334# _707_/a_1785_429# _707_/a_843_236#
+ _707_/a_132_114# _707_/a_681_505# _707_/a_38_114# _707_/a_324_432# _707_/a_1583_191#
+ _707_/a_1489_191# _707_/a_550_127# _707_/a_298_337# sg13g2_dfrbpq_1
XFILLER_24_48 VPWR VGND sg13g2_decap_8
X_423_ rx_inst.state\[2\] _241_ net31 _228_ VPWR VGND _423_/a_165_412# _423_/a_279_412#
+ sg13g2_nor3_1
X_354_ baud_inst.counter\[15\] VPWR _187_ VGND baud_inst.counter\[14\] _354_/a_170_412#
+ sg13g2_nor2_1
Xinput7 tx_data[4] net7 VPWR VGND input7/a_40_152# sg13g2_buf_1
XFILLER_27_124 VPWR VGND sg13g2_decap_8
XFILLER_19_48 VPWR VGND sg13g2_decap_8
X_406_ _225_ VPWR net175 VGND net36 _406_/a_154_118# sg13g2_nand2_1
X_337_ _171_ net172 VGND VPWR sg13g2_inv_1
XFILLER_24_105 VPWR VGND sg13g2_decap_8
XFILLER_2_0 VPWR VGND sg13g2_decap_8
Xinput10 tx_data[7] net10 VPWR VGND input10/a_40_152# sg13g2_buf_1
XFILLER_20_163 VPWR VGND sg13g2_decap_8
X_671_ VPWR _004_ rx_inst.state\[4\] clknet_4_6_0_clk VGND _084_ _671_/a_2002_114#
+ _671_/a_741_93# _671_/a_612_127# _671_/a_2250_412# _671_/a_1840_334# _671_/a_1785_429#
+ _671_/a_843_236# _671_/a_132_114# _671_/a_681_505# _671_/a_38_114# _671_/a_324_432#
+ _671_/a_1583_191# _671_/a_1489_191# _671_/a_550_127# _671_/a_298_337# sg13g2_dfrbpq_1
XFILLER_11_130 VPWR VGND sg13g2_decap_4
XFILLER_7_189 VPWR VGND sg13g2_decap_8
X_654_ VPWR _144_ tx_inst.data_reg\[0\] clknet_4_5_0_clk VGND _065_ _654_/a_2002_114#
+ _654_/a_741_93# _654_/a_612_127# _654_/a_2250_412# _654_/a_1840_334# _654_/a_1785_429#
+ _654_/a_843_236# _654_/a_132_114# _654_/a_681_505# _654_/a_38_114# _654_/a_324_432#
+ _654_/a_1583_191# _654_/a_1489_191# _654_/a_550_127# _654_/a_298_337# sg13g2_dfrbpq_1
X_585_ _072_ net38 VGND VPWR sg13g2_inv_1
XFILLER_3_192 VPWR VGND sg13g2_decap_8
Xfanout29 _190_ net29 VPWR VGND fanout29/a_40_152# sg13g2_buf_1
X_637_ VPWR net72 net17 clknet_4_15_0_clk VGND _048_ _637_/a_2002_114# _637_/a_741_93#
+ _637_/a_612_127# _637_/a_2250_412# _637_/a_1840_334# _637_/a_1785_429# _637_/a_843_236#
+ _637_/a_132_114# _637_/a_681_505# _637_/a_38_114# _637_/a_324_432# _637_/a_1583_191#
+ _637_/a_1489_191# _637_/a_550_127# _637_/a_298_337# sg13g2_dfrbpq_1
X_706_ VPWR _119_ _042_ clknet_4_5_0_clk VGND _120_ _706_/a_2002_114# _706_/a_741_93#
+ _706_/a_612_127# _706_/a_2250_412# _706_/a_1840_334# _706_/a_1785_429# _706_/a_843_236#
+ _706_/a_132_114# _706_/a_681_505# _706_/a_38_114# _706_/a_324_432# _706_/a_1583_191#
+ _706_/a_1489_191# _706_/a_550_127# _706_/a_298_337# sg13g2_dfrbpq_1
X_370_ _203_ VPWR _201_ VGND _202_ _370_/a_154_118# sg13g2_nand2_1
X_568_ _055_ net47 VGND VPWR sg13g2_inv_1
Xclkbuf_4_7_0_clk clknet_4_7_0_clk VPWR clknet_0_clk VGND clkbuf_4_7_0_clk/a_27_118#
+ sg13g2_buf_8
X_499_ _036_ VPWR _283_ net92 VGND _499_/a_209_168# _499_/a_177_436# _499_/a_380_412#
+ _499_/a_474_130# sg13g2_xor2_1
X_422_ VPWR _240_ _170_ net32 _169_ VGND _422_/a_146_122# _422_/a_248_122# sg13g2_nand3_1
XFILLER_6_7 VPWR VGND sg13g2_decap_8
X_353_ VPWR _186_ _183_ _184_ VGND net108 _185_ _353_/a_350_122# _353_/a_146_122#
+ _353_/a_248_122# sg13g2_nand4_1
Xinput8 tx_data[5] net8 VPWR VGND input8/a_40_152# sg13g2_buf_1
XFILLER_27_103 VPWR VGND sg13g2_decap_8
XFILLER_19_16 VPWR VGND sg13g2_decap_8
X_336_ _170_ rx_inst.state\[2\] VGND VPWR sg13g2_inv_1
X_405_ VGND net51 _224_ net122 VPWR _405_/a_27_156# _405_/a_229_118# sg13g2_nand2b_1
XFILLER_2_85 VPWR VGND sg13g2_decap_8
XFILLER_28_0 VPWR VGND sg13g2_decap_8
X_319_ _154_ net126 VGND VPWR sg13g2_inv_1
Xinput11 tx_start net11 VPWR VGND input11/a_40_152# sg13g2_buf_1
X_670_ VPWR net123 rx_inst.state\[3\] clknet_4_9_0_clk VGND _083_ _670_/a_2002_114#
+ _670_/a_741_93# _670_/a_612_127# _670_/a_2250_412# _670_/a_1840_334# _670_/a_1785_429#
+ _670_/a_843_236# _670_/a_132_114# _670_/a_681_505# _670_/a_38_114# _670_/a_324_432#
+ _670_/a_1583_191# _670_/a_1489_191# _670_/a_550_127# _670_/a_298_337# sg13g2_dfrbpq_1
XFILLER_11_164 VPWR VGND sg13g2_decap_8
X_584_ _071_ net41 VGND VPWR sg13g2_inv_1
X_653_ VPWR _143_ tx_inst.bit_index\[2\] clknet_4_4_0_clk VGND _064_ _653_/a_2002_114#
+ _653_/a_741_93# _653_/a_612_127# _653_/a_2250_412# _653_/a_1840_334# _653_/a_1785_429#
+ _653_/a_843_236# _653_/a_132_114# _653_/a_681_505# _653_/a_38_114# _653_/a_324_432#
+ _653_/a_1583_191# _653_/a_1489_191# _653_/a_550_127# _653_/a_298_337# sg13g2_dfrbpq_1
X_567_ _054_ net47 VGND VPWR sg13g2_inv_1
X_636_ VPWR net74 net16 clknet_4_13_0_clk VGND _047_ _636_/a_2002_114# _636_/a_741_93#
+ _636_/a_612_127# _636_/a_2250_412# _636_/a_1840_334# _636_/a_1785_429# _636_/a_843_236#
+ _636_/a_132_114# _636_/a_681_505# _636_/a_38_114# _636_/a_324_432# _636_/a_1583_191#
+ _636_/a_1489_191# _636_/a_550_127# _636_/a_298_337# sg13g2_dfrbpq_1
XFILLER_5_96 VPWR VGND sg13g2_decap_8
X_498_ net29 _035_ _283_ net153 VPWR VGND _498_/a_165_412# _498_/a_279_412# sg13g2_nor3_1
X_705_ VPWR _152_ net22 clknet_4_7_0_clk VGND _118_ _705_/a_2002_114# _705_/a_741_93#
+ _705_/a_612_127# _705_/a_2250_412# _705_/a_1840_334# _705_/a_1785_429# _705_/a_843_236#
+ _705_/a_132_114# _705_/a_681_505# _705_/a_38_114# _705_/a_324_432# _705_/a_1583_191#
+ _705_/a_1489_191# _705_/a_550_127# _705_/a_298_337# sg13g2_dfrbpq_1
XFILLER_10_0 VPWR VGND sg13g2_decap_8
X_421_ VGND VPWR net31 _230_ _239_ net37 _237_ _421_/a_252_412# _421_/a_354_412# _421_/a_150_412#
+ sg13g2_nor4_1
X_619_ _108_ net44 VGND VPWR sg13g2_inv_1
Xinput9 tx_data[6] net9 VPWR VGND input9/a_40_152# sg13g2_buf_1
XFILLER_5_222 VPWR VGND sg13g2_decap_4
X_352_ baud_inst.counter\[6\] baud_inst.counter\[7\] VPWR _185_ VGND _352_/a_268_412#
+ _352_/a_46_156# sg13g2_nor2b_1
XFILLER_19_39 VPWR VGND sg13g2_decap_4
X_404_ net51 _041_ VPWR _223_ VGND _404_/a_268_412# _404_/a_46_156# sg13g2_nor2b_1
Xclkbuf_4_6_0_clk clknet_4_6_0_clk VPWR clknet_0_clk VGND clkbuf_4_6_0_clk/a_27_118#
+ sg13g2_buf_8
X_335_ _169_ rx_inst.state\[3\] VGND VPWR sg13g2_inv_1
XFILLER_17_192 VPWR VGND sg13g2_decap_8
X_318_ _153_ net118 VGND VPWR sg13g2_inv_1
XFILLER_14_195 VPWR VGND sg13g2_decap_8
XFILLER_20_187 VPWR VGND sg13g2_decap_8
XFILLER_27_28 VPWR VGND sg13g2_decap_8
X_583_ _070_ net41 VGND VPWR sg13g2_inv_1
X_652_ VPWR _142_ tx_inst.bit_index\[1\] clknet_4_3_0_clk VGND _063_ _652_/a_2002_114#
+ _652_/a_741_93# _652_/a_612_127# _652_/a_2250_412# _652_/a_1840_334# _652_/a_1785_429#
+ _652_/a_843_236# _652_/a_132_114# _652_/a_681_505# _652_/a_38_114# _652_/a_324_432#
+ _652_/a_1583_191# _652_/a_1489_191# _652_/a_550_127# _652_/a_298_337# sg13g2_dfrbpq_1
XFILLER_28_93 VPWR VGND sg13g2_decap_8
X_635_ VPWR net85 net15 clknet_4_13_0_clk VGND _046_ _635_/a_2002_114# _635_/a_741_93#
+ _635_/a_612_127# _635_/a_2250_412# _635_/a_1840_334# _635_/a_1785_429# _635_/a_843_236#
+ _635_/a_132_114# _635_/a_681_505# _635_/a_38_114# _635_/a_324_432# _635_/a_1583_191#
+ _635_/a_1489_191# _635_/a_550_127# _635_/a_298_337# sg13g2_dfrbpq_1
X_566_ _053_ net44 VGND VPWR sg13g2_inv_1
X_704_ VPWR net50 net23 clknet_4_7_0_clk VGND _117_ _704_/a_2002_114# _704_/a_741_93#
+ _704_/a_612_127# _704_/a_2250_412# _704_/a_1840_334# _704_/a_1785_429# _704_/a_843_236#
+ _704_/a_132_114# _704_/a_681_505# _704_/a_38_114# _704_/a_324_432# _704_/a_1583_191#
+ _704_/a_1489_191# _704_/a_550_127# _704_/a_298_337# sg13g2_dfrbpq_1
X_497_ net152 VPWR _284_ VGND _280_ _497_/a_170_412# sg13g2_nor2_1
X_420_ VPWR _238_ net32 net24 VGND net35 _236_ _420_/a_350_122# _420_/a_146_122# _420_/a_248_122#
+ sg13g2_nand4_1
XFILLER_14_40 VPWR VGND sg13g2_decap_4
X_351_ baud_inst.counter\[4\] baud_inst.counter\[5\] VPWR _184_ VGND _351_/a_268_412#
+ _351_/a_46_156# sg13g2_nor2b_1
X_618_ _107_ net45 VGND VPWR sg13g2_inv_1
X_549_ VPWR VGND _311_ _165_ _313_ _027_ _549_/a_155_412# _549_/a_257_140# sg13g2_a21oi_1
X_334_ _168_ net62 VGND VPWR sg13g2_inv_1
XFILLER_2_204 VPWR VGND sg13g2_decap_4
X_403_ VGND VPWR _141_ _222_ _217_ net56 _403_/a_22_110# _403_/a_120_432# sg13g2_o21ai_1
XFILLER_24_119 VPWR VGND sg13g2_decap_8
X_317_ net21 _042_ VGND VPWR sg13g2_inv_1
XFILLER_0_0 VPWR VGND sg13g2_decap_8
Xclkbuf_4_5_0_clk clknet_4_5_0_clk VPWR clknet_0_clk VGND clkbuf_4_5_0_clk/a_27_118#
+ sg13g2_buf_8
X_651_ VPWR net57 tx_inst.bit_index\[0\] clknet_4_6_0_clk VGND _062_ _651_/a_2002_114#
+ _651_/a_741_93# _651_/a_612_127# _651_/a_2250_412# _651_/a_1840_334# _651_/a_1785_429#
+ _651_/a_843_236# _651_/a_132_114# _651_/a_681_505# _651_/a_38_114# _651_/a_324_432#
+ _651_/a_1583_191# _651_/a_1489_191# _651_/a_550_127# _651_/a_298_337# sg13g2_dfrbpq_1
X_582_ _069_ net41 VGND VPWR sg13g2_inv_1
XFILLER_3_173 VPWR VGND sg13g2_decap_4
X_634_ VPWR net83 net14 clknet_4_15_0_clk VGND _045_ _634_/a_2002_114# _634_/a_741_93#
+ _634_/a_612_127# _634_/a_2250_412# _634_/a_1840_334# _634_/a_1785_429# _634_/a_843_236#
+ _634_/a_132_114# _634_/a_681_505# _634_/a_38_114# _634_/a_324_432# _634_/a_1583_191#
+ _634_/a_1489_191# _634_/a_550_127# _634_/a_298_337# sg13g2_dfrbpq_1
X_703_ VPWR net59 baud_inst.counter\[31\] clknet_4_11_0_clk VGND _116_ _703_/a_2002_114#
+ _703_/a_741_93# _703_/a_612_127# _703_/a_2250_412# _703_/a_1840_334# _703_/a_1785_429#
+ _703_/a_843_236# _703_/a_132_114# _703_/a_681_505# _703_/a_38_114# _703_/a_324_432#
+ _703_/a_1583_191# _703_/a_1489_191# _703_/a_550_127# _703_/a_298_337# sg13g2_dfrbpq_1
X_565_ _052_ net44 VGND VPWR sg13g2_inv_1
XFILLER_5_21 VPWR VGND sg13g2_decap_8
X_496_ _182_ VPWR _283_ VGND _282_ _496_/a_170_412# sg13g2_nor2_1
X_350_ baud_inst.counter\[9\] _183_ baud_inst.counter\[8\] baud_inst.counter\[10\]
+ VPWR VGND _350_/a_165_412# _350_/a_279_412# sg13g2_nor3_1
XFILLER_27_117 VPWR VGND sg13g2_decap_8
X_617_ _106_ net45 VGND VPWR sg13g2_inv_1
X_548_ _313_ _307_ VPWR VGND _312_ _296_ _548_/a_272_160# _548_/a_170_160# _548_/a_76_160#
+ sg13g2_and3_1
X_479_ VGND VPWR _006_ _275_ net27 _171_ _479_/a_22_110# _479_/a_120_432# sg13g2_o21ai_1
XFILLER_4_7 VPWR VGND sg13g2_decap_8
XFILLER_26_161 VPWR VGND sg13g2_decap_8
X_333_ _167_ net37 VGND VPWR sg13g2_inv_1
X_402_ _222_ VPWR net34 VGND _216_ _402_/a_154_118# sg13g2_nand2_1
XFILLER_11_75 VPWR VGND sg13g2_decap_4
XFILLER_20_156 VPWR VGND sg13g2_decap_8
XFILLER_26_0 VPWR VGND sg13g2_decap_8
X_650_ VPWR net119 rx_inst.data_reg\[7\] clknet_4_13_0_clk VGND _061_ _650_/a_2002_114#
+ _650_/a_741_93# _650_/a_612_127# _650_/a_2250_412# _650_/a_1840_334# _650_/a_1785_429#
+ _650_/a_843_236# _650_/a_132_114# _650_/a_681_505# _650_/a_38_114# _650_/a_324_432#
+ _650_/a_1583_191# _650_/a_1489_191# _650_/a_550_127# _650_/a_298_337# sg13g2_dfrbpq_1
XFILLER_3_185 VPWR VGND sg13g2_decap_8
X_581_ _068_ net41 VGND VPWR sg13g2_inv_1
Xclkbuf_4_4_0_clk clknet_4_4_0_clk VPWR clknet_0_clk VGND clkbuf_4_4_0_clk/a_27_118#
+ sg13g2_buf_8
X_633_ VPWR net78 net13 clknet_4_14_0_clk VGND _044_ _633_/a_2002_114# _633_/a_741_93#
+ _633_/a_612_127# _633_/a_2250_412# _633_/a_1840_334# _633_/a_1785_429# _633_/a_843_236#
+ _633_/a_132_114# _633_/a_681_505# _633_/a_38_114# _633_/a_324_432# _633_/a_1583_191#
+ _633_/a_1489_191# _633_/a_550_127# _633_/a_298_337# sg13g2_dfrbpq_1
X_702_ VPWR net68 baud_inst.counter\[30\] clknet_4_11_0_clk VGND _115_ _702_/a_2002_114#
+ _702_/a_741_93# _702_/a_612_127# _702_/a_2250_412# _702_/a_1840_334# _702_/a_1785_429#
+ _702_/a_843_236# _702_/a_132_114# _702_/a_681_505# _702_/a_38_114# _702_/a_324_432#
+ _702_/a_1583_191# _702_/a_1489_191# _702_/a_550_127# _702_/a_298_337# sg13g2_dfrbpq_1
X_564_ _051_ net45 VGND VPWR sg13g2_inv_1
X_495_ _282_ VPWR baud_inst.counter\[4\] VGND net152 _495_/a_154_118# sg13g2_nand2_1
X_547_ _312_ baud_inst.counter\[24\] baud_inst.counter\[25\] VPWR VGND net113 net99
+ _547_/a_277_118# _547_/a_379_118# _547_/a_175_118# _547_/a_81_118# sg13g2_and4_1
X_616_ _105_ net44 VGND VPWR sg13g2_inv_1
X_478_ VGND net54 _275_ net11 VPWR _478_/a_27_156# _478_/a_229_118# sg13g2_nand2b_1
X_401_ VGND VPWR _142_ _220_ _221_ _217_ _401_/a_22_110# _401_/a_120_432# sg13g2_o21ai_1
X_332_ _166_ net146 VGND VPWR sg13g2_inv_1
XFILLER_23_176 VPWR VGND sg13g2_decap_8
XFILLER_23_154 VPWR VGND sg13g2_decap_4
XFILLER_11_21 VPWR VGND sg13g2_decap_8
XFILLER_11_157 VPWR VGND sg13g2_decap_8
XFILLER_7_117 VPWR VGND sg13g2_decap_4
XFILLER_7_139 VPWR VGND sg13g2_decap_8
XFILLER_19_0 VPWR VGND sg13g2_decap_8
X_580_ _067_ net41 VGND VPWR sg13g2_inv_1
X_701_ VPWR net107 baud_inst.counter\[29\] clknet_4_10_0_clk VGND _114_ _701_/a_2002_114#
+ _701_/a_741_93# _701_/a_612_127# _701_/a_2250_412# _701_/a_1840_334# _701_/a_1785_429#
+ _701_/a_843_236# _701_/a_132_114# _701_/a_681_505# _701_/a_38_114# _701_/a_324_432#
+ _701_/a_1583_191# _701_/a_1489_191# _701_/a_550_127# _701_/a_298_337# sg13g2_dfrbpq_1
X_632_ VPWR net66 net12 clknet_4_13_0_clk VGND _043_ _632_/a_2002_114# _632_/a_741_93#
+ _632_/a_612_127# _632_/a_2250_412# _632_/a_1840_334# _632_/a_1785_429# _632_/a_843_236#
+ _632_/a_132_114# _632_/a_681_505# _632_/a_38_114# _632_/a_324_432# _632_/a_1583_191#
+ _632_/a_1489_191# _632_/a_550_127# _632_/a_298_337# sg13g2_dfrbpq_1
X_563_ _050_ net48 VGND VPWR sg13g2_inv_1
X_494_ net29 _034_ _280_ _281_ VPWR VGND _494_/a_165_412# _494_/a_279_412# sg13g2_nor3_1
XFILLER_5_89 VPWR VGND sg13g2_decap_8
X_546_ _026_ _310_ VPWR net99 VGND _546_/a_155_160# _546_/a_192_429# _546_/a_435_412#
+ _546_/a_341_118# sg13g2_xnor2_1
X_615_ _104_ net44 VGND VPWR sg13g2_inv_1
X_477_ VGND VPWR _007_ net169 net27 _166_ _477_/a_22_110# _477_/a_120_432# sg13g2_o21ai_1
Xclkbuf_4_3_0_clk clknet_4_3_0_clk VPWR clknet_0_clk VGND clkbuf_4_3_0_clk/a_27_118#
+ sg13g2_buf_8
X_331_ _165_ net113 VGND VPWR sg13g2_inv_1
X_400_ _221_ net34 VPWR net183 VGND _400_/a_155_160# _400_/a_192_429# _400_/a_435_412#
+ _400_/a_341_118# sg13g2_xnor2_1
XFILLER_17_185 VPWR VGND sg13g2_decap_8
X_529_ _302_ VGND VPWR _301_ _296_ _529_/a_139_160# _529_/a_45_160# sg13g2_and2_1
XFILLER_23_100 VPWR VGND sg13g2_decap_4
XFILLER_17_87 VPWR VGND sg13g2_decap_8
X_700_ VPWR net134 baud_inst.counter\[28\] clknet_4_11_0_clk VGND _113_ _700_/a_2002_114#
+ _700_/a_741_93# _700_/a_612_127# _700_/a_2250_412# _700_/a_1840_334# _700_/a_1785_429#
+ _700_/a_843_236# _700_/a_132_114# _700_/a_681_505# _700_/a_38_114# _700_/a_324_432#
+ _700_/a_1583_191# _700_/a_1489_191# _700_/a_550_127# _700_/a_298_337# sg13g2_dfrbpq_1
XFILLER_28_42 VPWR VGND sg13g2_decap_8
X_562_ _049_ net47 VGND VPWR sg13g2_inv_1
X_631_ _121_ net43 VGND VPWR sg13g2_inv_1
X_493_ _281_ VGND VPWR _182_ _162_ _493_/a_139_160# _493_/a_45_160# sg13g2_and2_1
XFILLER_29_194 VPWR VGND sg13g2_decap_4
XFILLER_29_161 VPWR VGND sg13g2_decap_4
X_545_ VPWR _311_ baud_inst.counter\[24\] net99 VGND baud_inst.counter\[25\] _308_
+ _545_/a_350_122# _545_/a_146_122# _545_/a_248_122# sg13g2_nand4_1
X_614_ _103_ net44 VGND VPWR sg13g2_inv_1
X_476_ VPWR _274_ net27 _195_ net168 VGND _476_/a_146_122# _476_/a_248_122# sg13g2_nand3_1
XFILLER_26_120 VPWR VGND sg13g2_decap_8
XFILLER_25_21 VPWR VGND sg13g2_decap_4
X_330_ _164_ net103 VGND VPWR sg13g2_inv_1
X_528_ _301_ baud_inst.counter\[16\] net156 VPWR VGND net103 baud_inst.counter\[18\]
+ _528_/a_277_118# _528_/a_379_118# _528_/a_175_118# _528_/a_81_118# sg13g2_and4_1
X_459_ VGND net30 _266_ _000_ VPWR _459_/a_27_156# _459_/a_229_118# sg13g2_nand2b_1
XFILLER_1_230 VPWR VGND sg13g2_decap_8
XFILLER_9_0 VPWR VGND sg13g2_decap_8
Xclkbuf_4_2_0_clk clknet_4_2_0_clk VPWR clknet_0_clk VGND clkbuf_4_2_0_clk/a_27_118#
+ sg13g2_buf_8
XFILLER_2_7 VPWR VGND sg13g2_decap_8
XFILLER_14_178 VPWR VGND sg13g2_decap_8
XFILLER_3_199 VPWR VGND sg13g2_decap_4
XFILLER_24_0 VPWR VGND sg13g2_decap_4
X_561_ _048_ net47 VGND VPWR sg13g2_inv_1
XFILLER_28_21 VPWR VGND sg13g2_decap_8
X_630_ _120_ net43 VGND VPWR sg13g2_inv_1
XFILLER_5_14 VPWR VGND sg13g2_decap_8
X_492_ _162_ VPWR _280_ VGND _182_ _492_/a_170_412# sg13g2_nor2_1
X_613_ _102_ net39 VGND VPWR sg13g2_inv_1
X_544_ net141 _310_ VPWR _025_ VGND _544_/a_268_412# _544_/a_46_156# sg13g2_nor2b_1
X_475_ _166_ VPWR _001_ VGND net26 _475_/a_170_412# sg13g2_nor2_1
XFILLER_17_110 VPWR VGND sg13g2_decap_8
X_527_ _017_ _299_ VPWR net101 VGND _527_/a_155_160# _527_/a_192_429# _527_/a_435_412#
+ _527_/a_341_118# sg13g2_xnor2_1
X_458_ _167_ _000_ _168_ net26 VPWR VGND _458_/a_165_412# _458_/a_279_412# sg13g2_nor3_1
X_389_ net55 net4 VPWR _213_ VGND _389_/a_268_412# _389_/a_46_156# sg13g2_nor2b_1
XFILLER_28_7 VPWR VGND sg13g2_decap_8
Xclkbuf_4_1_0_clk clknet_4_1_0_clk VPWR clknet_0_clk VGND clkbuf_4_1_0_clk/a_27_118#
+ sg13g2_buf_8
XFILLER_3_134 VPWR VGND sg13g2_decap_8
X_560_ _047_ net48 VGND VPWR sg13g2_inv_1
X_491_ _033_ _181_ VPWR net60 VGND _491_/a_155_160# _491_/a_192_429# _491_/a_435_412#
+ _491_/a_341_118# sg13g2_xnor2_1
X_689_ VPWR net158 baud_inst.counter\[17\] clknet_4_2_0_clk VGND _102_ _689_/a_2002_114#
+ _689_/a_741_93# _689_/a_612_127# _689_/a_2250_412# _689_/a_1840_334# _689_/a_1785_429#
+ _689_/a_843_236# _689_/a_132_114# _689_/a_681_505# _689_/a_38_114# _689_/a_324_432#
+ _689_/a_1583_191# _689_/a_1489_191# _689_/a_550_127# _689_/a_298_337# sg13g2_dfrbpq_1
XFILLER_10_7 VPWR VGND sg13g2_decap_8
X_474_ VGND VPWR _122_ net65 _266_ _160_ _474_/a_22_110# _474_/a_120_432# sg13g2_o21ai_1
X_543_ VPWR _310_ baud_inst.counter\[24\] _308_ net140 VGND _543_/a_146_122# _543_/a_248_122#
+ sg13g2_nand3_1
X_612_ _101_ net39 VGND VPWR sg13g2_inv_1
X_526_ VPWR _300_ baud_inst.counter\[16\] net101 VGND baud_inst.counter\[17\] _296_
+ _526_/a_350_122# _526_/a_146_122# _526_/a_248_122# sg13g2_nand4_1
X_457_ VGND VPWR _265_ net80 _264_ net30 _457_/a_22_110# _457_/a_120_432# sg13g2_o21ai_1
X_388_ _212_ _146_ _206_ VPWR VGND net165 _388_/a_59_156# _388_/a_285_412# _388_/a_382_118#
+ _388_/a_496_118# _388_/a_285_118# _388_/a_559_412# sg13g2_mux2_1
XFILLER_11_14 VPWR VGND sg13g2_decap_8
X_509_ VPWR VGND _288_ net97 net108 _290_ _509_/a_155_412# _509_/a_257_140# sg13g2_a21oi_1
XFILLER_3_146 VPWR VGND sg13g2_decap_4
XFILLER_12_201 VPWR VGND sg13g2_decap_8
X_490_ _030_ VGND VPWR _279_ _181_ _490_/a_139_160# _490_/a_45_160# sg13g2_and2_1
X_688_ VPWR net161 baud_inst.counter\[16\] clknet_4_2_0_clk VGND _101_ _688_/a_2002_114#
+ _688_/a_741_93# _688_/a_612_127# _688_/a_2250_412# _688_/a_1840_334# _688_/a_1785_429#
+ _688_/a_843_236# _688_/a_132_114# _688_/a_681_505# _688_/a_38_114# _688_/a_324_432#
+ _688_/a_1583_191# _688_/a_1489_191# _688_/a_550_127# _688_/a_298_337# sg13g2_dfrbpq_1
Xclkbuf_4_0_0_clk clknet_4_0_0_clk VPWR clknet_0_clk VGND clkbuf_4_0_0_clk/a_27_118#
+ sg13g2_buf_8
XFILLER_29_131 VPWR VGND sg13g2_decap_8
X_473_ VGND VPWR _273_ net64 _264_ _240_ _473_/a_22_110# _473_/a_120_432# sg13g2_o21ai_1
X_542_ VPWR VGND _308_ baud_inst.counter\[24\] net140 _309_ _542_/a_155_412# _542_/a_257_140#
+ sg13g2_a21oi_1
X_611_ _100_ net44 VGND VPWR sg13g2_inv_1
XFILLER_4_230 VPWR VGND sg13g2_decap_8
XFILLER_26_134 VPWR VGND sg13g2_decap_8
X_456_ VPWR VGND net28 net37 _168_ _264_ _456_/a_155_412# _456_/a_257_140# sg13g2_a21oi_1
X_525_ net157 _299_ VPWR _016_ VGND _525_/a_268_412# _525_/a_46_156# sg13g2_nor2b_1
X_387_ net55 net5 VPWR _212_ VGND _387_/a_268_412# _387_/a_46_156# sg13g2_nor2b_1
X_439_ VGND VPWR net31 _230_ _253_ net2 _251_ _439_/a_252_412# _439_/a_354_412# _439_/a_150_412#
+ sg13g2_nor4_1
X_508_ _009_ VPWR _288_ net97 VGND _508_/a_209_168# _508_/a_177_436# _508_/a_380_412#
+ _508_/a_474_130# sg13g2_xor2_1
XFILLER_7_0 VPWR VGND sg13g2_decap_8
XFILLER_0_7 VPWR VGND sg13g2_decap_8
XFILLER_28_35 VPWR VGND sg13g2_decap_8
X_687_ VPWR net89 baud_inst.counter\[15\] clknet_4_8_0_clk VGND _100_ _687_/a_2002_114#
+ _687_/a_741_93# _687_/a_612_127# _687_/a_2250_412# _687_/a_1840_334# _687_/a_1785_429#
+ _687_/a_843_236# _687_/a_132_114# _687_/a_681_505# _687_/a_38_114# _687_/a_324_432#
+ _687_/a_1583_191# _687_/a_1489_191# _687_/a_550_127# _687_/a_298_337# sg13g2_dfrbpq_1
XFILLER_5_28 VPWR VGND sg13g2_decap_4
XFILLER_29_154 VPWR VGND sg13g2_decap_8
XFILLER_29_110 VPWR VGND sg13g2_decap_8
X_472_ VGND VPWR _123_ _272_ _266_ _159_ _472_/a_22_110# _472_/a_120_432# sg13g2_o21ai_1
X_541_ _024_ VPWR _308_ net162 VGND _541_/a_209_168# _541_/a_177_436# _541_/a_380_412#
+ _541_/a_474_130# sg13g2_xor2_1
X_610_ _099_ net46 VGND VPWR sg13g2_inv_1
XFILLER_26_168 VPWR VGND sg13g2_decap_4
XFILLER_26_113 VPWR VGND sg13g2_decap_8
XFILLER_1_223 VPWR VGND sg13g2_decap_8
X_455_ VPWR VGND net24 net52 _263_ _130_ _455_/a_155_412# _455_/a_257_140# sg13g2_a21oi_1
XFILLER_17_124 VPWR VGND sg13g2_decap_8
X_524_ VPWR _299_ baud_inst.counter\[16\] _296_ net156 VGND _524_/a_146_122# _524_/a_248_122#
+ sg13g2_nand3_1
X_386_ _211_ _147_ _206_ VPWR VGND net145 _386_/a_59_156# _386_/a_285_412# _386_/a_382_118#
+ _386_/a_496_118# _386_/a_285_118# _386_/a_559_412# sg13g2_mux2_1
XFILLER_22_171 VPWR VGND sg13g2_decap_4
XFILLER_14_116 VPWR VGND sg13g2_decap_8
X_438_ VPWR _252_ net32 net24 VGND _161_ _236_ _438_/a_350_122# _438_/a_146_122# _438_/a_248_122#
+ sg13g2_nand4_1
X_369_ VPWR _202_ net172 net27 net179 VGND _369_/a_146_122# _369_/a_248_122# sg13g2_nand3_1
X_507_ _288_ VPWR _039_ VGND net116 _507_/a_170_412# sg13g2_nor2_1
XFILLER_26_7 VPWR VGND sg13g2_decap_8
XFILLER_28_14 VPWR VGND sg13g2_decap_8
XFILLER_0_73 VPWR VGND sg13g2_decap_8
XFILLER_9_60 VPWR VGND sg13g2_decap_4
X_686_ VPWR net91 baud_inst.counter\[14\] clknet_4_9_0_clk VGND _099_ _686_/a_2002_114#
+ _686_/a_741_93# _686_/a_612_127# _686_/a_2250_412# _686_/a_1840_334# _686_/a_1785_429#
+ _686_/a_843_236# _686_/a_132_114# _686_/a_681_505# _686_/a_38_114# _686_/a_324_432#
+ _686_/a_1583_191# _686_/a_1489_191# _686_/a_550_127# _686_/a_298_337# sg13g2_dfrbpq_1
X_471_ VGND VPWR _272_ net77 _264_ net30 _471_/a_22_110# _471_/a_120_432# sg13g2_o21ai_1
X_540_ _308_ VGND VPWR _307_ _296_ _540_/a_139_160# _540_/a_45_160# sg13g2_and2_1
X_669_ VPWR net167 rx_inst.state\[2\] clknet_4_9_0_clk VGND _082_ _669_/a_2002_114#
+ _669_/a_741_93# _669_/a_612_127# _669_/a_2250_412# _669_/a_1840_334# _669_/a_1785_429#
+ _669_/a_843_236# _669_/a_132_114# _669_/a_681_505# _669_/a_38_114# _669_/a_324_432#
+ _669_/a_1583_191# _669_/a_1489_191# _669_/a_550_127# _669_/a_298_337# sg13g2_dfrbpq_1
Xhold90 baud_inst.counter\[14\] VPWR VGND net90 hold90/a_56_118# hold90/a_326_118#
+ hold90/a_438_182# sg13g2_dlygate4sd3_1
XFILLER_6_94 VPWR VGND sg13g2_decap_4
XFILLER_25_191 VPWR VGND sg13g2_decap_8
X_454_ VPWR VGND net24 rx_inst.state\[2\] net36 _263_ _454_/a_155_412# _454_/a_257_140#
+ sg13g2_a21oi_1
X_523_ VPWR VGND _296_ baud_inst.counter\[16\] net156 _298_ _523_/a_155_412# _523_/a_257_140#
+ sg13g2_a21oi_1
X_385_ net55 net6 VPWR _211_ VGND _385_/a_268_412# _385_/a_46_156# sg13g2_nor2b_1
XFILLER_11_28 VPWR VGND sg13g2_decap_4
X_437_ _251_ VPWR _161_ VGND _236_ _437_/a_154_118# sg13g2_nand2_1
X_368_ VPWR VGND _200_ net55 _199_ _201_ _368_/a_155_412# _368_/a_257_140# sg13g2_a21oi_1
X_506_ VPWR VGND _287_ baud_inst.counter\[8\] net115 _289_ _506_/a_155_412# _506_/a_257_140#
+ sg13g2_a21oi_1
XFILLER_9_143 VPWR VGND sg13g2_decap_4
XFILLER_10_131 VPWR VGND sg13g2_decap_8
XFILLER_3_116 VPWR VGND sg13g2_decap_8
XFILLER_3_127 VPWR VGND sg13g2_decap_8
X_685_ VPWR net130 baud_inst.counter\[13\] clknet_4_9_0_clk VGND _098_ _685_/a_2002_114#
+ _685_/a_741_93# _685_/a_612_127# _685_/a_2250_412# _685_/a_1840_334# _685_/a_1785_429#
+ _685_/a_843_236# _685_/a_132_114# _685_/a_681_505# _685_/a_38_114# _685_/a_324_432#
+ _685_/a_1583_191# _685_/a_1489_191# _685_/a_550_127# _685_/a_298_337# sg13g2_dfrbpq_1
X_470_ VGND VPWR _124_ _271_ _266_ _158_ _470_/a_22_110# _470_/a_120_432# sg13g2_o21ai_1
Xhold91 _013_ VPWR VGND net91 hold91/a_56_118# hold91/a_326_118# hold91/a_438_182#
+ sg13g2_dlygate4sd3_1
Xhold80 net19 VPWR VGND net80 hold80/a_56_118# hold80/a_326_118# hold80/a_438_182#
+ sg13g2_dlygate4sd3_1
X_668_ VPWR _000_ rx_inst.state\[1\] clknet_4_6_0_clk VGND _081_ _668_/a_2002_114#
+ _668_/a_741_93# _668_/a_612_127# _668_/a_2250_412# _668_/a_1840_334# _668_/a_1785_429#
+ _668_/a_843_236# _668_/a_132_114# _668_/a_681_505# _668_/a_38_114# _668_/a_324_432#
+ _668_/a_1583_191# _668_/a_1489_191# _668_/a_550_127# _668_/a_298_337# sg13g2_dfrbpq_1
X_599_ _088_ net38 VGND VPWR sg13g2_inv_1
X_453_ _261_ VPWR _131_ VGND _262_ _453_/a_170_412# sg13g2_nor2_1
X_522_ _015_ VPWR _296_ net160 VGND _522_/a_209_168# _522_/a_177_436# _522_/a_380_412#
+ _522_/a_474_130# sg13g2_xor2_1
X_384_ _210_ _148_ _206_ VPWR VGND net171 _384_/a_59_156# _384_/a_285_412# _384_/a_382_118#
+ _384_/a_496_118# _384_/a_285_118# _384_/a_559_412# sg13g2_mux2_1
X_436_ _241_ _136_ _157_ _250_ _249_ VPWR _167_ VGND _436_/a_142_412# _436_/a_244_140#
+ _436_/a_550_140# _436_/a_244_412# sg13g2_a221oi_1
X_367_ net172 VPWR _200_ VGND net168 _367_/a_170_412# sg13g2_nor2_1
X_505_ _288_ baud_inst.counter\[8\] VPWR VGND _287_ net115 _505_/a_272_160# _505_/a_170_160#
+ _505_/a_76_160# sg13g2_and3_1
XFILLER_5_0 VPWR VGND sg13g2_decap_8
X_419_ _237_ VPWR net35 VGND _236_ _419_/a_154_118# sg13g2_nand2_1
XFILLER_17_28 VPWR VGND sg13g2_decap_8
XFILLER_2_172 VPWR VGND sg13g2_decap_8
XFILLER_2_194 VPWR VGND sg13g2_decap_8
XFILLER_28_49 VPWR VGND sg13g2_decap_4
Xclkbuf_4_15_0_clk clknet_4_15_0_clk VPWR clknet_0_clk VGND clkbuf_4_15_0_clk/a_27_118#
+ sg13g2_buf_8
X_684_ VPWR net178 baud_inst.counter\[12\] clknet_4_2_0_clk VGND _097_ _684_/a_2002_114#
+ _684_/a_741_93# _684_/a_612_127# _684_/a_2250_412# _684_/a_1840_334# _684_/a_1785_429#
+ _684_/a_843_236# _684_/a_132_114# _684_/a_681_505# _684_/a_38_114# _684_/a_324_432#
+ _684_/a_1583_191# _684_/a_1489_191# _684_/a_550_127# _684_/a_298_337# sg13g2_dfrbpq_1
XFILLER_29_124 VPWR VGND sg13g2_decap_8
Xhold70 _128_ VPWR VGND net70 hold70/a_56_118# hold70/a_326_118# hold70/a_438_182#
+ sg13g2_dlygate4sd3_1
XFILLER_20_50 VPWR VGND sg13g2_decap_8
Xhold81 _129_ VPWR VGND net81 hold81/a_56_118# hold81/a_326_118# hold81/a_438_182#
+ sg13g2_dlygate4sd3_1
XFILLER_4_223 VPWR VGND sg13g2_decap_4
Xhold92 baud_inst.counter\[6\] VPWR VGND net92 hold92/a_56_118# hold92/a_326_118#
+ hold92/a_438_182# sg13g2_dlygate4sd3_1
XFILLER_26_127 VPWR VGND sg13g2_decap_8
X_667_ VPWR net63 _041_ clknet_4_6_0_clk VGND _080_ _667_/a_2002_114# _667_/a_741_93#
+ _667_/a_612_127# _667_/a_2250_412# _667_/a_1840_334# _667_/a_1785_429# _667_/a_843_236#
+ _667_/a_132_114# _667_/a_681_505# _667_/a_38_114# _667_/a_324_432# _667_/a_1583_191#
+ _667_/a_1489_191# _667_/a_550_127# _667_/a_298_337# sg13g2_dfrbpq_1
X_598_ _087_ net38 VGND VPWR sg13g2_inv_1
X_452_ VPWR VGND _225_ rx_inst.state\[2\] _230_ _262_ _452_/a_155_412# _452_/a_257_140#
+ sg13g2_a21oi_1
X_521_ _296_ VPWR _014_ VGND net88 _521_/a_170_412# sg13g2_nor2_1
X_383_ net55 net7 VPWR _210_ VGND _383_/a_268_412# _383_/a_46_156# sg13g2_nor2b_1
XFILLER_9_7 VPWR VGND sg13g2_decap_8
X_435_ _250_ _225_ _230_ VPWR VGND net35 net31 _435_/a_72_436# _435_/a_268_436# _435_/a_411_436#
+ _435_/a_166_436# sg13g2_or4_1
X_504_ _038_ VPWR _287_ net135 VGND _504_/a_209_168# _504_/a_177_436# _504_/a_380_412#
+ _504_/a_474_130# sg13g2_xor2_1
X_366_ net55 VPWR _199_ VGND net11 _366_/a_170_412# sg13g2_nor2_1
X_418_ net36 rx_inst.bit_index\[1\] VPWR _236_ VGND _418_/a_268_412# _418_/a_46_156#
+ sg13g2_nor2b_1
X_349_ VPWR _182_ net86 net60 VGND net79 net181 _349_/a_350_122# _349_/a_146_122#
+ _349_/a_248_122# sg13g2_nand4_1
XFILLER_0_21 VPWR VGND sg13g2_decap_8
XFILLER_28_28 VPWR VGND sg13g2_decap_8
X_683_ VPWR net110 baud_inst.counter\[11\] clknet_4_2_0_clk VGND _096_ _683_/a_2002_114#
+ _683_/a_741_93# _683_/a_612_127# _683_/a_2250_412# _683_/a_1840_334# _683_/a_1785_429#
+ _683_/a_843_236# _683_/a_132_114# _683_/a_681_505# _683_/a_38_114# _683_/a_324_432#
+ _683_/a_1583_191# _683_/a_1489_191# _683_/a_550_127# _683_/a_298_337# sg13g2_dfrbpq_1
XFILLER_29_103 VPWR VGND sg13g2_decap_8
Xhold82 net14 VPWR VGND net82 hold82/a_56_118# hold82/a_326_118# hold82/a_438_182#
+ sg13g2_dlygate4sd3_1
XFILLER_29_82 VPWR VGND sg13g2_decap_8
Xhold71 net17 VPWR VGND net71 hold71/a_56_118# hold71/a_326_118# hold71/a_438_182#
+ sg13g2_dlygate4sd3_1
Xclkbuf_4_14_0_clk clknet_4_14_0_clk VPWR clknet_0_clk VGND clkbuf_4_14_0_clk/a_27_118#
+ sg13g2_buf_8
Xhold60 baud_inst.counter\[3\] VPWR VGND net60 hold60/a_56_118# hold60/a_326_118#
+ hold60/a_438_182# sg13g2_dlygate4sd3_1
X_597_ _086_ net40 VGND VPWR sg13g2_inv_1
Xhold93 _036_ VPWR VGND net93 hold93/a_56_118# hold93/a_326_118# hold93/a_438_182#
+ sg13g2_dlygate4sd3_1
X_666_ VPWR _007_ tx_inst.state\[4\] clknet_4_6_0_clk VGND _078_ _666_/a_2002_114#
+ _666_/a_741_93# _666_/a_612_127# _666_/a_2250_412# _666_/a_1840_334# _666_/a_1785_429#
+ _666_/a_843_236# _666_/a_132_114# _666_/a_681_505# _666_/a_38_114# _666_/a_324_432#
+ _666_/a_1583_191# _666_/a_1489_191# _666_/a_550_127# _666_/a_298_337# sg13g2_dfrbpq_1
XFILLER_26_106 VPWR VGND sg13g2_decap_8
XFILLER_17_117 VPWR VGND sg13g2_decap_8
X_520_ VPWR VGND _294_ baud_inst.counter\[14\] net87 _297_ _520_/a_155_412# _520_/a_257_140#
+ sg13g2_a21oi_1
XFILLER_1_216 VPWR VGND sg13g2_decap_8
X_649_ VPWR net127 rx_inst.data_reg\[6\] clknet_4_15_0_clk VGND _060_ _649_/a_2002_114#
+ _649_/a_741_93# _649_/a_612_127# _649_/a_2250_412# _649_/a_1840_334# _649_/a_1785_429#
+ _649_/a_843_236# _649_/a_132_114# _649_/a_681_505# _649_/a_38_114# _649_/a_324_432#
+ _649_/a_1583_191# _649_/a_1489_191# _649_/a_550_127# _649_/a_298_337# sg13g2_dfrbpq_1
X_451_ VPWR VGND net24 net36 net175 _261_ _451_/a_155_412# _451_/a_257_140# sg13g2_a21oi_1
X_382_ _209_ _149_ _206_ VPWR VGND net137 _382_/a_59_156# _382_/a_285_412# _382_/a_382_118#
+ _382_/a_496_118# _382_/a_285_118# _382_/a_559_412# sg13g2_mux2_1
XFILLER_14_109 VPWR VGND sg13g2_decap_8
XFILLER_22_164 VPWR VGND sg13g2_decap_8
X_434_ VGND VPWR net31 _225_ _249_ net35 _230_ _434_/a_252_412# _434_/a_354_412# _434_/a_150_412#
+ sg13g2_nor4_1
X_503_ net29 _037_ net95 _287_ VPWR VGND _503_/a_165_412# _503_/a_279_412# sg13g2_nor3_1
X_365_ VPWR VGND _197_ net27 _192_ _198_ _365_/a_155_412# _365_/a_257_140# sg13g2_a21oi_1
X_417_ VGND VPWR _140_ _235_ _233_ _153_ _417_/a_22_110# _417_/a_120_432# sg13g2_o21ai_1
X_348_ VPWR _181_ net86 net181 net79 VGND _348_/a_146_122# _348_/a_248_122# sg13g2_nand3_1
XFILLER_5_160 VPWR VGND sg13g2_decap_4
XFILLER_0_66 VPWR VGND sg13g2_decap_8
XFILLER_18_51 VPWR VGND sg13g2_decap_8
X_682_ VPWR net98 baud_inst.counter\[10\] clknet_4_2_0_clk VGND _095_ _682_/a_2002_114#
+ _682_/a_741_93# _682_/a_612_127# _682_/a_2250_412# _682_/a_1840_334# _682_/a_1785_429#
+ _682_/a_843_236# _682_/a_132_114# _682_/a_681_505# _682_/a_38_114# _682_/a_324_432#
+ _682_/a_1583_191# _682_/a_1489_191# _682_/a_550_127# _682_/a_298_337# sg13g2_dfrbpq_1
Xhold83 _124_ VPWR VGND net83 hold83/a_56_118# hold83/a_326_118# hold83/a_438_182#
+ sg13g2_dlygate4sd3_1
Xhold72 _127_ VPWR VGND net72 hold72/a_56_118# hold72/a_326_118# hold72/a_438_182#
+ sg13g2_dlygate4sd3_1
Xhold50 tx_inst.state\[1\] VPWR VGND net50 hold50/a_56_118# hold50/a_326_118# hold50/a_438_182#
+ sg13g2_dlygate4sd3_1
Xhold61 _033_ VPWR VGND net61 hold61/a_56_118# hold61/a_326_118# hold61/a_438_182#
+ sg13g2_dlygate4sd3_1
X_596_ _085_ net38 VGND VPWR sg13g2_inv_1
Xhold94 baud_inst.counter\[7\] VPWR VGND net94 hold94/a_56_118# hold94/a_326_118#
+ hold94/a_438_182# sg13g2_dlygate4sd3_1
X_665_ VPWR _006_ tx_inst.state\[3\] clknet_4_5_0_clk VGND _077_ _665_/a_2002_114#
+ _665_/a_741_93# _665_/a_612_127# _665_/a_2250_412# _665_/a_1840_334# _665_/a_1785_429#
+ _665_/a_843_236# _665_/a_132_114# _665_/a_681_505# _665_/a_38_114# _665_/a_324_432#
+ _665_/a_1583_191# _665_/a_1489_191# _665_/a_550_127# _665_/a_298_337# sg13g2_dfrbpq_1
X_450_ _132_ net25 VPWR _260_ _227_ VGND _161_ _450_/a_127_436# _450_/a_127_96# _450_/a_398_96#
+ sg13g2_a22oi_1
X_381_ net55 net8 VPWR _209_ VGND _381_/a_268_412# _381_/a_46_156# sg13g2_nor2b_1
X_648_ VPWR net125 rx_inst.data_reg\[5\] clknet_4_14_0_clk VGND _059_ _648_/a_2002_114#
+ _648_/a_741_93# _648_/a_612_127# _648_/a_2250_412# _648_/a_1840_334# _648_/a_1785_429#
+ _648_/a_843_236# _648_/a_132_114# _648_/a_681_505# _648_/a_38_114# _648_/a_324_432#
+ _648_/a_1583_191# _648_/a_1489_191# _648_/a_550_127# _648_/a_298_337# sg13g2_dfrbpq_1
X_579_ _066_ net38 VGND VPWR sg13g2_inv_1
Xclkbuf_4_13_0_clk clknet_4_13_0_clk VPWR clknet_0_clk VGND clkbuf_4_13_0_clk/a_27_118#
+ sg13g2_buf_8
X_433_ _241_ _137_ _156_ _248_ _247_ VPWR _167_ VGND _433_/a_142_412# _433_/a_244_140#
+ _433_/a_550_140# _433_/a_244_412# sg13g2_a221oi_1
X_502_ _182_ _287_ _282_ _286_ VPWR VGND _502_/a_165_412# _502_/a_279_412# sg13g2_nor3_1
X_364_ VPWR VGND _193_ net34 _196_ _197_ _364_/a_155_412# _364_/a_257_140# sg13g2_a21oi_1
XFILLER_10_124 VPWR VGND sg13g2_decap_8
X_347_ VPWR _180_ _178_ _179_ _177_ VGND _347_/a_146_122# _347_/a_248_122# sg13g2_nand3_1
Xhold180 rx_inst.state\[2\] VPWR VGND net180 hold180/a_56_118# hold180/a_326_118#
+ hold180/a_438_182# sg13g2_dlygate4sd3_1
X_416_ VPWR _235_ net32 net25 VGND net37 _234_ _416_/a_350_122# _416_/a_146_122# _416_/a_248_122#
+ sg13g2_nand4_1
XFILLER_12_64 VPWR VGND sg13g2_decap_4
XFILLER_3_0 VPWR VGND sg13g2_decap_8
XFILLER_9_21 VPWR VGND sg13g2_decap_8
X_681_ VPWR net117 baud_inst.counter\[9\] clknet_4_0_0_clk VGND _094_ _681_/a_2002_114#
+ _681_/a_741_93# _681_/a_612_127# _681_/a_2250_412# _681_/a_1840_334# _681_/a_1785_429#
+ _681_/a_843_236# _681_/a_132_114# _681_/a_681_505# _681_/a_38_114# _681_/a_324_432#
+ _681_/a_1583_191# _681_/a_1489_191# _681_/a_550_127# _681_/a_298_337# sg13g2_dfrbpq_1
XFILLER_29_138 VPWR VGND sg13g2_decap_8
Xhold84 net15 VPWR VGND net84 hold84/a_56_118# hold84/a_326_118# hold84/a_438_182#
+ sg13g2_dlygate4sd3_1
Xhold73 net16 VPWR VGND net73 hold73/a_56_118# hold73/a_326_118# hold73/a_438_182#
+ sg13g2_dlygate4sd3_1
Xhold51 rx_inst.state\[1\] VPWR VGND net51 hold51/a_56_118# hold51/a_326_118# hold51/a_438_182#
+ sg13g2_dlygate4sd3_1
Xhold62 rx_inst.state\[4\] VPWR VGND net62 hold62/a_56_118# hold62/a_326_118# hold62/a_438_182#
+ sg13g2_dlygate4sd3_1
X_595_ _084_ net42 VGND VPWR sg13g2_inv_1
X_664_ VPWR _005_ tx_inst.state\[2\] clknet_4_4_0_clk VGND _076_ _664_/a_2002_114#
+ _664_/a_741_93# _664_/a_612_127# _664_/a_2250_412# _664_/a_1840_334# _664_/a_1785_429#
+ _664_/a_843_236# _664_/a_132_114# _664_/a_681_505# _664_/a_38_114# _664_/a_324_432#
+ _664_/a_1583_191# _664_/a_1489_191# _664_/a_550_127# _664_/a_298_337# sg13g2_dfrbpq_1
Xhold95 _285_ VPWR VGND net95 hold95/a_56_118# hold95/a_326_118# hold95/a_438_182#
+ sg13g2_dlygate4sd3_1
X_380_ _208_ _150_ _206_ VPWR VGND net170 _380_/a_59_156# _380_/a_285_412# _380_/a_382_118#
+ _380_/a_496_118# _380_/a_285_118# _380_/a_559_412# sg13g2_mux2_1
X_647_ VPWR net139 rx_inst.data_reg\[4\] clknet_4_12_0_clk VGND _058_ _647_/a_2002_114#
+ _647_/a_741_93# _647_/a_612_127# _647_/a_2250_412# _647_/a_1840_334# _647_/a_1785_429#
+ _647_/a_843_236# _647_/a_132_114# _647_/a_681_505# _647_/a_38_114# _647_/a_324_432#
+ _647_/a_1583_191# _647_/a_1489_191# _647_/a_550_127# _647_/a_298_337# sg13g2_dfrbpq_1
X_578_ _065_ net41 VGND VPWR sg13g2_inv_1
C0 clknet_4_1_0_clk FILLER_2_79/a_40_246# 0
C1 _287_ net38 0.10942f
C2 _200_ FILLER_7_234/a_32_246# 0
C3 net37 _460_/a_120_432# 0
C4 rx_inst.state\[3\] net43 0.79562f
C5 net31 clknet_4_12_0_clk 0.0199f
C6 net124 _649_/a_1583_191# 0
C7 fanout36/a_40_152# _242_ 0
C8 _229_ VPWR 0.08762f
C9 net105 _700_/a_324_432# 0
C10 hold151/a_326_118# FILLER_26_141/a_40_246# 0.00327f
C11 net177 hold177/a_438_182# 0.02178f
C12 baud_inst.counter\[16\] net88 0
C13 _013_ baud_inst.counter\[15\] 0.01051f
C14 _315_ hold106/a_438_182# 0.0366f
C15 _512_/a_165_412# VPWR 0
C16 fanout34/a_40_152# net183 0
C17 _656_/a_38_114# VPWR 0.00298f
C18 _680_/a_38_114# _093_ 0.05769f
C19 net140 _308_ 1.24024f
C20 _178_ hold75/a_326_118# 0.00379f
C21 _697_/a_38_114# _026_ 0
C22 _672_/a_298_337# hold61/a_56_118# 0
C23 _288_ _505_/a_76_160# 0.00654f
C24 _680_/a_741_93# baud_inst.counter\[10\] 0
C25 hold116/a_326_118# hold116/a_438_182# 0
C26 baud_inst.counter\[15\] baud_inst.counter\[14\] 0.19726f
C27 _697_/a_843_236# net142 0
C28 net35 _134_ 0
C29 net46 _686_/a_550_127# 0
C30 _099_ _686_/a_612_127# 0.00285f
C31 FILLER_16_203/a_32_246# _647_/a_1583_191# 0
C32 clkbuf_4_12_0_clk/a_27_118# _241_ 0
C33 net48 net78 0.10071f
C34 _472_/a_120_432# _272_ 0
C35 net55 _210_ 0.12f
C36 hold159/a_56_118# clknet_4_1_0_clk 0
C37 _642_/a_38_114# _697_/a_2250_412# 0
C38 _271_ _124_ 0.25977f
C39 hold99/a_56_118# net99 0.00202f
C40 clkbuf_4_2_0_clk/a_27_118# _290_ 0.01345f
C41 _341_/a_886_118# tx_inst.bit_index\[2\] 0.00833f
C42 clknet_4_4_0_clk net56 0
C43 _226_ _449_/a_27_156# 0.04412f
C44 _446_/a_248_122# _258_ 0
C45 _525_/a_46_156# _296_ 0.00153f
C46 net157 _522_/a_474_130# 0.00262f
C47 _299_ _522_/a_380_412# 0
C48 _225_ hold180/a_56_118# 0
C49 _642_/a_843_236# _131_ 0.00155f
C50 _245_ _244_ 0.05345f
C51 rx_data[0] _632_/a_2250_412# 0.00248f
C52 _248_ hold139/a_56_118# 0
C53 hold63/a_56_118# _374_/a_142_412# 0
C54 output17/a_40_152# rx_data[5] 0
C55 _177_ _180_ 0.14905f
C56 rx_inst.data_reg\[3\] _156_ 0
C57 _671_/a_612_127# _168_ 0.00454f
C58 _057_ _273_ 0
C59 clknet_4_12_0_clk clkbuf_4_15_0_clk/a_27_118# 0.00362f
C60 hold142/a_438_182# hold100/a_438_182# 0
C61 hold110/a_326_118# VPWR 0.00467f
C62 _186_ _683_/a_324_432# 0.00598f
C63 _078_ _666_/a_324_432# 0.01945f
C64 net97 FILLER_12_42/a_32_246# 0
C65 _205_ clknet_0_clk 0.01033f
C66 hold169/a_326_118# net27 0
C67 net39 baud_inst.counter\[16\] 0
C68 _230_ _427_/a_146_122# 0
C69 _695_/a_741_93# VPWR 0.02272f
C70 _510_/a_350_122# _291_ -0
C71 net108 net97 0.55381f
C72 net44 clknet_4_8_0_clk 2.78247f
C73 _024_ _541_/a_474_130# 0
C74 hold85/a_438_182# _125_ 0
C75 hold64/a_438_182# hold66/a_56_118# 0
C76 _679_/a_2250_412# VPWR 0.00684f
C77 clknet_4_13_0_clk VPWR 0.43665f
C78 net119 _647_/a_612_127# 0
C79 hold140/a_56_118# FILLER_20_106/a_32_246# 0.00404f
C80 hold141/a_438_182# _546_/a_192_429# 0
C81 _073_ _665_/a_132_114# 0
C82 _040_ _665_/a_843_236# 0.00135f
C83 _231_ _224_ 0
C84 _267_ clknet_0_clk 0
C85 _500_/a_155_412# clkbuf_4_0_0_clk/a_27_118# 0
C86 _059_ hold127/a_326_118# 0
C87 net181 net86 0.52348f
C88 _293_ _685_/a_38_114# 0.00122f
C89 _129_ _668_/a_1840_334# 0
C90 net77 _648_/a_741_93# 0.00462f
C91 _272_ _648_/a_324_432# 0
C92 hold101/a_326_118# net101 0
C93 net123 FILLER_13_89/a_40_246# 0
C94 FILLER_20_65/a_32_246# baud_inst.counter\[24\] 0.00102f
C95 clknet_0_clk _664_/a_843_236# 0.00108f
C96 net129 _186_ 0
C97 hold132/a_326_118# _232_ 0
C98 _006_ _665_/a_843_236# 0
C99 _195_ _217_ 0.05187f
C100 _275_ _665_/a_681_505# 0
C101 hold109/a_56_118# net29 0
C102 net74 _639_/a_1840_334# 0
C103 _126_ _639_/a_2250_412# 0
C104 net49 _419_/a_154_118# 0
C105 hold166/a_56_118# clknet_4_9_0_clk 0
C106 hold96/a_56_118# VPWR 0.00352f
C107 baud_inst.counter\[12\] _684_/a_1583_191# 0.00588f
C108 _295_ _684_/a_843_236# 0.00106f
C109 hold166/a_438_182# _205_ 0
C110 hold171/a_326_118# _212_ 0.00723f
C111 _006_ _166_ 0
C112 hold143/a_438_182# _240_ 0.00599f
C113 VPWR net65 0.16193f
C114 _307_ _687_/a_741_93# 0
C115 hold148/a_56_118# _692_/a_843_236# 0
C116 net44 _686_/a_1840_334# 0.00196f
C117 baud_inst.counter\[21\] baud_inst.counter\[23\] 0.00508f
C118 _109_ baud_inst.counter\[25\] 0
C119 net26 _241_ 0
C120 net7 FILLER_0_115/a_40_246# 0.00159f
C121 hold165/a_326_118# tx_inst.data_reg\[2\] 0
C122 net55 _655_/a_1840_334# 0.02416f
C123 hold165/a_438_182# clknet_4_4_0_clk 0.06534f
C124 _483_/a_22_110# VPWR 0
C125 hold59/a_438_182# _702_/a_741_93# 0.00129f
C126 _644_/a_2002_114# _159_ 0
C127 hold59/a_326_118# _702_/a_843_236# 0
C128 _346_/a_354_412# _313_ 0.00179f
C129 net43 _386_/a_285_412# 0.00133f
C130 net51 _404_/a_46_156# 0.0108f
C131 _177_ net140 0.00117f
C132 baud_inst.counter\[26\] baud_inst.counter\[24\] 0.04687f
C133 _636_/a_741_93# hold81/a_56_118# 0
C134 _170_ hold131/a_326_118# 0
C135 _223_ _136_ 0.01424f
C136 net184 net41 0.00349f
C137 _216_ _141_ 0.00105f
C138 tx_busy _704_/a_1489_191# 0.01418f
C139 net2 _639_/a_741_93# 0.01151f
C140 net32 _241_ 0.03948f
C141 _642_/a_1583_191# clknet_0_clk 0.0037f
C142 net32 FILLER_25_163/a_32_246# 0
C143 net2 _425_/a_268_412# 0
C144 fanout32/a_40_152# _169_ 0.01249f
C145 _078_ _168_ 0
C146 VPWR FILLER_29_145/a_40_246# 0.14539f
C147 _089_ _281_ 0.22456f
C148 _229_ _167_ 0
C149 _170_ _054_ 0
C150 _062_ _651_/a_741_93# 0.00192f
C151 _704_/a_324_432# net43 0.00393f
C152 _684_/a_843_236# clknet_4_2_0_clk 0.02581f
C153 _356_/a_248_122# _296_ 0
C154 _671_/a_1583_191# clknet_0_clk 0.00194f
C155 _178_ _695_/a_1840_334# 0
C156 clknet_4_14_0_clk _245_ 0.5018f
C157 output19/a_40_152# rx_data[7] 0
C158 _645_/a_1489_191# _159_ 0.0096f
C159 _155_ hold127/a_326_118# 0
C160 net155 FILLER_0_115/a_40_246# 0
C161 clkbuf_4_0_0_clk/a_27_118# net38 0
C162 _077_ net21 0.01417f
C163 _689_/a_843_236# _688_/a_298_337# 0
C164 _689_/a_741_93# _688_/a_38_114# 0
C165 clknet_0_clk _686_/a_1583_191# 0.00301f
C166 tx_inst.bit_index\[1\] _147_ 0
C167 clkbuf_0_clk/a_116_82# hold167/a_56_118# 0.00258f
C168 _229_ _225_ 0.00333f
C169 net49 _693_/a_843_236# 0.02924f
C170 _230_ _640_/a_1785_429# 0
C171 output21/a_40_152# net50 0
C172 net82 _271_ 0.09156f
C173 _360_/a_1453_124# _175_ 0
C174 VPWR _669_/a_38_114# 0.00219f
C175 baud_inst.counter\[13\] _670_/a_1583_191# 0
C176 fanout26/a_40_152# clknet_4_9_0_clk 0.00128f
C177 FILLER_6_205/a_40_246# tx_inst.state\[2\] 0
C178 _707_/a_324_432# _704_/a_843_236# 0
C179 _707_/a_843_236# _704_/a_324_432# 0
C180 _707_/a_741_93# _704_/a_741_93# 0.03306f
C181 FILLER_13_102/a_32_246# _098_ 0
C182 hold159/a_56_118# _147_ 0.00167f
C183 net39 _684_/a_1583_191# 0
C184 _268_ clknet_4_15_0_clk 0.02136f
C185 net6 _655_/a_1785_429# 0
C186 tx_busy _707_/a_1785_429# 0
C187 _704_/a_1583_191# net19 0
C188 FILLER_19_55/a_40_246# VPWR 0.14707f
C189 _134_ _254_ 0
C190 net8 net38 0
C191 _217_ _401_/a_22_110# 0.03211f
C192 baud_inst.counter\[15\] _686_/a_741_93# 0
C193 baud_inst.counter\[14\] _686_/a_324_432# 0.03367f
C194 hold89/a_56_118# _519_/a_81_118# 0
C195 _285_ _287_ 0
C196 _690_/a_132_114# baud_inst.counter\[17\] 0
C197 clknet_4_13_0_clk _266_ 0.05244f
C198 _127_ net65 0
C199 baud_inst.counter\[0\] _181_ 0.01518f
C200 _658_/a_132_114# VPWR 0
C201 net156 VPWR 0.54085f
C202 _288_ _681_/a_612_127# 0
C203 _519_/a_81_118# _187_ 0
C204 net37 _416_/a_146_122# 0.00293f
C205 _313_ net134 0.00109f
C206 clk _706_/a_1840_334# 0
C207 _499_/a_209_168# _183_ 0.0011f
C208 _227_ net49 0.01573f
C209 hold113/a_438_182# _309_ 0
C210 net155 input10/a_40_152# 0
C211 _268_ _158_ 0.00145f
C212 net14 net71 0
C213 baud_inst.counter\[21\] _694_/a_1840_334# 0
C214 clknet_0_clk _211_ 0.02024f
C215 hold183/a_438_182# net57 0.00173f
C216 _551_/a_76_160# clknet_4_8_0_clk 0
C217 net36 _253_ 0
C218 baud_inst.counter\[21\] net114 0
C219 _282_ clknet_0_clk 0.03161f
C220 baud_inst.counter\[28\] _113_ 0.00612f
C221 hold160/a_326_118# baud_inst.counter\[19\] 0
C222 _431_/a_81_118# _170_ 0
C223 _697_/a_1840_334# clknet_4_9_0_clk 0
C224 tx_inst.bit_index\[2\] net145 0.00136f
C225 hold146/a_438_182# net43 0.00137f
C226 net69 _461_/a_120_432# 0.00398f
C227 hold66/a_326_118# _632_/a_741_93# 0.00638f
C228 hold66/a_56_118# _632_/a_843_236# 0
C229 hold66/a_438_182# _632_/a_324_432# 0
C230 _678_/a_298_337# net40 0.02611f
C231 clknet_4_7_0_clk rx_inst.state\[1\] 0.00644f
C232 FILLER_16_56/a_32_246# net88 0
C233 _643_/a_2250_412# _264_ 0.00912f
C234 tx_inst.data_reg\[6\] _656_/a_843_236# 0.00303f
C235 _376_/a_76_160# clknet_0_clk 0.00444f
C236 _707_/a_843_236# net19 0.00283f
C237 net148 _692_/a_38_114# 0
C238 _374_/a_142_412# clknet_0_clk 0
C239 baud_inst.counter\[21\] FILLER_21_33/a_32_246# 0.00403f
C240 net108 clkbuf_4_2_0_clk/a_27_118# 0.12778f
C241 fanout32/a_40_152# _084_ 0
C242 _528_/a_81_118# net103 0.04762f
C243 _266_ net65 0.64122f
C244 net30 _122_ 0.03466f
C245 net36 net29 0
C246 rx_data[7] _636_/a_843_236# 0
C247 _302_ clknet_4_8_0_clk 1.50995f
C248 _244_ _255_ 0
C249 _286_ baud_inst.counter\[8\] 0.03098f
C250 FILLER_10_78/a_32_246# _499_/a_209_168# 0
C251 FILLER_14_202/a_40_246# net51 0.00512f
C252 _046_ _156_ 0.00868f
C253 _390_/a_59_156# _209_ 0.0082f
C254 _686_/a_612_127# _685_/a_843_236# 0
C255 _686_/a_324_432# _685_/a_1489_191# 0
C256 _690_/a_1840_334# clknet_4_8_0_clk 0.00165f
C257 net87 _687_/a_1583_191# 0.00685f
C258 _179_ net46 0.49859f
C259 net71 _637_/a_741_93# 0.00272f
C260 net45 _701_/a_843_236# 0.04795f
C261 _180_ VPWR 0.65055f
C262 _143_ FILLER_7_121/a_40_246# 0
C263 net74 net73 0
C264 _126_ _269_ 0.24806f
C265 clkbuf_4_11_0_clk/a_27_118# net49 0
C266 hold87/a_56_118# _696_/a_38_114# 0
C267 _646_/a_298_337# _223_ 0
C268 net13 _633_/a_324_432# 0.0075f
C269 clkbuf_4_10_0_clk/a_27_118# clknet_4_8_0_clk 0.03859f
C270 _703_/a_298_337# _313_ 0.00168f
C271 hold153/a_56_118# net154 0.06338f
C272 _503_/a_165_412# net95 0.00163f
C273 net2 _061_ 0.00378f
C274 net145 _657_/a_324_432# 0
C275 _707_/a_741_93# hold51/a_438_182# 0
C276 _707_/a_843_236# hold51/a_326_118# 0
C277 hold126/a_56_118# _264_ 0.00654f
C278 _214_ tx_inst.data_reg\[2\] 0
C279 hold174/a_326_118# _176_ 0
C280 hold174/a_56_118# net27 0.02475f
C281 _293_ clknet_0_clk 0.00271f
C282 _206_ FILLER_2_183/a_32_246# 0.013f
C283 _386_/a_59_156# _211_ 0.00133f
C284 net44 _687_/a_324_432# 0.02784f
C285 net51 net62 3.13389f
C286 clknet_4_6_0_clk _668_/a_843_236# 0.0222f
C287 _170_ _060_ 0
C288 hold137/a_438_182# _678_/a_2250_412# 0
C289 _499_/a_209_168# net115 0
C290 _227_ _411_/a_494_160# 0
C291 _109_ baud_inst.counter\[24\] 0.01318f
C292 _010_ VPWR 0.1181f
C293 hold183/a_438_182# _400_/a_341_118# 0
C294 _641_/a_324_432# baud_inst.counter\[25\] 0.05576f
C295 _656_/a_1840_334# VPWR 0.00229f
C296 _282_ _182_ 1.07826f
C297 _646_/a_298_337# _240_ 0.00174f
C298 _549_/a_257_140# _311_ 0.00269f
C299 hold164/a_56_118# _692_/a_324_432# 0
C300 hold164/a_326_118# _692_/a_38_114# 0
C301 _672_/a_38_114# net61 0
C302 _672_/a_324_432# _033_ 0.02446f
C303 tx_inst.data_reg\[2\] FILLER_3_177/a_32_246# 0
C304 clknet_4_4_0_clk _196_ 0.03723f
C305 hold158/a_438_182# net158 0.02065f
C306 hold158/a_56_118# baud_inst.counter\[17\] 0
C307 baud_inst.counter\[30\] _554_/a_146_122# 0
C308 baud_inst.counter\[28\] _554_/a_350_122# 0
C309 baud_inst.counter\[31\] _554_/a_248_122# 0
C310 _680_/a_2250_412# _183_ 0
C311 hold177/a_56_118# baud_inst.counter\[13\] 0.00367f
C312 _021_ _302_ 0.01948f
C313 _697_/a_550_127# _110_ 0
C314 _697_/a_612_127# net142 0.00218f
C315 _248_ _433_/a_244_412# 0.01569f
C316 _123_ _272_ 0.1218f
C317 _550_/a_209_168# FILLER_28_53/a_32_246# 0
C318 rx_inst.state\[2\] _236_ 0
C319 net12 _632_/a_1840_334# 0.00557f
C320 _114_ hold107/a_438_182# 0.00435f
C321 _661_/a_843_236# _151_ 0
C322 _661_/a_132_114# net155 0
C323 _661_/a_1583_191# _206_ 0
C324 _016_ _015_ 0.00517f
C325 rx_inst.data_reg\[4\] net30 0.02549f
C326 _655_/a_298_337# clknet_0_clk 0
C327 hold115/a_56_118# hold116/a_326_118# 0.00359f
C328 hold115/a_326_118# hold116/a_56_118# 0.00359f
C329 _079_ _374_/a_244_140# 0
C330 _073_ _074_ 0.00301f
C331 tx_inst.data_reg\[2\] FILLER_3_150/a_40_246# 0.00274f
C332 VPWR _382_/a_382_118# 0.00455f
C333 rx_data[7] hold81/a_438_182# 0.00252f
C334 _206_ _275_ 0
C335 _186_ _683_/a_2250_412# 0.00813f
C336 hold141/a_438_182# clknet_4_8_0_clk 0
C337 baud_inst.counter\[27\] _108_ 0
C338 net48 _636_/a_324_432# 0
C339 _467_/a_120_432# net84 0
C340 _341_/a_71_118# net41 0
C341 _674_/a_843_236# _030_ 0
C342 _369_/a_248_122# tx_inst.state\[2\] 0
C343 hold136/a_438_182# FILLER_5_32/a_40_246# 0.00941f
C344 _267_ _048_ 0
C345 _059_ net77 0.00754f
C346 _695_/a_1785_429# VPWR 0
C347 VPWR net140 0.17708f
C348 rx_inst.data_reg\[4\] _647_/a_324_432# 0
C349 _645_/a_741_93# _170_ 0
C350 _013_ clknet_4_9_0_clk 0.00571f
C351 _293_ _182_ 0
C352 _055_ _056_ 0.01729f
C353 _073_ _665_/a_1489_191# 0
C354 VPWR baud_inst.counter\[11\] 0.17247f
C355 clknet_4_14_0_clk _255_ 0.00896f
C356 _285_ clkbuf_4_0_0_clk/a_27_118# 0.04107f
C357 net94 clknet_0_clk 0.11219f
C358 baud_inst.counter\[14\] clknet_4_9_0_clk 0.03941f
C359 FILLER_7_176/a_32_246# _007_ 0.00989f
C360 _057_ _647_/a_298_337# 0
C361 net49 _115_ 0
C362 _207_ _390_/a_59_156# 0
C363 net55 _390_/a_285_412# 0.00339f
C364 baud_inst.counter\[3\] net135 0
C365 clknet_4_3_0_clk _499_/a_209_168# 0
C366 clknet_4_6_0_clk _667_/a_324_432# 0.02922f
C367 hold102/a_56_118# VPWR 0.01208f
C368 _284_ _034_ 0
C369 _002_ FILLER_15_127/a_32_246# 0.02957f
C370 _692_/a_1583_191# _692_/a_2250_412# 0
C371 baud_inst.counter\[17\] FILLER_12_42/a_32_246# 0
C372 _304_ fanout44/a_40_152# 0
C373 _006_ _665_/a_612_127# 0
C374 _339_/a_1453_124# clknet_4_4_0_clk 0
C375 hold74/a_438_182# clknet_4_13_0_clk 0
C376 _680_/a_2250_412# net115 0.00229f
C377 baud_inst.counter\[12\] _684_/a_2002_114# 0
C378 net128 _684_/a_1489_191# 0
C379 _198_ _368_/a_257_140# 0
C380 baud_inst.counter\[28\] hold114/a_326_118# 0.00375f
C381 baud_inst.counter\[31\] hold114/a_56_118# 0.0027f
C382 _699_/a_1583_191# _165_ 0.00265f
C383 net49 _242_ 0.04768f
C384 FILLER_22_133/a_40_246# rx_inst.state\[2\] 0.00121f
C385 FILLER_16_70/a_40_246# baud_inst.counter\[12\] 0.00258f
C386 net35 clkbuf_4_12_0_clk/a_27_118# 0.00948f
C387 tx_inst.data_reg\[7\] net171 0.16619f
C388 _680_/a_741_93# _504_/a_380_412# 0
C389 _125_ _650_/a_1583_191# 0
C390 FILLER_16_70/a_40_246# _696_/a_38_114# 0
C391 _114_ _694_/a_843_236# 0
C392 net3 _380_/a_59_156# 0.00587f
C393 hold77/a_326_118# VPWR 0.0042f
C394 FILLER_1_67/a_40_246# VPWR 0.13424f
C395 hold100/a_438_182# _310_ 0
C396 net184 _171_ 0
C397 net92 _510_/a_146_122# 0
C398 _678_/a_324_432# net93 0
C399 _118_ tx_done 0
C400 _055_ _134_ 0
C401 _179_ _313_ 0.00886f
C402 _536_/a_435_412# _106_ 0
C403 hold109/a_438_182# net40 0
C404 rx_data[6] hold71/a_56_118# 0.01267f
C405 net49 _701_/a_38_114# 0.01174f
C406 _170_ _649_/a_741_93# 0
C407 _685_/a_1489_191# clknet_4_9_0_clk 0
C408 _156_ _647_/a_550_127# 0
C409 _433_/a_244_412# net139 0
C410 tx_inst.data_reg\[6\] _658_/a_2250_412# 0
C411 _500_/a_155_412# net181 0.00151f
C412 hold87/a_438_182# _308_ 0
C413 _642_/a_2002_114# clknet_0_clk 0
C414 _155_ net77 0
C415 net52 _161_ 0.0768f
C416 net48 hold81/a_56_118# 0
C417 hold89/a_438_182# _296_ 0.01377f
C418 _075_ net26 0.00275f
C419 hold123/a_326_118# clknet_0_clk 0
C420 hold121/a_438_182# _693_/a_324_432# 0
C421 hold68/a_56_118# VPWR 0.0352f
C422 _152_ _665_/a_38_114# 0
C423 _513_/a_192_429# _292_ 0.03918f
C424 _636_/a_741_93# _157_ 0
C425 _280_ _685_/a_843_236# 0
C426 _041_ rx_inst.state\[4\] 0
C427 baud_inst.counter\[24\] _541_/a_474_130# 0
C428 _205_ net43 0.16083f
C429 rx_inst.data_reg\[2\] _159_ 0.01242f
C430 net94 _182_ 0.02837f
C431 clknet_4_5_0_clk clknet_0_clk 0.03917f
C432 FILLER_11_144/a_32_246# clknet_4_6_0_clk 0
C433 clkbuf_4_6_0_clk/a_27_118# _166_ 0
C434 _689_/a_1583_191# _688_/a_843_236# 0
C435 _689_/a_1840_334# _688_/a_741_93# 0
C436 _689_/a_2250_412# _688_/a_324_432# 0
C437 net120 VPWR 0.74771f
C438 _118_ net55 0.00758f
C439 clknet_0_clk _686_/a_2002_114# 0
C440 rx_data[3] _264_ 0
C441 _353_/a_350_122# _183_ 0
C442 clknet_4_6_0_clk _142_ 0
C443 net39 _016_ 0.00304f
C444 _206_ _071_ 0.02701f
C445 net155 net41 0
C446 rx_inst.bit_index\[2\] _223_ 0.00213f
C447 net42 clknet_4_6_0_clk 1.06429f
C448 _060_ _237_ 0
C449 _360_/a_500_118# net34 0
C450 _360_/a_1377_160# _175_ 0
C451 VPWR _669_/a_1840_334# 0.00117f
C452 hold52/a_56_118# clknet_4_14_0_clk 0.01153f
C453 hold113/a_56_118# net46 0
C454 _013_ _686_/a_2250_412# 0.00188f
C455 net49 net163 0.10796f
C456 baud_inst.counter\[23\] _301_ 0.00618f
C457 VPWR _633_/a_843_236# 0.01551f
C458 _073_ _201_ 0.01866f
C459 _707_/a_612_127# _704_/a_324_432# 0
C460 _707_/a_324_432# _704_/a_612_127# 0
C461 FILLER_18_65/a_40_246# _687_/a_2250_412# 0
C462 hold147/a_438_182# _105_ 0
C463 _641_/a_741_93# net140 0
C464 _673_/a_741_93# _037_ 0.002f
C465 hold63/a_438_182# net51 0.00179f
C466 _074_ net41 0.48685f
C467 FILLER_13_68/a_40_246# _684_/a_2250_412# 0.01012f
C468 _301_ _100_ 0
C469 _219_ _220_ 0
C470 _218_ _142_ 0
C471 clknet_4_5_0_clk _077_ 0.05252f
C472 baud_inst.counter\[14\] _686_/a_2250_412# 0.0159f
C473 _206_ FILLER_0_154/a_40_246# 0.00451f
C474 _489_/a_115_308# net136 0
C475 _099_ hold91/a_438_182# 0
C476 _230_ _425_/a_46_156# 0
C477 _064_ _217_ 0
C478 hold97/a_56_118# net109 0.01496f
C479 _707_/a_132_114# net43 0
C480 _690_/a_1489_191# baud_inst.counter\[17\] 0.00338f
C481 _658_/a_1489_191# VPWR 0
C482 net128 _187_ 0
C483 _288_ net117 0.03269f
C484 baud_inst.counter\[12\] baud_inst.counter\[13\] 0.22823f
C485 _228_ _224_ 0.0438f
C486 net136 _681_/a_324_432# 0
C487 _202_ _275_ 0
C488 _171_ _665_/a_132_114# 0
C489 _081_ _671_/a_843_236# 0
C490 net35 net26 0
C491 _052_ hold176/a_326_118# 0
C492 net176 hold176/a_56_118# 0
C493 _673_/a_298_337# _086_ 0.04948f
C494 _673_/a_38_114# net40 0
C495 net181 net38 0.07699f
C496 _171_ net169 0
C497 net98 _681_/a_324_432# 0
C498 hold98/a_326_118# _681_/a_1583_191# 0
C499 hold98/a_56_118# _681_/a_1840_334# 0
C500 rx_inst.state\[2\] clk 0
C501 clknet_4_4_0_clk tx_inst.data_reg\[0\] 0.02992f
C502 hold144/a_56_118# FILLER_20_177/a_32_246# 0.00404f
C503 _123_ _648_/a_298_337# 0
C504 net35 net32 0.7264f
C505 net21 net43 0.19028f
C506 hold129/a_438_182# fanout29/a_40_152# 0
C507 _646_/a_38_114# clknet_0_clk 0.0119f
C508 _644_/a_324_432# _242_ 0
C509 hold69/a_56_118# net70 0
C510 net7 FILLER_0_109/a_32_246# 0.02114f
C511 hold89/a_56_118# _014_ 0.02276f
C512 hold89/a_326_118# net88 0.00323f
C513 net74 hold138/a_56_118# 0
C514 hold86/a_326_118# _287_ 0
C515 _357_/a_252_412# _186_ 0.00212f
C516 hold100/a_438_182# _698_/a_1840_334# 0.00197f
C517 net100 _698_/a_843_236# 0.00715f
C518 _008_ _674_/a_843_236# 0
C519 tx_inst.data_reg\[6\] _656_/a_612_127# 0
C520 _707_/a_612_127# net19 0
C521 baud_inst.counter\[13\] net88 0
C522 _187_ _014_ 0
C523 hold64/a_56_118# _635_/a_2250_412# 0.00101f
C524 hold64/a_438_182# _635_/a_1583_191# 0
C525 hold64/a_326_118# _635_/a_1840_334# 0
C526 input3/a_40_152# net3 0.00138f
C527 hold174/a_438_182# net26 0.0156f
C528 _191_ _685_/a_843_236# 0
C529 _528_/a_81_118# net101 0
C530 _436_/a_244_412# _157_ 0.00854f
C531 _436_/a_142_412# _250_ 0.00311f
C532 clknet_4_14_0_clk _051_ 0.01728f
C533 _695_/a_741_93# FILLER_22_43/a_40_246# 0.00392f
C534 baud_inst.counter\[25\] FILLER_20_106/a_32_246# 0.02954f
C535 tx_inst.data_reg\[4\] hold165/a_326_118# 0
C536 _361_/a_248_122# _197_ 0
C537 _686_/a_741_93# clknet_4_9_0_clk 0.02326f
C538 _343_/a_257_140# _174_ 0
C539 _343_/a_155_412# _175_ 0.03403f
C540 _173_ _176_ 0
C541 net37 net16 0
C542 hold77/a_438_182# net30 0.01987f
C543 hold77/a_326_118# _266_ 0.01025f
C544 _045_ net72 0.01029f
C545 _636_/a_1583_191# clkbuf_4_13_0_clk/a_27_118# 0.00123f
C546 net71 _637_/a_1785_429# 0
C547 net45 _701_/a_612_127# 0.00187f
C548 net92 FILLER_7_82/a_32_246# 0
C549 _531_/a_380_412# _299_ 0
C550 net155 FILLER_0_109/a_32_246# 0
C551 _294_ _684_/a_1840_334# 0
C552 net13 _633_/a_2250_412# 0.01368f
C553 _021_ hold148/a_326_118# 0.01176f
C554 hold66/a_326_118# net66 0
C555 hold97/a_326_118# _096_ 0
C556 hold183/a_326_118# clk 0
C557 baud_inst.counter\[20\] hold121/a_326_118# 0.03208f
C558 _292_ _184_ 0
C559 net95 _037_ 0.66585f
C560 _291_ baud_inst.counter\[4\] 0
C561 _002_ _409_/a_73_118# 0.00323f
C562 net71 clknet_0_clk 0
C563 FILLER_25_198/a_32_246# _649_/a_324_432# 0
C564 rx_inst.bit_index\[1\] net37 0
C565 net44 _687_/a_2250_412# 0.01322f
C566 FILLER_20_65/a_32_246# _307_ 0
C567 net39 baud_inst.counter\[13\] 0.02538f
C568 net42 net29 0.10695f
C569 clknet_4_6_0_clk _668_/a_612_127# 0.00494f
C570 net49 hold105/a_56_118# 0.00267f
C571 _380_/a_382_118# _208_ 0.01617f
C572 _380_/a_59_156# _150_ 0
C573 VPWR _504_/a_209_168# 0.01417f
C574 hold55/a_326_118# net2 0
C575 FILLER_12_89/a_40_246# baud_inst.counter\[13\] 0
C576 FILLER_16_166/a_32_246# net2 0
C577 _155_ rx_inst.data_reg\[6\] 0
C578 clknet_0_clk _473_/a_120_432# 0.00143f
C579 tx_inst.data_reg\[1\] _209_ 0.14486f
C580 VPWR hold60/a_56_118# 0.01325f
C581 FILLER_5_164/a_40_246# clkbuf_4_4_0_clk/a_27_118# 0.00137f
C582 tx hold55/a_326_118# 0.01434f
C583 FILLER_14_185/a_32_246# rx_inst.state\[4\] 0
C584 _646_/a_1583_191# _240_ 0.00742f
C585 _219_ FILLER_6_151/a_40_246# 0
C586 _672_/a_2250_412# _033_ 0
C587 tx_inst.bit_index\[2\] _220_ 0
C588 net22 VPWR 0.07663f
C589 net31 FILLER_23_143/a_32_246# 0
C590 net6 VPWR 0.46817f
C591 net87 _520_/a_257_140# 0
C592 _694_/a_843_236# _107_ 0
C593 _533_/a_248_122# VPWR 0
C594 _659_/a_843_236# _211_ 0
C595 _633_/a_843_236# _266_ 0
C596 hold136/a_326_118# _279_ 0.00462f
C597 _053_ _697_/a_1583_191# 0.0023f
C598 _387_/a_46_156# _212_ 0
C599 net43 _211_ 0
C600 baud_inst.counter\[28\] _700_/a_324_432# 0.00302f
C601 clknet_4_5_0_clk hold146/a_56_118# 0
C602 rx_inst.state\[2\] _409_/a_167_412# 0.00425f
C603 rx_inst.state\[3\] net51 0.19297f
C604 _228_ _409_/a_269_412# 0
C605 _132_ _131_ 0.00142f
C606 rx_inst.bit_index\[2\] _261_ 0.00106f
C607 _644_/a_612_127# _170_ 0
C608 clknet_4_12_0_clk _262_ 0.04764f
C609 _292_ FILLER_9_72/a_32_246# 0
C610 baud_inst.counter\[18\] net160 0.00104f
C611 hold135/a_56_118# VPWR 0.00745f
C612 _655_/a_1583_191# clknet_0_clk 0
C613 _129_ _650_/a_1583_191# 0
C614 FILLER_15_67/a_40_246# _292_ 0
C615 hold127/a_56_118# _244_ 0.00487f
C616 rx_data[0] rx_data[6] 0.64345f
C617 net156 _163_ 0.15179f
C618 _656_/a_741_93# tx_data[6] 0.00202f
C619 _656_/a_324_432# net9 0.01632f
C620 net79 _503_/a_165_412# 0
C621 net48 _636_/a_2250_412# 0.00839f
C622 hold113/a_56_118# _313_ 0
C623 _660_/a_298_337# net54 0.02235f
C624 _674_/a_612_127# _030_ 0.00554f
C625 _674_/a_2250_412# baud_inst.counter\[2\] 0
C626 tx_inst.data_reg\[5\] clknet_0_clk 0.0247f
C627 hold130/a_56_118# _358_/a_72_436# 0
C628 _374_/a_142_412# net43 0.03096f
C629 net45 net99 0
C630 input4/a_40_152# tx_data[7] 0
C631 hold161/a_438_182# net161 0.00528f
C632 clkload0/Y clknet_0_clk 0.0037f
C633 baud_inst.counter\[14\] _687_/a_741_93# 0
C634 baud_inst.counter\[15\] _687_/a_843_236# 0.00139f
C635 rx_inst.data_reg\[4\] _647_/a_2250_412# 0.01149f
C636 VPWR FILLER_11_134/a_32_246# 0.09957f
C637 _662_/a_38_114# _073_ 0.02072f
C638 _660_/a_741_93# clknet_4_5_0_clk 0.02542f
C639 clknet_0_clk _450_/a_127_436# 0.0021f
C640 _073_ tx_inst.state\[3\] 0
C641 _069_ tx_inst.data_reg\[1\] 0.00647f
C642 _240_ net64 0.0953f
C643 rx_inst.state\[2\] net2 0.27311f
C644 tx_inst.state\[1\] _152_ 0.0013f
C645 _637_/a_38_114# FILLER_27_210/a_40_246# 0.00201f
C646 net55 net159 0.0359f
C647 _075_ net50 0
C648 rx_inst.state\[3\] net123 0
C649 _058_ _249_ 0.00477f
C650 _429_/a_550_140# _158_ 0
C651 net184 hold184/a_438_182# 0.0293f
C652 input2/a_40_152# _705_/a_1840_334# 0
C653 hold97/a_438_182# _183_ 0
C654 _278_ _191_ 0.15692f
C655 hold164/a_326_118# _103_ 0
C656 _692_/a_843_236# clknet_4_10_0_clk 0.02684f
C657 _680_/a_1489_191# net135 0
C658 _518_/a_45_160# VPWR 0.00583f
C659 _153_ _235_ 0.00336f
C660 _170_ _257_ 0.02579f
C661 _170_ _256_ 0
C662 net32 _254_ 0.01697f
C663 net47 _474_/a_22_110# 0
C664 _339_/a_1377_160# clknet_4_4_0_clk 0
C665 hold183/a_56_118# _653_/a_2250_412# 0
C666 tx _705_/a_843_236# 0.00129f
C667 output14/a_40_152# VPWR 0.0093f
C668 clknet_4_0_0_clk _681_/a_38_114# 0
C669 _163_ _180_ 0
C670 clkbuf_0_clk/a_116_82# _669_/a_324_432# 0
C671 _689_/a_843_236# _101_ 0.01314f
C672 _206_ FILLER_0_130/a_32_246# 0
C673 net53 net44 0.00244f
C674 _678_/a_324_432# clknet_4_1_0_clk 0.00228f
C675 tx_inst.state\[4\] _376_/a_272_160# 0
C676 net48 _259_ 0.16041f
C677 _680_/a_843_236# _038_ 0
C678 clknet_4_5_0_clk FILLER_6_189/a_40_246# 0.00428f
C679 _635_/a_1583_191# _632_/a_843_236# 0
C680 _635_/a_843_236# _632_/a_1583_191# 0
C681 _394_/a_120_432# net27 0
C682 net28 _372_/a_120_432# 0.00117f
C683 _178_ net46 2.08066f
C684 net85 _632_/a_38_114# 0
C685 hold163/a_438_182# _105_ 0
C686 clk _658_/a_843_236# 0.00166f
C687 FILLER_8_35/a_32_246# baud_inst.counter\[9\] 0.01509f
C688 tx_inst.bit_index\[2\] FILLER_6_151/a_40_246# 0.00412f
C689 _207_ tx_inst.data_reg\[1\] 0.00149f
C690 _285_ net108 0
C691 hold59/a_438_182# _115_ 0
C692 _022_ _106_ 0.0037f
C693 baud_inst.counter\[26\] _697_/a_38_114# 0
C694 _284_ _351_/a_46_156# 0
C695 hold153/a_56_118# baud_inst.counter\[5\] 0.00698f
C696 FILLER_26_141/a_40_246# _161_ 0
C697 net49 _701_/a_1840_334# 0.00671f
C698 FILLER_8_63/a_40_246# _287_ 0.01168f
C699 clkbuf_4_6_0_clk/a_27_118# _651_/a_1583_191# 0.00128f
C700 _685_/a_298_337# net91 0
C701 _241_ hold180/a_438_182# 0
C702 _285_ net181 0.00173f
C703 _283_ net86 0
C704 fanout41/a_40_152# VPWR 0.00582f
C705 rx net81 0.02433f
C706 net2 _050_ 0.00459f
C707 _411_/a_358_436# _228_ 0.0217f
C708 _411_/a_115_308# rx_inst.state\[2\] 0.01466f
C709 net105 clknet_4_10_0_clk 0
C710 _116_ hold59/a_56_118# 0.00644f
C711 net182 _670_/a_298_337# 0
C712 net103 net40 0
C713 hold162/a_326_118# _696_/a_741_93# 0.00222f
C714 hold162/a_56_118# _696_/a_843_236# 0
C715 _637_/a_298_337# VPWR 0.00127f
C716 net109 _684_/a_298_337# 0
C717 net66 _635_/a_38_114# 0
C718 net44 _515_/a_76_160# 0
C719 net48 _157_ 0.14419f
C720 hold67/a_438_182# hold59/a_56_118# 0
C721 net32 _420_/a_248_122# 0.00467f
C722 clkload2/Y clknet_0_clk 0.02251f
C723 _177_ _554_/a_248_122# 0
C724 hold161/a_56_118# VPWR 0.00389f
C725 _643_/a_843_236# net111 0
C726 _680_/a_1583_191# baud_inst.counter\[8\] 0.00766f
C727 net158 _688_/a_298_337# 0
C728 _233_ net30 0
C729 _675_/a_843_236# net38 0.03837f
C730 net44 FILLER_17_0/a_40_246# 0.01992f
C731 net49 fanout46/a_40_152# 0.04805f
C732 clknet_4_14_0_clk hold127/a_56_118# 0
C733 _244_ _424_/a_244_412# 0.00449f
C734 tx_inst.data_reg\[4\] FILLER_3_150/a_40_246# 0
C735 _186_ _183_ 0.03654f
C736 tx_inst.bit_index\[0\] hold169/a_56_118# 0.00142f
C737 _118_ output22/a_40_152# 0
C738 _692_/a_1489_191# clknet_4_8_0_clk 0
C739 _131_ _451_/a_257_140# 0
C740 _057_ _160_ 0.012f
C741 hold97/a_438_182# net115 0
C742 clknet_4_4_0_clk tx_inst.data_reg\[1\] 0.18433f
C743 hold90/a_438_182# net29 0.01333f
C744 hold87/a_438_182# VPWR 0.00527f
C745 _031_ net133 0.05158f
C746 VPWR _633_/a_612_127# 0.00985f
C747 _363_/a_22_110# hold184/a_326_118# 0
C748 net51 _704_/a_324_432# 0
C749 FILLER_15_116/a_40_246# _670_/a_324_432# 0
C750 net84 _635_/a_843_236# 0.00199f
C751 net15 _156_ 0.02667f
C752 net152 _282_ 0.29191f
C753 net26 _651_/a_1840_334# 0.0011f
C754 _667_/a_2250_412# net29 0
C755 net62 _459_/a_229_118# 0
C756 _168_ _459_/a_27_156# 0.00117f
C757 _265_ _639_/a_38_114# 0.02593f
C758 FILLER_26_229/a_32_246# net30 0
C759 net159 _389_/a_46_156# 0
C760 _390_/a_559_412# _213_ 0.00155f
C761 _644_/a_1489_191# clknet_4_14_0_clk 0.00603f
C762 clknet_4_3_0_clk _652_/a_298_337# 0.01225f
C763 _674_/a_1840_334# _672_/a_298_337# 0
C764 _674_/a_1583_191# _672_/a_38_114# 0
C765 net32 _416_/a_146_122# 0.00221f
C766 _264_ _649_/a_1583_191# 0.04249f
C767 hold144/a_326_118# _057_ 0.00643f
C768 net78 FILLER_29_179/a_40_246# 0.03151f
C769 clknet_0_clk _199_ 0
C770 _200_ _665_/a_298_337# 0.03019f
C771 net172 _665_/a_324_432# 0
C772 net79 hold79/a_56_118# 0.02107f
C773 _662_/a_38_114# net41 0.01276f
C774 _194_ net26 0
C775 hold98/a_438_182# _681_/a_1489_191# 0
C776 hold157/a_438_182# net101 0
C777 tx_inst.bit_index\[1\] net165 0.00235f
C778 _449_/a_27_156# net62 0
C779 clk _656_/a_132_114# 0
C780 _646_/a_1840_334# clknet_0_clk 0.0318f
C781 net45 _695_/a_2250_412# 0.00116f
C782 hold174/a_438_182# FILLER_5_181/a_32_246# 0
C783 net27 _651_/a_1489_191# 0.01782f
C784 _189_ _186_ 0.01184f
C785 net66 _632_/a_550_127# 0
C786 net37 _667_/a_38_114# 0.00678f
C787 net122 _667_/a_324_432# 0.02241f
C788 _226_ net2 0.19914f
C789 _029_ hold107/a_326_118# 0.04182f
C790 net106 hold107/a_438_182# 0.02472f
C791 net100 _698_/a_612_127# 0.0039f
C792 _534_/a_46_156# clknet_4_10_0_clk 0.00129f
C793 _127_ _637_/a_298_337# 0
C794 net51 net19 0.04977f
C795 fanout42/a_40_152# _142_ 0
C796 hold155/a_326_118# _210_ 0.00141f
C797 _361_/a_146_122# VPWR 0
C798 FILLER_10_147/a_32_246# net122 0
C799 net30 FILLER_17_199/a_40_246# 0
C800 FILLER_18_158/a_40_246# _435_/a_72_436# 0
C801 _241_ _137_ 0.08093f
C802 _157_ _250_ 0.05112f
C803 _154_ FILLER_23_186/a_40_246# 0.00285f
C804 baud_inst.counter\[21\] hold147/a_56_118# 0.01685f
C805 rx_inst.bit_index\[2\] _447_/a_81_118# 0
C806 net42 fanout42/a_40_152# 0.01176f
C807 _177_ hold114/a_56_118# 0
C808 _257_ _263_ 0
C809 _675_/a_1583_191# _675_/a_2250_412# 0
C810 _339_/a_805_385# clknet_0_clk 0
C811 _077_ _199_ 0.18325f
C812 _206_ _388_/a_59_156# 0.01557f
C813 net79 _673_/a_681_505# 0
C814 VPWR _666_/a_741_93# 0.01559f
C815 _527_/a_192_429# _300_ 0.03467f
C816 _527_/a_341_118# net101 0.01621f
C817 net71 _048_ 0.00194f
C818 net45 net107 0.00275f
C819 _452_/a_155_412# net175 0.01812f
C820 clknet_4_5_0_clk net43 0.32604f
C821 _696_/a_843_236# net141 0.01607f
C822 _696_/a_324_432# _025_ 0.02794f
C823 _696_/a_741_93# _310_ 0.03869f
C824 _680_/a_741_93# FILLER_7_40/a_32_246# 0
C825 FILLER_17_199/a_40_246# _647_/a_324_432# 0
C826 _257_ _237_ 0
C827 _360_/a_71_118# _656_/a_1489_191# 0
C828 clknet_0_clk net175 0.01493f
C829 hold145/a_438_182# tx_inst.data_reg\[3\] 0.00923f
C830 net51 hold51/a_326_118# 0.00606f
C831 _637_/a_298_337# _266_ 0
C832 _637_/a_38_114# net30 0
C833 clknet_4_14_0_clk _424_/a_244_412# 0.00699f
C834 hold129/a_438_182# _186_ 0.00224f
C835 hold124/a_326_118# rx_inst.data_reg\[5\] 0.01999f
C836 FILLER_17_94/a_40_246# net91 0
C837 _312_ _541_/a_209_168# 0
C838 _648_/a_1583_191# _648_/a_2250_412# -0
C839 _648_/a_741_93# _648_/a_1489_191# 0
C840 _178_ _313_ 0.01783f
C841 VPWR _287_ 0.2906f
C842 fanout43/a_40_152# FILLER_14_148/a_40_246# 0.01f
C843 clknet_0_clk _273_ 0.24228f
C844 hold173/a_56_118# _222_ 0
C845 _226_ _411_/a_115_308# 0.00289f
C846 _697_/a_38_114# _109_ 0
C847 VPWR _509_/a_155_412# 0
C848 net44 net91 0.01944f
C849 clknet_4_5_0_clk _664_/a_324_432# 0.02355f
C850 _175_ hold174/a_56_118# 0
C851 _531_/a_380_412# _105_ 0
C852 _676_/a_843_236# baud_inst.counter\[13\] 0
C853 net16 _650_/a_1583_191# 0
C854 _646_/a_2002_114# _240_ 0
C855 FILLER_26_151/a_32_246# _236_ 0
C856 clknet_4_0_0_clk hold61/a_438_182# 0.00225f
C857 net122 FILLER_11_144/a_32_246# 0
C858 FILLER_15_173/a_40_246# net2 0
C859 _660_/a_38_114# FILLER_0_174/a_32_246# 0
C860 _074_ _706_/a_843_236# 0
C861 hold183/a_56_118# tx_inst.bit_index\[1\] 0.03023f
C862 _254_ FILLER_25_150/a_32_246# 0
C863 _699_/a_741_93# _547_/a_81_118# 0
C864 hold136/a_56_118# _674_/a_741_93# 0
C865 hold136/a_326_118# _674_/a_324_432# 0
C866 FILLER_15_127/a_32_246# _669_/a_1583_191# 0
C867 _694_/a_612_127# _107_ 0
C868 _659_/a_612_127# _211_ 0
C869 _633_/a_612_127# _266_ 0
C870 FILLER_27_46/a_32_246# _701_/a_741_93# 0
C871 net106 _694_/a_843_236# 0
C872 hold113/a_438_182# clknet_0_clk 0.01033f
C873 fanout24/a_40_152# _263_ 0
C874 FILLER_27_194/a_40_246# _648_/a_741_93# 0
C875 _171_ _201_ 0
C876 net122 _142_ 0
C877 _642_/a_324_432# _053_ 0.03024f
C878 _642_/a_298_337# clknet_4_12_0_clk 0.00226f
C879 _642_/a_38_114# _132_ 0.03573f
C880 FILLER_23_204/a_40_246# clkbuf_4_15_0_clk/a_27_118# 0.01094f
C881 baud_inst.counter\[30\] _700_/a_1583_191# 0
C882 baud_inst.counter\[28\] _700_/a_2250_412# 0.04657f
C883 tx_inst.data_reg\[7\] net155 0.01046f
C884 baud_inst.counter\[4\] _492_/a_170_412# 0
C885 hold154/a_438_182# _676_/a_298_337# 0
C886 net42 net122 0.06071f
C887 net132 _170_ 0.09226f
C888 net28 _224_ 0.00895f
C889 net176 clkbuf_4_9_0_clk/a_27_118# 0
C890 hold112/a_56_118# _136_ 0
C891 hold85/a_56_118# _635_/a_741_93# 0
C892 _098_ hold128/a_438_182# 0.0048f
C893 _431_/a_81_118# _247_ 0
C894 net40 _086_ 0.03605f
C895 rx_data[4] hold84/a_56_118# 0
C896 hold64/a_438_182# hold84/a_438_182# 0
C897 hold175/a_326_118# fanout24/a_40_152# 0.00127f
C898 _466_/a_22_110# _156_ 0.03154f
C899 net121 net75 0.01951f
C900 net124 _648_/a_1583_191# 0.00721f
C901 _155_ _648_/a_132_114# 0
C902 FILLER_22_133/a_40_246# _455_/a_155_412# 0.01004f
C903 net94 net152 0
C904 FILLER_17_96/a_32_246# net46 0.00403f
C905 FILLER_5_164/a_40_246# VPWR 0.16671f
C906 net31 _236_ 0.21093f
C907 _656_/a_2250_412# net9 0.00188f
C908 net79 _037_ 0.00755f
C909 _697_/a_298_337# VPWR 0.00296f
C910 _660_/a_681_505# _214_ 0
C911 FILLER_4_183/a_40_246# _076_ 0.00456f
C912 hold56/a_326_118# _651_/a_324_432# 0
C913 _223_ _458_/a_165_412# 0
C914 _302_ FILLER_17_0/a_40_246# 0
C915 _307_ _541_/a_474_130# 0
C916 _264_ _471_/a_120_432# 0.00174f
C917 _452_/a_155_412# _161_ 0
C918 _091_ net40 1.38612f
C919 _485_/a_22_110# net122 0.02623f
C920 _485_/a_120_432# net37 0.0084f
C921 _358_/a_72_436# _358_/a_411_436# -0
C922 _013_ hold91/a_56_118# 0.01543f
C923 _641_/a_1583_191# net52 0
C924 _660_/a_1785_429# clknet_4_5_0_clk 0
C925 _012_ baud_inst.counter\[13\] 0.02155f
C926 FILLER_21_96/a_40_246# net99 0.03223f
C927 clknet_0_clk _161_ 0.00419f
C928 _145_ tx_data[5] 0
C929 FILLER_20_57/a_32_246# _308_ 0
C930 baud_inst.counter\[2\] _673_/a_2250_412# 0.00194f
C931 _216_ _400_/a_435_412# 0
C932 _195_ FILLER_7_176/a_32_246# 0.00189f
C933 _089_ _676_/a_132_114# 0
C934 baud_inst.counter\[14\] hold91/a_56_118# 0.00244f
C935 _184_ _351_/a_268_412# 0.00127f
C936 hold56/a_56_118# _007_ 0.02332f
C937 _041_ _483_/a_120_432# 0
C938 _696_/a_324_432# FILLER_17_79/a_40_246# 0
C939 _554_/a_248_122# VPWR 0
C940 _705_/a_324_432# _166_ 0.0017f
C941 rx_inst.data_reg\[1\] _244_ 0
C942 _677_/a_1840_334# _063_ 0
C943 _670_/a_1583_191# net29 0.00112f
C944 _692_/a_550_127# net164 0
C945 _692_/a_612_127# clknet_4_10_0_clk 0
C946 _206_ net50 0
C947 _080_ FILLER_14_148/a_40_246# 0
C948 _673_/a_741_93# clknet_4_1_0_clk 0.02147f
C949 clknet_4_0_0_clk _681_/a_1840_334# 0.01703f
C950 clkbuf_0_clk/a_116_82# _669_/a_2250_412# 0
C951 _643_/a_38_114# FILLER_21_192/a_40_246# 0
C952 _689_/a_612_127# _101_ 0.00202f
C953 _189_ _684_/a_324_432# 0.02004f
C954 baud_inst.counter\[27\] clkbuf_4_10_0_clk/a_27_118# 0.00132f
C955 hold111/a_56_118# net30 0.00933f
C956 _678_/a_2250_412# clknet_4_1_0_clk 0
C957 _339_/a_886_118# FILLER_7_146/a_32_246# 0
C958 net156 _523_/a_155_412# 0
C959 tx_inst.data_reg\[7\] hold145/a_56_118# 0.00368f
C960 _659_/a_741_93# FILLER_7_121/a_40_246# 0
C961 clknet_4_3_0_clk _653_/a_741_93# 0
C962 hold123/a_56_118# baud_inst.counter\[4\] 0.00116f
C963 _635_/a_2250_412# _632_/a_2250_412# 0
C964 net162 net46 0.15818f
C965 output15/a_40_152# rx_inst.data_reg\[4\] 0
C966 net15 hold138/a_438_182# 0.00128f
C967 clknet_4_12_0_clk _058_ 0.08686f
C968 hold182/a_438_182# _083_ 0.00154f
C969 net94 hold115/a_438_182# 0
C970 net92 hold115/a_326_118# 0
C971 rx_data[5] rx_data[6] 0.9657f
C972 baud_inst.counter\[26\] _697_/a_1840_334# 0
C973 FILLER_13_100/a_40_246# baud_inst.counter\[13\] 0.03856f
C974 net28 _235_ 0.00587f
C975 hold171/a_56_118# VPWR 0.04474f
C976 _685_/a_1583_191# net91 0
C977 net177 net156 0.05766f
C978 _230_ _228_ 0
C979 _383_/a_46_156# net38 0
C980 hold160/a_326_118# baud_inst.counter\[16\] 0.04059f
C981 net37 fanout28/a_40_152# 0
C982 net101 net40 0
C983 _637_/a_1583_191# VPWR 0.00577f
C984 hold52/a_326_118# rx_inst.state\[2\] 0
C985 FILLER_2_208/a_40_246# _664_/a_2250_412# 0
C986 clknet_4_7_0_clk _200_ 0
C987 _170_ _238_ 0.06649f
C988 net111 net47 0.01121f
C989 FILLER_8_116/a_40_246# _211_ 0
C990 baud_inst.counter\[15\] _308_ 0
C991 _638_/a_843_236# clknet_4_15_0_clk 0.00855f
C992 _694_/a_38_114# _693_/a_741_93# 0
C993 FILLER_8_116/a_40_246# _282_ 0
C994 _659_/a_843_236# tx_inst.data_reg\[5\] 0
C995 baud_inst.counter\[23\] _112_ 0
C996 fanout25/a_40_152# VPWR 0.00664f
C997 _206_ baud_inst.counter\[6\] 0
C998 _675_/a_612_127# net38 0.00887f
C999 _206_ _367_/a_170_412# 0.00156f
C1000 tx_inst.data_reg\[5\] net43 0.44868f
C1001 _043_ clkbuf_4_15_0_clk/a_27_118# 0
C1002 VPWR clkbuf_4_0_0_clk/a_27_118# 0.02481f
C1003 net179 _198_ 0.23973f
C1004 net29 _682_/a_2250_412# 0.00229f
C1005 fanout36/a_40_152# net52 0.0263f
C1006 hold86/a_56_118# net86 0.00358f
C1007 hold86/a_326_118# net181 0
C1008 hold114/a_56_118# VPWR 0.04206f
C1009 _092_ _679_/a_741_93# 0
C1010 net2 hold80/a_326_118# 0.01727f
C1011 rx hold80/a_438_182# 0.032f
C1012 net143 _157_ 0.07653f
C1013 clknet_4_8_0_clk _687_/a_681_505# 0
C1014 _652_/a_324_432# net137 0
C1015 baud_inst.counter\[20\] _538_/a_175_118# 0
C1016 VPWR net78 0.17717f
C1017 _511_/a_252_412# _183_ 0
C1018 _062_ _667_/a_741_93# 0
C1019 _517_/a_209_168# VPWR 0.00273f
C1020 baud_inst.counter\[27\] hold141/a_438_182# 0
C1021 _052_ net140 0
C1022 baud_inst.counter\[26\] hold141/a_326_118# 0.00321f
C1023 clknet_4_1_0_clk net95 0
C1024 clkbuf_4_1_0_clk/a_27_118# _382_/a_382_118# 0.00337f
C1025 _205_ net51 0.49231f
C1026 net177 _180_ 0
C1027 _657_/a_38_114# _070_ 0.03082f
C1028 hold153/a_56_118# clknet_0_clk 0.00333f
C1029 _650_/a_1840_334# _668_/a_324_432# 0
C1030 _650_/a_1583_191# _668_/a_741_93# 0
C1031 net18 net65 0
C1032 _023_ _105_ 0
C1033 _500_/a_155_412# _283_ 0.00662f
C1034 _500_/a_257_140# net92 0.00439f
C1035 net40 _682_/a_843_236# 0.00206f
C1036 _528_/a_379_118# _296_ 0.00137f
C1037 _265_ _639_/a_1840_334# 0.01226f
C1038 _129_ _639_/a_1583_191# 0.0056f
C1039 net8 VPWR 0.0105f
C1040 hold181/a_326_118# _181_ 0
C1041 hold181/a_438_182# net60 0.00109f
C1042 hold99/a_438_182# _697_/a_843_236# 0
C1043 _488_/a_209_168# net6 0
C1044 _277_ net2 0.00631f
C1045 _555_/a_209_168# _702_/a_298_337# 0
C1046 FILLER_21_192/a_40_246# _043_ 0.00208f
C1047 _220_ _667_/a_1489_191# 0
C1048 rx_inst.data_reg\[1\] clknet_4_14_0_clk 0.0517f
C1049 clknet_4_3_0_clk _652_/a_1583_191# 0.0016f
C1050 _527_/a_192_429# net160 0
C1051 hold136/a_438_182# baud_inst.counter\[9\] 0
C1052 net42 _667_/a_550_127# 0
C1053 _227_ net25 0.00276f
C1054 _013_ _515_/a_170_160# 0.00436f
C1055 net44 _691_/a_741_93# 0.00401f
C1056 _168_ _647_/a_843_236# 0
C1057 net60 FILLER_0_54/a_40_246# 0.00982f
C1058 _662_/a_1840_334# net41 0
C1059 hold151/a_438_182# _135_ 0.00597f
C1060 hold151/a_326_118# net151 0.03419f
C1061 _035_ _282_ 0
C1062 _515_/a_170_160# baud_inst.counter\[14\] 0
C1063 _449_/a_27_156# _262_ 0
C1064 net35 hold180/a_438_182# 0
C1065 clk _656_/a_1489_191# 0.00208f
C1066 _053_ clknet_4_9_0_clk 0
C1067 net133 _313_ 0.04779f
C1068 _664_/a_324_432# _005_ 0.04717f
C1069 _664_/a_298_337# tx_inst.state\[2\] 0
C1070 baud_inst.counter\[6\] hold92/a_56_118# 0.02597f
C1071 net37 _667_/a_1840_334# 0
C1072 baud_inst.counter\[30\] hold58/a_326_118# 0.00252f
C1073 baud_inst.counter\[31\] hold58/a_438_182# 0.00115f
C1074 net123 _205_ 0
C1075 _518_/a_45_160# _163_ 0.00206f
C1076 _678_/a_38_114# _352_/a_46_156# 0.00718f
C1077 net150 net47 0.01634f
C1078 _655_/a_324_432# net38 0.02654f
C1079 _652_/a_298_337# baud_inst.counter\[5\] 0
C1080 _191_ net130 0.00146f
C1081 clknet_0_clk clkbuf_4_14_0_clk/a_27_118# 0.04902f
C1082 net140 FILLER_20_95/a_40_246# 0.03138f
C1083 _526_/a_350_122# _300_ 0
C1084 _055_ FILLER_25_150/a_32_246# 0
C1085 net44 _641_/a_38_114# 0.01411f
C1086 _112_ net114 0.35248f
C1087 _556_/a_192_429# _551_/a_76_160# 0
C1088 _675_/a_741_93# baud_inst.counter\[3\] 0
C1089 _678_/a_324_432# hold94/a_438_182# 0
C1090 _339_/a_308_118# clknet_0_clk 0
C1091 _143_ _652_/a_38_114# 0
C1092 _219_ net27 0
C1093 net79 _673_/a_550_127# 0
C1094 _059_ _648_/a_1489_191# 0
C1095 _657_/a_324_432# clknet_4_1_0_clk 0.02856f
C1096 net50 _202_ 0
C1097 _677_/a_1840_334# _089_ 0
C1098 VPWR _689_/a_681_505# 0
C1099 FILLER_19_132/a_40_246# _454_/a_155_412# 0
C1100 VPWR clkbuf_4_5_0_clk/a_27_118# 0.05363f
C1101 hold55/a_56_118# FILLER_8_236/a_40_246# 0.00786f
C1102 _499_/a_209_168# _182_ 0
C1103 _696_/a_2250_412# _025_ 0.00325f
C1104 _696_/a_612_127# net141 0
C1105 _315_ _550_/a_209_168# 0.00157f
C1106 _360_/a_295_385# _067_ 0
C1107 _360_/a_71_118# tx_inst.data_reg\[2\] 0.05271f
C1108 _360_/a_1453_124# clknet_4_4_0_clk 0.00377f
C1109 _173_ _174_ 0
C1110 hold55/a_438_182# _665_/a_1840_334# 0
C1111 _507_/a_170_412# _288_ 0.00286f
C1112 _194_ net34 0.45435f
C1113 hold153/a_56_118# _182_ 0.00184f
C1114 _663_/a_843_236# clkbuf_4_7_0_clk/a_27_118# 0.0027f
C1115 _637_/a_1840_334# net30 0
C1116 _283_ net38 0
C1117 _646_/a_741_93# net48 0.00232f
C1118 VPWR FILLER_17_162/a_32_246# 0.069f
C1119 baud_inst.counter\[20\] _694_/a_38_114# 0.03185f
C1120 hold109/a_56_118# clknet_4_2_0_clk 0.02466f
C1121 _293_ _035_ 0
C1122 _209_ _066_ 0
C1123 _648_/a_741_93# rx_inst.data_reg\[5\] 0
C1124 clknet_4_5_0_clk _654_/a_681_505# 0
C1125 _660_/a_1583_191# _065_ 0.0216f
C1126 _660_/a_843_236# tx_inst.data_reg\[0\] 0.00122f
C1127 output23/a_40_152# net2 0
C1128 tx_done input2/a_40_152# 0.00411f
C1129 net51 _671_/a_1583_191# 0.00303f
C1130 net36 _170_ 0
C1131 _059_ FILLER_27_194/a_40_246# 0
C1132 _641_/a_298_337# clknet_0_clk 0.00492f
C1133 net55 tx_data[6] 0.00917f
C1134 rx_inst.bit_index\[1\] net32 0
C1135 FILLER_21_31/a_40_246# FILLER_21_33/a_32_246# 0.0524f
C1136 VPWR _290_ 0.17702f
C1137 _549_/a_155_412# clknet_0_clk 0.00555f
C1138 clknet_4_5_0_clk _664_/a_2250_412# 0
C1139 hold184/a_326_118# _341_/a_1377_160# 0
C1140 clknet_4_7_0_clk _705_/a_132_114# 0
C1141 net132 hold132/a_438_182# 0.00157f
C1142 output16/a_40_152# _061_ 0
C1143 fanout25/a_40_152# _167_ 0
C1144 _555_/a_380_412# net67 0.0033f
C1145 net3 net41 0.02263f
C1146 _197_ _664_/a_298_337# 0.0016f
C1147 _288_ _682_/a_324_432# 0.01312f
C1148 _690_/a_132_114# VPWR 0
C1149 net136 _674_/a_843_236# 0
C1150 _395_/a_146_122# VPWR 0
C1151 _680_/a_843_236# hold116/a_438_182# 0
C1152 _677_/a_741_93# hold92/a_56_118# 0
C1153 _281_ net40 0.23432f
C1154 _412_/a_22_110# net29 0.0122f
C1155 fanout32/a_40_152# net29 0.00713f
C1156 hold158/a_438_182# net161 0.01132f
C1157 _690_/a_843_236# FILLER_17_24/a_32_246# 0
C1158 _642_/a_1840_334# _132_ 0.01442f
C1159 _642_/a_1583_191# clknet_4_12_0_clk 0.00668f
C1160 _225_ fanout25/a_40_152# 0
C1161 _691_/a_298_337# _692_/a_324_432# 0
C1162 net43 _199_ 0
C1163 net60 net135 0
C1164 _370_/a_154_118# net172 0.00169f
C1165 net156 net157 0.27631f
C1166 tx_data[0] FILLER_0_154/a_40_246# 0.003f
C1167 _238_ _237_ 0
C1168 net35 _137_ 0
C1169 _662_/a_741_93# _706_/a_324_432# 0
C1170 _662_/a_324_432# _706_/a_741_93# 0
C1171 output21/a_40_152# net55 0.00791f
C1172 net30 FILLER_18_210/a_32_246# 0
C1173 hold64/a_326_118# _264_ 0.00297f
C1174 net55 _384_/a_382_118# 0.01305f
C1175 net124 _648_/a_2002_114# 0
C1176 _155_ _648_/a_1489_191# 0
C1177 _244_ _251_ 0
C1178 FILLER_22_133/a_40_246# _130_ 0
C1179 _042_ _665_/a_843_236# 0
C1180 net156 _684_/a_550_127# 0
C1181 _159_ fanout47/a_40_152# 0
C1182 _067_ tx_data[6] 0
C1183 _697_/a_1583_191# VPWR 0.00585f
C1184 _286_ _282_ 0.70366f
C1185 hold56/a_438_182# _651_/a_1840_334# 0
C1186 _264_ _272_ 0.0153f
C1187 rx_inst.data_reg\[0\] _638_/a_298_337# 0
C1188 net37 _003_ 0.01635f
C1189 hold141/a_326_118# _109_ 0
C1190 fanout33/a_40_152# _665_/a_741_93# 0.00194f
C1191 _358_/a_72_436# _191_ 0.00257f
C1192 hold108/a_56_118# VPWR 0.05149f
C1193 net108 FILLER_8_63/a_40_246# 0
C1194 clknet_4_4_0_clk _653_/a_324_432# 0.0264f
C1195 net73 _265_ 0
C1196 hold182/a_56_118# net39 0.00328f
C1197 _223_ _647_/a_132_114# 0
C1198 _643_/a_843_236# clknet_4_15_0_clk 0.00135f
C1199 _339_/a_805_385# net43 0
C1200 net54 _478_/a_27_156# 0.02744f
C1201 hold121/a_56_118# _695_/a_132_114# 0
C1202 _660_/a_298_337# VPWR 0.00704f
C1203 tx_inst.bit_index\[2\] net27 0.0014f
C1204 _216_ _221_ 0.00644f
C1205 net92 net153 0
C1206 _186_ baud_inst.counter\[5\] 0
C1207 baud_inst.counter\[8\] _181_ 0.00168f
C1208 _155_ FILLER_27_194/a_40_246# 0
C1209 net65 _649_/a_843_236# 0
C1210 _646_/a_843_236# _157_ 0.012f
C1211 _041_ _004_ 0.27866f
C1212 hold58/a_56_118# _703_/a_1583_191# 0
C1213 _506_/a_155_412# FILLER_6_54/a_32_246# 0
C1214 hold110/a_438_182# _505_/a_76_160# 0
C1215 _374_/a_142_412# net51 -0
C1216 hold90/a_326_118# net90 0
C1217 net32 FILLER_22_152/a_32_246# 0
C1218 _017_ baud_inst.counter\[16\] 0.01518f
C1219 _670_/a_2002_114# net29 0
C1220 net164 clknet_4_10_0_clk 0
C1221 net34 _341_/a_886_118# 0
C1222 fanout27/a_40_152# _168_ 0
C1223 VPWR _700_/a_38_114# 0
C1224 net31 net2 0.33206f
C1225 _172_ tx_inst.data_reg\[2\] 0.00291f
C1226 _657_/a_681_505# net41 0
C1227 _277_ _169_ 0.03581f
C1228 net37 _650_/a_324_432# 0.00117f
C1229 _691_/a_324_432# _164_ 0
C1230 _691_/a_741_93# _302_ 0
C1231 hold142/a_326_118# baud_inst.counter\[25\] 0.01153f
C1232 _018_ baud_inst.counter\[19\] 0
C1233 net158 _101_ 0.23664f
C1234 _189_ _684_/a_2250_412# 0.01318f
C1235 net44 clkbuf_4_8_0_clk/a_27_118# 0
C1236 _691_/a_1583_191# _690_/a_843_236# 0
C1237 _691_/a_843_236# _690_/a_1583_191# 0
C1238 _468_/a_22_110# rx_inst.data_reg\[4\] 0
C1239 _270_ hold138/a_56_118# 0.00613f
C1240 hold141/a_56_118# VPWR 0.02385f
C1241 hold129/a_56_118# FILLER_12_82/a_32_246# 0
C1242 _231_ net180 0
C1243 _230_ _434_/a_150_412# -0
C1244 _111_ _130_ 0
C1245 _242_ net25 0
C1246 _207_ _066_ 0
C1247 net156 _298_ 0.09022f
C1248 baud_inst.counter\[22\] _535_/a_248_122# 0
C1249 _479_/a_120_432# _006_ 0
C1250 _479_/a_22_110# _275_ 0.0024f
C1251 _667_/a_741_93# net63 0
C1252 _699_/a_324_432# _701_/a_2250_412# 0
C1253 baud_inst.counter\[27\] _546_/a_341_118# 0.01783f
C1254 net173 net57 0
C1255 baud_inst.counter\[12\] net29 0.89982f
C1256 FILLER_20_57/a_32_246# VPWR 0.08287f
C1257 _114_ _029_ 0
C1258 hold76/a_438_182# _538_/a_81_118# 0
C1259 _403_/a_22_110# _141_ 0
C1260 net42 FILLER_11_123/a_40_246# 0.01449f
C1261 _448_/a_142_412# clknet_0_clk 0
C1262 _678_/a_1583_191# _090_ 0
C1263 hold158/a_56_118# VPWR 0.00884f
C1264 _657_/a_324_432# _147_ 0.01627f
C1265 _657_/a_741_93# _068_ 0.00192f
C1266 _469_/a_22_110# _264_ 0.00124f
C1267 _109_ _013_ 0.00203f
C1268 clknet_4_9_0_clk hold91/a_326_118# 0.00345f
C1269 _206_ FILLER_0_117/a_32_246# 0.01276f
C1270 net26 _668_/a_741_93# 0
C1271 FILLER_18_148/a_40_246# clknet_0_clk 0.00115f
C1272 _109_ baud_inst.counter\[14\] 0
C1273 net49 _440_/a_244_412# 0.0061f
C1274 _292_ _684_/a_1489_191# 0.01793f
C1275 net156 _188_ 0.78771f
C1276 _644_/a_298_337# FILLER_26_151/a_32_246# 0
C1277 _638_/a_612_127# clknet_4_15_0_clk 0
C1278 _694_/a_324_432# _693_/a_2250_412# 0
C1279 _694_/a_741_93# _693_/a_1840_334# 0
C1280 _645_/a_324_432# net150 0
C1281 net131 _633_/a_298_337# 0.00104f
C1282 net36 _263_ 0.05314f
C1283 _021_ fanout44/a_40_152# 0
C1284 hold168/a_56_118# _076_ 0
C1285 clknet_4_14_0_clk _251_ 0
C1286 tx_inst.data_reg\[1\] FILLER_3_141/a_40_246# 0
C1287 _143_ _653_/a_843_236# 0.00854f
C1288 _642_/a_2250_412# _451_/a_155_412# 0
C1289 net6 clkbuf_4_1_0_clk/a_27_118# 0
C1290 net182 baud_inst.counter\[12\] 0
C1291 net37 FILLER_14_164/a_32_246# 0
C1292 baud_inst.counter\[28\] clknet_4_10_0_clk 0.02884f
C1293 clkload3/Y clkbuf_4_15_0_clk/a_27_118# 0
C1294 _488_/a_209_168# _287_ 0
C1295 rx_inst.bit_index\[1\] hold175/a_438_182# 0.01374f
C1296 net36 hold175/a_326_118# 0
C1297 _545_/a_146_122# _310_ 0.00211f
C1298 _550_/a_209_168# hold106/a_438_182# 0
C1299 _550_/a_380_412# hold106/a_56_118# 0
C1300 net36 _237_ 0
C1301 net92 _280_ 0
C1302 net41 _150_ 0.54776f
C1303 _071_ _208_ 0
C1304 baud_inst.counter\[20\] baud_inst.counter\[23\] 0.38451f
C1305 hold184/a_56_118# _217_ 0
C1306 hold184/a_326_118# _195_ 0
C1307 _640_/a_38_114# net100 0
C1308 _040_ net11 0
C1309 _650_/a_2250_412# _668_/a_1840_334# 0
C1310 hold79/a_438_182# _672_/a_1840_334# 0
C1311 tx_inst.data_reg\[0\] _120_ 0
C1312 _657_/a_1840_334# _070_ 0
C1313 _283_ _285_ 0
C1314 hold116/a_326_118# VPWR 0.00571f
C1315 net40 _682_/a_612_127# 0
C1316 _526_/a_248_122# _296_ 0
C1317 net101 _522_/a_380_412# 0
C1318 baud_inst.counter\[15\] VPWR 0.45124f
C1319 _301_ _296_ 0.19166f
C1320 net45 _304_ 0
C1321 hold144/a_56_118# _223_ 0.00355f
C1322 hold99/a_56_118# _697_/a_1489_191# 0
C1323 net94 _286_ 0.06671f
C1324 net39 net29 0.03833f
C1325 net67 _702_/a_38_114# 0.00628f
C1326 net173 _400_/a_341_118# 0
C1327 FILLER_12_89/a_40_246# net29 0.00699f
C1328 net155 _658_/a_298_337# 0
C1329 _501_/a_154_118# _286_ 0.00175f
C1330 _189_ _356_/a_350_122# -0
C1331 VPWR FILLER_12_42/a_32_246# 0.0818f
C1332 hold149/a_326_118# clknet_4_10_0_clk 0
C1333 baud_inst.counter\[2\] _672_/a_324_432# 0
C1334 _674_/a_741_93# clknet_4_0_0_clk 0.04593f
C1335 _277_ _084_ 0.02244f
C1336 hold102/a_56_118# net157 0
C1337 _636_/a_324_432# VPWR 0
C1338 net44 _691_/a_1785_429# 0
C1339 _048_ FILLER_28_204/a_32_246# 0.00153f
C1340 _632_/a_741_93# _264_ 0.04277f
C1341 _654_/a_38_114# _144_ 0.01968f
C1342 _654_/a_324_432# _065_ 0.01192f
C1343 hold96/a_326_118# _092_ 0.00367f
C1344 net108 VPWR 0.29169f
C1345 _249_ _450_/a_127_436# 0
C1346 _680_/a_324_432# hold117/a_326_118# 0
C1347 _353_/a_350_122# _182_ 0
C1348 net166 VPWR 0.06906f
C1349 _265_ net118 0.00115f
C1350 VPWR net181 0.44483f
C1351 hold111/a_438_182# _160_ 0
C1352 clk tx_inst.data_reg\[2\] 0.01569f
C1353 net26 _667_/a_38_114# 0
C1354 _461_/a_22_110# _637_/a_1583_191# 0
C1355 _673_/a_1840_334# _672_/a_1583_191# 0
C1356 _661_/a_741_93# net41 0
C1357 _664_/a_1583_191# tx_inst.state\[2\] 0.013f
C1358 _692_/a_843_236# VPWR 0.01017f
C1359 clknet_4_3_0_clk hold128/a_56_118# 0.00206f
C1360 net87 _684_/a_38_114# 0
C1361 _643_/a_324_432# _240_ 0
C1362 _678_/a_843_236# baud_inst.counter\[6\] 0.02874f
C1363 _655_/a_2250_412# net38 0
C1364 hold163/a_438_182# net103 0
C1365 baud_inst.counter\[28\] baud_inst.counter\[31\] 0.14008f
C1366 clknet_4_6_0_clk _061_ 0
C1367 rx_data[0] net69 -0
C1368 net182 net39 0.06591f
C1369 FILLER_0_163/a_32_246# net9 0.00278f
C1370 net182 FILLER_12_89/a_40_246# 0.00536f
C1371 _686_/a_1840_334# hold91/a_438_182# 0.00197f
C1372 _686_/a_843_236# net91 0
C1373 _316_ _551_/a_76_160# 0
C1374 baud_inst.counter\[21\] net75 0.02175f
C1375 _675_/a_1785_429# baud_inst.counter\[3\] 0
C1376 _216_ _652_/a_2250_412# 0
C1377 _143_ _652_/a_1840_334# 0
C1378 _704_/a_843_236# VPWR 0.00175f
C1379 _059_ rx_inst.data_reg\[5\] 0
C1380 FILLER_0_237/a_40_246# VPWR 0.15039f
C1381 _264_ _648_/a_298_337# 0
C1382 FILLER_26_88/a_40_246# net67 0.00193f
C1383 net79 clknet_4_1_0_clk 0.14953f
C1384 _373_/a_170_412# VPWR 0
C1385 _072_ _657_/a_38_114# 0
C1386 VPWR _689_/a_550_127# 0
C1387 FILLER_19_132/a_40_246# _263_ 0
C1388 _659_/a_38_114# VPWR -0
C1389 net123 FILLER_12_117/a_40_246# 0.02554f
C1390 FILLER_17_201/a_32_246# _157_ 0.00499f
C1391 FILLER_26_172/a_40_246# clkbuf_4_14_0_clk/a_27_118# 0.00185f
C1392 hold157/a_326_118# clknet_4_2_0_clk 0
C1393 _129_ FILLER_16_221/a_32_246# 0
C1394 _447_/a_379_118# VPWR 0
C1395 _360_/a_1377_160# clknet_4_4_0_clk 0.00474f
C1396 net184 _656_/a_2250_412# 0
C1397 _516_/a_165_412# net29 0.00132f
C1398 net2 _404_/a_46_156# 0.00866f
C1399 _126_ _240_ 0.00524f
C1400 clk net62 0.01957f
C1401 _302_ _106_ 0.02496f
C1402 _646_/a_1785_429# net48 0
C1403 net105 VPWR 0.21486f
C1404 net49 net52 0.00917f
C1405 baud_inst.counter\[20\] _694_/a_1840_334# 0
C1406 hold142/a_438_182# net140 0.01214f
C1407 hold142/a_326_118# baud_inst.counter\[24\] 0
C1408 net54 _664_/a_1489_191# 0
C1409 net103 _014_ 0
C1410 _648_/a_1785_429# rx_inst.data_reg\[5\] 0
C1411 _462_/a_22_110# VPWR 0
C1412 _658_/a_550_127# _148_ 0
C1413 _660_/a_612_127# tx_inst.data_reg\[0\] 0.00261f
C1414 _660_/a_1489_191# _144_ 0.01696f
C1415 _660_/a_2002_114# _065_ 0
C1416 FILLER_26_35/a_32_246# net49 0
C1417 FILLER_24_229/a_32_246# rx_inst.data_reg\[6\] 0
C1418 _264_ FILLER_21_229/a_32_246# 0.00136f
C1419 FILLER_2_81/a_32_246# net40 0
C1420 net51 _671_/a_2002_114# 0
C1421 _641_/a_1583_191# clknet_0_clk 0.0044f
C1422 _178_ hold120/a_438_182# 0
C1423 _698_/a_324_432# net99 0
C1424 net31 _169_ 0
C1425 _027_ clknet_0_clk 0.01458f
C1426 tx_inst.state\[1\] _705_/a_550_127# 0
C1427 clknet_4_7_0_clk _705_/a_1489_191# 0.00326f
C1428 _034_ baud_inst.counter\[13\] 0
C1429 rx_data[4] rx_inst.data_reg\[7\] 0
C1430 VPWR hold81/a_56_118# 0.00771f
C1431 net48 output13/a_40_152# 0
C1432 FILLER_10_14/a_40_246# VPWR 0.15611f
C1433 hold155/a_326_118# net159 0
C1434 baud_inst.counter\[20\] FILLER_21_33/a_32_246# 0.0012f
C1435 tx_inst.data_reg\[6\] _660_/a_741_93# 0.02643f
C1436 _707_/a_38_114# VPWR 0
C1437 _513_/a_341_118# clknet_0_clk 0.00322f
C1438 _646_/a_2250_412# hold143/a_56_118# 0
C1439 _646_/a_1583_191# hold143/a_438_182# 0.00237f
C1440 _114_ _535_/a_146_122# 0
C1441 _206_ _656_/a_741_93# 0
C1442 VPWR _436_/a_142_412# 0.00114f
C1443 baud_inst.counter\[21\] _701_/a_324_432# 0
C1444 hold86/a_56_118# net38 0
C1445 _074_ _119_ 0
C1446 _288_ _682_/a_2250_412# 0.01593f
C1447 _690_/a_1489_191# VPWR 0.00515f
C1448 net136 _674_/a_612_127# 0
C1449 _018_ FILLER_17_24/a_32_246# 0
C1450 _174_ FILLER_4_172/a_32_246# 0.01448f
C1451 _029_ _107_ 0
C1452 hold149/a_326_118# hold149/a_438_182# 0
C1453 _678_/a_741_93# _677_/a_843_236# 0
C1454 _678_/a_843_236# _677_/a_741_93# 0
C1455 FILLER_11_142/a_40_246# net43 0.00243f
C1456 clknet_0_clk _647_/a_1583_191# 0.00347f
C1457 FILLER_25_198/a_32_246# _648_/a_324_432# 0
C1458 rx_inst.data_reg\[0\] _049_ 0
C1459 _154_ clknet_0_clk 0.08081f
C1460 _203_ _200_ 0.00755f
C1461 net48 net24 0.11857f
C1462 _391_/a_268_412# _214_ 0
C1463 FILLER_5_156/a_32_246# tx_inst.data_reg\[2\] 0
C1464 hold123/a_326_118# net123 0.00156f
C1465 hold101/a_326_118# net156 0
C1466 VPWR _546_/a_435_412# 0
C1467 _662_/a_1840_334# _706_/a_843_236# 0
C1468 _680_/a_843_236# hold115/a_56_118# 0
C1469 clknet_4_5_0_clk FILLER_5_213/a_32_246# 0
C1470 _668_/a_843_236# FILLER_12_208/a_32_246# 0
C1471 _097_ _296_ 0
C1472 _155_ rx_inst.data_reg\[5\] 0.00555f
C1473 _699_/a_324_432# baud_inst.counter\[29\] 0.00106f
C1474 hold123/a_438_182# _191_ 0.02121f
C1475 output21/a_40_152# output22/a_40_152# 0
C1476 _636_/a_324_432# _266_ 0
C1477 FILLER_19_178/a_40_246# _433_/a_244_412# 0
C1478 _636_/a_741_93# net30 0.00243f
C1479 clknet_4_14_0_clk _648_/a_681_505# 0.00123f
C1480 FILLER_23_186/a_40_246# _649_/a_38_114# 0
C1481 clknet_4_5_0_clk _214_ 0.01009f
C1482 FILLER_4_100/a_40_246# _213_ 0
C1483 _642_/a_324_432# VPWR 0.00472f
C1484 baud_inst.counter\[22\] _693_/a_2250_412# 0
C1485 _023_ _694_/a_843_236# 0
C1486 _672_/a_1583_191# _086_ 0
C1487 _672_/a_1840_334# net40 0
C1488 _343_/a_155_412# clknet_4_4_0_clk 0
C1489 net47 clknet_4_15_0_clk 0.04123f
C1490 hold162/a_56_118# baud_inst.counter\[25\] 0.00419f
C1491 hold162/a_438_182# net99 0
C1492 _659_/a_2250_412# _339_/a_382_118# 0
C1493 net121 _303_ 0.12488f
C1494 rx_done net2 0.01346f
C1495 _671_/a_324_432# VPWR 0.00944f
C1496 FILLER_18_210/a_32_246# _647_/a_2250_412# 0.01061f
C1497 _643_/a_612_127# clknet_4_15_0_clk 0
C1498 hold131/a_56_118# _158_ 0.0073f
C1499 net58 _700_/a_843_236# 0
C1500 rx_done tx 0
C1501 _660_/a_1583_191# VPWR 0.01679f
C1502 FILLER_7_82/a_32_246# _036_ 0
C1503 hold182/a_438_182# _676_/a_324_432# 0
C1504 hold182/a_56_118# _676_/a_843_236# 0.0028f
C1505 hold182/a_326_118# _676_/a_741_93# 0.00231f
C1506 _405_/a_27_156# clknet_0_clk 0.00129f
C1507 output16/a_40_152# _156_ 0
C1508 hold143/a_438_182# net64 0.00758f
C1509 FILLER_20_198/a_40_246# clknet_0_clk 0.00102f
C1510 hold143/a_326_118# _273_ 0
C1511 VPWR _686_/a_324_432# 0
C1512 net65 _649_/a_612_127# 0
C1513 _158_ net47 0.02827f
C1514 VPWR FILLER_0_156/a_32_246# 0.06162f
C1515 _534_/a_46_156# VPWR 0.00551f
C1516 FILLER_9_70/a_40_246# _096_ 0
C1517 _652_/a_298_337# _182_ 0
C1518 _089_ baud_inst.counter\[11\] 0
C1519 baud_inst.counter\[30\] _703_/a_741_93# 0.00148f
C1520 baud_inst.counter\[31\] _703_/a_843_236# 0.01699f
C1521 VPWR _700_/a_1840_334# 0
C1522 net79 _672_/a_681_505# 0
C1523 tx_data[0] _388_/a_59_156# 0.00223f
C1524 _661_/a_1583_191# clknet_4_1_0_clk 0.01161f
C1525 FILLER_14_202/a_40_246# net2 0.0067f
C1526 hold104/a_326_118# net103 0
C1527 _657_/a_550_127# net41 0
C1528 tx_inst.data_reg\[4\] _360_/a_71_118# 0.02849f
C1529 hold137/a_438_182# baud_inst.counter\[6\] 0
C1530 _240_ _647_/a_1489_191# 0.00192f
C1531 _224_ _223_ 0.06365f
C1532 _691_/a_38_114# _103_ 0
C1533 hold126/a_438_182# clknet_4_15_0_clk 0
C1534 _044_ hold78/a_56_118# 0.00788f
C1535 hold125/a_438_182# clknet_0_clk 0.01176f
C1536 _694_/a_1840_334# _701_/a_298_337# 0.00138f
C1537 _694_/a_1583_191# _701_/a_38_114# 0
C1538 _101_ _688_/a_843_236# 0.00371f
C1539 _646_/a_38_114# clknet_4_12_0_clk 0.0257f
C1540 VPWR hold72/a_326_118# 0.00228f
C1541 hold169/a_56_118# _666_/a_38_114# 0
C1542 hold169/a_326_118# _666_/a_298_337# 0.00245f
C1543 _494_/a_165_412# net40 0
C1544 hold159/a_56_118# _209_ 0.00634f
C1545 _093_ _681_/a_1840_334# 0.00189f
C1546 hold76/a_326_118# baud_inst.counter\[23\] 0
C1547 hold76/a_56_118# baud_inst.counter\[22\] 0.01995f
C1548 _697_/a_1840_334# FILLER_20_106/a_32_246# 0
C1549 net183 clknet_0_clk 0
C1550 _160_ clknet_0_clk 0.07527f
C1551 _249_ net175 0
C1552 _462_/a_22_110# _266_ 0.02438f
C1553 _657_/a_1583_191# tx_inst.data_reg\[3\] 0.00154f
C1554 _183_ _681_/a_2250_412# 0
C1555 baud_inst.counter\[12\] _493_/a_45_160# 0
C1556 _246_ _433_/a_244_140# 0
C1557 _430_/a_170_412# rx_inst.state\[2\] 0
C1558 _635_/a_1840_334# hold84/a_326_118# 0
C1559 _138_ net78 0
C1560 _637_/a_324_432# net47 0.00207f
C1561 _635_/a_2250_412# hold84/a_56_118# 0
C1562 _635_/a_1583_191# hold84/a_438_182# 0
C1563 net2 net62 1.60975f
C1564 net133 _700_/a_132_114# 0
C1565 hold132/a_438_182# _444_/a_142_412# 0
C1566 hold132/a_326_118# _444_/a_244_412# 0
C1567 VPWR _385_/a_268_412# 0
C1568 hold87/a_326_118# net90 0
C1569 net26 fanout28/a_40_152# 0
C1570 _186_ clknet_0_clk 0.08646f
C1571 net163 _527_/a_192_429# 0
C1572 _163_ _290_ 0
C1573 net89 net156 0
C1574 net37 _456_/a_155_412# 0
C1575 net30 hold81/a_326_118# 0.03386f
C1576 hold162/a_326_118# _180_ 0.02909f
C1577 hold166/a_56_118# clkbuf_0_clk/a_116_82# 0.00423f
C1578 clknet_4_11_0_clk _703_/a_38_114# 0.00115f
C1579 net32 fanout28/a_40_152# 0
C1580 _170_ _059_ 0.03442f
C1581 hold119/a_56_118# _061_ 0
C1582 _240_ _224_ 0
C1583 hold74/a_56_118# output19/a_40_152# 0.00117f
C1584 net70 clknet_4_15_0_clk 0.05471f
C1585 _694_/a_612_127# _693_/a_1583_191# 0
C1586 _663_/a_324_432# clknet_0_clk 0.04865f
C1587 _645_/a_2250_412# net150 0.01137f
C1588 _499_/a_209_168# net152 0.00921f
C1589 _372_/a_22_110# clknet_0_clk 0.00151f
C1590 _643_/a_741_93# clknet_0_clk 0.01694f
C1591 _119_ _201_ 0.00109f
C1592 _170_ _159_ 0.15423f
C1593 _167_ _436_/a_142_412# 0.0121f
C1594 hold144/a_326_118# clknet_0_clk 0
C1595 net41 _070_ 0.14703f
C1596 _143_ _653_/a_612_127# 0.00497f
C1597 hold153/a_56_118# net152 0
C1598 _675_/a_843_236# VPWR 0.02657f
C1599 clknet_0_clk _417_/a_120_432# 0
C1600 net47 _633_/a_1489_191# 0
C1601 FILLER_22_133/a_40_246# _262_ 0
C1602 _688_/a_298_337# net161 0
C1603 tx_inst.data_reg\[4\] input9/a_40_152# 0
C1604 _680_/a_612_127# net38 0.01078f
C1605 _125_ _047_ 0.00294f
C1606 _404_/a_46_156# _169_ 0.00158f
C1607 hold121/a_326_118# _022_ 0
C1608 _673_/a_1840_334# FILLER_5_59/a_40_246# 0
C1609 _079_ clkbuf_0_clk/a_116_82# 0.00148f
C1610 hold63/a_438_182# clk 0.02704f
C1611 _028_ hold106/a_326_118# 0.00129f
C1612 baud_inst.counter\[25\] net141 0.01092f
C1613 net99 _025_ 0
C1614 _041_ fanout31/a_40_152# 0.00206f
C1615 _642_/a_741_93# _641_/a_324_432# 0
C1616 _642_/a_324_432# _641_/a_741_93# 0
C1617 _668_/a_132_114# rx_inst.state\[4\] 0
C1618 hold119/a_326_118# _264_ 0.00193f
C1619 FILLER_5_207/a_32_246# tx_inst.state\[2\] 0
C1620 _390_/a_559_412# net38 0
C1621 hold159/a_56_118# _069_ 0
C1622 _680_/a_843_236# net38 0.01448f
C1623 _300_ net160 0
C1624 _671_/a_1840_334# _459_/a_27_156# 0
C1625 net67 _702_/a_1840_334# 0.00515f
C1626 net79 hold136/a_56_118# 0
C1627 _223_ _235_ 0.00936f
C1628 _699_/a_1583_191# net99 0
C1629 _699_/a_843_236# _311_ 0
C1630 _206_ _658_/a_1840_334# 0
C1631 _674_/a_1785_429# clknet_4_0_0_clk 0.0014f
C1632 _662_/a_324_432# _200_ 0
C1633 net102 _299_ 0
C1634 _636_/a_2250_412# VPWR 0.00583f
C1635 _127_ hold72/a_326_118# 0
C1636 net39 _493_/a_45_160# 0.00125f
C1637 _671_/a_324_432# _167_ 0
C1638 _632_/a_1785_429# _264_ 0.0014f
C1639 net115 _681_/a_2250_412# 0
C1640 _653_/a_741_93# clknet_0_clk 0
C1641 hold154/a_56_118# net154 0.00836f
C1642 _422_/a_248_122# _169_ 0.00128f
C1643 net36 hold176/a_438_182# 0
C1644 _249_ _161_ 0
C1645 _072_ FILLER_0_115/a_40_246# 0.00484f
C1646 _186_ _182_ 0.52505f
C1647 _670_/a_1583_191# FILLER_11_123/a_40_246# 0
C1648 tx_inst.data_reg\[4\] _172_ 0
C1649 _377_/a_46_156# input7/a_40_152# 0
C1650 _065_ _664_/a_1489_191# 0
C1651 _217_ net168 0.2023f
C1652 clkbuf_0_clk/a_116_82# fanout26/a_40_152# 0.00194f
C1653 _683_/a_843_236# net29 0.00469f
C1654 net26 _667_/a_1840_334# 0
C1655 _170_ _155_ 0.14705f
C1656 hold148/a_326_118# _106_ 0.00802f
C1657 _673_/a_741_93# clknet_4_0_0_clk 0
C1658 _664_/a_2002_114# tx_inst.state\[2\] 0
C1659 hold162/a_326_118# net140 0
C1660 hold162/a_56_118# baud_inst.counter\[24\] 0.02378f
C1661 _692_/a_612_127# VPWR 0.00136f
C1662 _678_/a_612_127# baud_inst.counter\[6\] 0.00733f
C1663 _486_/a_358_436# net166 0.02555f
C1664 net16 FILLER_16_221/a_32_246# 0
C1665 FILLER_25_7/a_40_246# net149 0
C1666 _691_/a_324_432# hold164/a_56_118# 0
C1667 _691_/a_38_114# hold164/a_326_118# 0.00113f
C1668 _691_/a_298_337# hold164/a_438_182# 0
C1669 FILLER_4_102/a_32_246# clknet_0_clk 0
C1670 _091_ _090_ 0
C1671 _278_ _652_/a_843_236# 0
C1672 _228_ net180 0.02217f
C1673 _240_ _235_ 0.07706f
C1674 net66 _264_ 0.02983f
C1675 _686_/a_612_127# net91 0.00292f
C1676 net30 hold72/a_438_182# 0
C1677 net58 _314_ 0.06158f
C1678 _378_/a_382_118# net55 0.00222f
C1679 VPWR clknet_4_9_0_clk 1.17159f
C1680 _132_ _450_/a_127_96# 0
C1681 _264_ _648_/a_1583_191# 0.0373f
C1682 _643_/a_1583_191# rx_inst.data_reg\[0\] 0
C1683 net42 net146 0
C1684 net182 _676_/a_843_236# 0
C1685 FILLER_16_154/a_32_246# _405_/a_27_156# 0
C1686 _180_ _310_ 2.0959f
C1687 _659_/a_1840_334# VPWR 0.0014f
C1688 net27 _275_ 0.46799f
C1689 hold177/a_56_118# FILLER_14_72/a_32_246# 0
C1690 _644_/a_741_93# _158_ 0.00535f
C1691 clknet_4_10_0_clk FILLER_25_36/a_32_246# 0
C1692 net45 _700_/a_298_337# 0
C1693 _663_/a_2250_412# _121_ 0
C1694 _259_ VPWR 0.06843f
C1695 tx_inst.bit_index\[1\] clknet_4_4_0_clk 0.34438f
C1696 _012_ net29 0.013f
C1697 _045_ rx_data[1] 0
C1698 net49 FILLER_26_141/a_40_246# 0.00292f
C1699 hold130/a_326_118# fanout29/a_40_152# 0.00225f
C1700 baud_inst.counter\[21\] _695_/a_298_337# 0
C1701 net54 tx_inst.state\[2\] 0.00327f
C1702 hold161/a_56_118# net157 0.01298f
C1703 hold98/a_56_118# net116 0
C1704 hold98/a_326_118# _288_ 0.01412f
C1705 rx_data[2] hold83/a_438_182# 0
C1706 _641_/a_2002_114# clknet_0_clk 0
C1707 net36 hold180/a_326_118# 0
C1708 _645_/a_324_432# _158_ 0.00127f
C1709 net147 fanout45/a_40_152# 0
C1710 _654_/a_324_432# VPWR 0.00245f
C1711 fanout45/a_40_152# net46 0.03412f
C1712 _546_/a_341_118# FILLER_23_83/a_32_246# 0
C1713 _698_/a_2250_412# net99 0.00209f
C1714 FILLER_5_59/a_40_246# _086_ 0
C1715 hold58/a_438_182# VPWR 0.00529f
C1716 clknet_4_7_0_clk net22 0.57863f
C1717 _634_/a_1583_191# clknet_4_15_0_clk 0.03542f
C1718 tx_inst.data_reg\[6\] _660_/a_1785_429# 0
C1719 VPWR _664_/a_132_114# 0
C1720 _707_/a_1840_334# VPWR 0.00103f
C1721 net72 net126 0.00205f
C1722 _646_/a_1785_429# net143 0
C1723 FILLER_4_183/a_40_246# _664_/a_38_114# 0.00201f
C1724 clknet_0_clk _684_/a_324_432# 0.00163f
C1725 _041_ _168_ 0
C1726 net55 _665_/a_681_505# 0
C1727 _135_ FILLER_27_135/a_32_246# 0
C1728 VPWR _157_ 0.6716f
C1729 net75 _301_ 0
C1730 baud_inst.counter\[6\] _037_ 0
C1731 net39 _670_/a_741_93# 0
C1732 rx_inst.data_reg\[2\] hold78/a_438_182# 0
C1733 net136 _030_ 0.00201f
C1734 _246_ hold180/a_56_118# 0
C1735 _432_/a_146_122# net32 0
C1736 clknet_4_0_0_clk net95 0.04915f
C1737 clk rx_inst.state\[3\] 0.04553f
C1738 _690_/a_843_236# baud_inst.counter\[16\] 0
C1739 _691_/a_741_93# _692_/a_1489_191# 0
C1740 _691_/a_1840_334# _692_/a_1840_334# 0
C1741 hold87/a_56_118# net46 0.00279f
C1742 _691_/a_1583_191# _692_/a_2250_412# 0
C1743 net106 _029_ 0.12948f
C1744 _678_/a_1583_191# _677_/a_1583_191# 0
C1745 hold179/a_56_118# FILLER_2_208/a_40_246# 0.0034f
C1746 net98 _682_/a_298_337# 0.00592f
C1747 _009_ _682_/a_38_114# 0
C1748 hold159/a_326_118# _149_ 0
C1749 _169_ net62 0.04449f
C1750 tx_busy rx 0.08435f
C1751 hold154/a_56_118# clknet_4_3_0_clk 0
C1752 clknet_4_15_0_clk _649_/a_324_432# 0.03627f
C1753 VPWR _026_ 0.04525f
C1754 _662_/a_38_114# _119_ 0
C1755 _073_ _706_/a_38_114# 0.00238f
C1756 FILLER_13_100/a_40_246# net29 0
C1757 net87 _356_/a_248_122# 0
C1758 _518_/a_45_160# _188_ 0
C1759 _163_ baud_inst.counter\[15\] 0.00302f
C1760 net39 _288_ 0.00189f
C1761 _117_ hold50/a_56_118# 0.00874f
C1762 _639_/a_1840_334# _668_/a_2250_412# 0
C1763 _639_/a_2250_412# _668_/a_1840_334# 0
C1764 _636_/a_1785_429# net30 0
C1765 _636_/a_2250_412# _266_ 0.00236f
C1766 clknet_4_14_0_clk _648_/a_550_127# 0
C1767 tx_inst.bit_index\[0\] clknet_4_6_0_clk 0.00691f
C1768 _642_/a_2250_412# VPWR 0.0027f
C1769 hold53/a_438_182# net53 0.00725f
C1770 VPWR _212_ 0.07752f
C1771 tx_inst.data_reg\[4\] clk 0.09145f
C1772 _682_/a_324_432# clknet_4_2_0_clk 0.00694f
C1773 net48 net30 0.15058f
C1774 net151 _161_ 0
C1775 _154_ FILLER_26_172/a_40_246# 0
C1776 net33 _665_/a_1489_191# 0
C1777 _310_ net140 0.06484f
C1778 net141 baud_inst.counter\[24\] 0.16637f
C1779 _481_/a_22_110# net41 0
C1780 _141_ clkbuf_4_4_0_clk/a_27_118# 0
C1781 tx_inst.data_reg\[5\] _339_/a_71_118# 0.02798f
C1782 _163_ net108 0
C1783 FILLER_13_89/a_40_246# baud_inst.counter\[13\] 0.00614f
C1784 _231_ net37 0.00524f
C1785 FILLER_24_218/a_40_246# net65 0.02384f
C1786 _392_/a_285_412# net41 0
C1787 _392_/a_382_118# _071_ 0
C1788 _671_/a_2250_412# VPWR 0.01017f
C1789 hold161/a_56_118# _298_ 0
C1790 net49 _690_/a_324_432# 0.00344f
C1791 _358_/a_166_436# VPWR 0.00134f
C1792 hold177/a_438_182# _519_/a_81_118# 0
C1793 hold88/a_56_118# hold177/a_326_118# 0.00583f
C1794 _267_ _638_/a_38_114# 0
C1795 _660_/a_2002_114# VPWR 0
C1796 FILLER_7_146/a_32_246# _653_/a_1583_191# 0
C1797 FILLER_13_137/a_32_246# net63 0.01475f
C1798 FILLER_16_166/a_32_246# net29 0
C1799 _635_/a_843_236# FILLER_19_228/a_40_246# 0
C1800 net34 _220_ 0.02688f
C1801 net118 _668_/a_324_432# 0
C1802 VPWR _686_/a_2250_412# 0.00416f
C1803 _637_/a_324_432# _634_/a_1583_191# 0
C1804 _632_/a_298_337# net65 0.00226f
C1805 net144 _157_ -0
C1806 net48 _647_/a_324_432# 0.04749f
C1807 FILLER_25_198/a_32_246# net124 0.0112f
C1808 hold168/a_438_182# clkbuf_4_5_0_clk/a_27_118# 0.00224f
C1809 rx_inst.bit_index\[2\] _243_ 0.20277f
C1810 _348_/a_248_122# _066_ 0
C1811 _364_/a_257_140# _197_ 0
C1812 baud_inst.counter\[26\] baud_inst.counter\[31\] 0
C1813 _175_ tx_inst.bit_index\[2\] 0
C1814 net39 _682_/a_681_505# 0
C1815 hold183/a_326_118# clknet_4_6_0_clk 0
C1816 net182 FILLER_13_100/a_40_246# 0.00219f
C1817 _177_ baud_inst.counter\[28\] 0.00902f
C1818 baud_inst.counter\[31\] _703_/a_612_127# 0
C1819 VPWR _478_/a_27_156# 0.00821f
C1820 _689_/a_38_114# _525_/a_268_412# 0
C1821 _661_/a_132_114# _072_ 0
C1822 _661_/a_741_93# tx_inst.data_reg\[7\] 0.00551f
C1823 net135 FILLER_6_54/a_32_246# 0
C1824 net26 _650_/a_324_432# 0.00186f
C1825 _129_ _047_ 0
C1826 hold174/a_56_118# clknet_4_4_0_clk 0
C1827 FILLER_5_213/a_32_246# _199_ 0.01596f
C1828 hold104/a_326_118# net101 0.00185f
C1829 _691_/a_1840_334# _103_ 0
C1830 hold179/a_56_118# _654_/a_1583_191# 0
C1831 _488_/a_209_168# net181 0
C1832 net94 _680_/a_1583_191# 0.001f
C1833 _118_ hold172/a_438_182# 0.00133f
C1834 _198_ _665_/a_38_114# 0.00205f
C1835 hold165/a_438_182# tx_inst.data_reg\[0\] 0.00187f
C1836 _652_/a_298_337# net43 0
C1837 _101_ _688_/a_612_127# 0
C1838 _646_/a_1840_334# clknet_4_12_0_clk 0
C1839 _314_ _027_ 0.00314f
C1840 net32 _427_/a_146_122# 0.00528f
C1841 net114 _701_/a_1583_191# 0
C1842 fanout40/a_40_152# _688_/a_741_93# 0
C1843 hold124/a_438_182# net65 0
C1844 _655_/a_38_114# _145_ 0.02546f
C1845 _259_ _167_ 0
C1846 FILLER_8_92/a_32_246# _183_ 0
C1847 net128 _281_ 0.0039f
C1848 hold132/a_438_182# _159_ 0.04429f
C1849 hold65/a_56_118# _638_/a_324_432# 0
C1850 _550_/a_177_436# net134 0
C1851 net133 _700_/a_1489_191# 0
C1852 _028_ _700_/a_612_127# 0
C1853 _264_ hold70/a_326_118# 0.00537f
C1854 net35 clknet_4_15_0_clk 0
C1855 net2 _262_ 0.03903f
C1856 _677_/a_38_114# net40 0.00151f
C1857 net62 _084_ 0.0091f
C1858 net37 _264_ 0.00724f
C1859 clknet_4_11_0_clk _703_/a_1840_334# 0
C1860 VPWR _383_/a_46_156# 0.00824f
C1861 _650_/a_1583_191# _650_/a_2250_412# 0
C1862 _241_ FILLER_18_158/a_40_246# 0
C1863 hold77/a_56_118# _470_/a_120_432# 0
C1864 _246_ _229_ 0.28666f
C1865 _107_ _693_/a_1840_334# 0.00293f
C1866 _266_ _157_ 0.35512f
C1867 _663_/a_2250_412# clknet_0_clk 0
C1868 hold131/a_438_182# net78 0.00123f
C1869 _216_ _651_/a_324_432# 0
C1870 baud_inst.counter\[12\] FILLER_14_72/a_32_246# 0.00222f
C1871 rx_inst.state\[2\] net29 0.0036f
C1872 _643_/a_1785_429# clknet_0_clk 0.00181f
C1873 net12 clknet_4_13_0_clk 0
C1874 net26 FILLER_14_164/a_32_246# 0
C1875 _167_ _157_ 0.08275f
C1876 _284_ _282_ 0
C1877 _113_ hold134/a_56_118# 0.00874f
C1878 clknet_4_12_0_clk net175 0.00325f
C1879 _675_/a_612_127# VPWR 0.01045f
C1880 clknet_0_clk _140_ 0
C1881 _168_ FILLER_14_185/a_32_246# 0
C1882 net33 _201_ 0
C1883 FILLER_4_108/a_40_246# _382_/a_59_156# 0
C1884 FILLER_16_70/a_40_246# net46 0
C1885 _249_ _647_/a_298_337# 0
C1886 _157_ _647_/a_741_93# 0.00704f
C1887 _044_ _633_/a_298_337# 0.028f
C1888 hold56/a_326_118# _142_ 0
C1889 rx_inst.state\[3\] net2 0.00133f
C1890 _698_/a_1840_334# net140 0
C1891 net48 _448_/a_244_140# 0
C1892 _052_ _697_/a_1583_191# 0.0108f
C1893 _641_/a_132_114# net142 0
C1894 _216_ net169 0.00611f
C1895 _642_/a_843_236# _641_/a_1840_334# 0
C1896 clknet_4_12_0_clk _273_ 0.01193f
C1897 _660_/a_1489_191# net179 0.00401f
C1898 clknet_4_5_0_clk hold179/a_56_118# 0.00894f
C1899 net176 _131_ 0
C1900 _046_ _636_/a_1583_191# 0.00117f
C1901 _706_/a_38_114# net41 0
C1902 hold153/a_326_118# net153 0.00728f
C1903 hold153/a_56_118# _035_ 0.00365f
C1904 net167 FILLER_15_116/a_40_246# 0.02753f
C1905 net156 _528_/a_81_118# 0.02949f
C1906 _687_/a_1785_429# _308_ 0
C1907 net49 _452_/a_155_412# 0.00159f
C1908 net79 FILLER_0_40/a_40_246# 0.00274f
C1909 _657_/a_324_432# FILLER_3_123/a_32_246# 0
C1910 hold172/a_56_118# VPWR 0.00487f
C1911 _519_/a_379_118# _296_ 0
C1912 _671_/a_2250_412# _266_ 0.00221f
C1913 _555_/a_474_130# net68 0
C1914 hold88/a_438_182# _296_ 0
C1915 net12 net65 0
C1916 _675_/a_741_93# net60 0
C1917 _675_/a_324_432# _181_ 0
C1918 net178 _688_/a_1785_429# 0
C1919 FILLER_24_229/a_32_246# hold70/a_56_118# 0
C1920 _090_ _281_ 0
C1921 net51 _161_ 0
C1922 net49 clknet_0_clk 0.25994f
C1923 _654_/a_1489_191# tx_inst.data_reg\[0\] 0
C1924 _361_/a_248_122# net184 0
C1925 net45 _546_/a_192_429# 0
C1926 hold119/a_56_118# _156_ 0
C1927 hold171/a_326_118# net171 0.00156f
C1928 _679_/a_843_236# _037_ 0.00888f
C1929 _679_/a_1583_191# net29 0
C1930 _478_/a_27_156# FILLER_7_234/a_32_246# 0.00761f
C1931 _234_ _416_/a_248_122# 0
C1932 _642_/a_1840_334# _260_ 0
C1933 _107_ FILLER_24_19/a_40_246# 0.00356f
C1934 _676_/a_1583_191# _142_ 0
C1935 net55 tx_data[4] 0.00215f
C1936 _065_ tx_inst.state\[2\] 0
C1937 net18 _637_/a_1583_191# 0.0232f
C1938 _683_/a_612_127# net29 0.00368f
C1939 hold183/a_56_118# tx_inst.bit_index\[2\] 0
C1940 net42 _676_/a_1583_191# 0
C1941 VPWR _475_/a_170_412# 0.00251f
C1942 _673_/a_1785_429# clknet_4_0_0_clk 0
C1943 hold173/a_326_118# net183 0
C1944 net183 net43 0
C1945 _344_/a_354_412# baud_inst.counter\[26\] 0.00391f
C1946 _232_ _447_/a_379_118# 0.00355f
C1947 _448_/a_550_140# _259_ 0
C1948 hold63/a_438_182# _169_ 0
C1949 _265_ net80 0.41832f
C1950 net164 VPWR 0.09415f
C1951 net93 baud_inst.counter\[6\] 0.01247f
C1952 _292_ baud_inst.counter\[9\] 0
C1953 _511_/a_252_412# _182_ 0
C1954 _411_/a_115_308# rx_inst.state\[3\] 0.00114f
C1955 VPWR FILLER_25_141/a_32_246# 0.08627f
C1956 clknet_4_1_0_clk hold94/a_56_118# 0.00844f
C1957 VPWR _687_/a_741_93# 0.03438f
C1958 hold178/a_326_118# net178 0.00156f
C1959 net74 _636_/a_681_505# 0
C1960 _663_/a_1489_191# _666_/a_2250_412# 0
C1961 _080_ _278_ 0
C1962 _655_/a_324_432# VPWR 0.01722f
C1963 hold74/a_326_118# net48 0.01299f
C1964 _178_ _703_/a_324_432# 0
C1965 net31 _413_/a_170_412# 0
C1966 _206_ net55 5.09092f
C1967 _097_ _294_ 0
C1968 clknet_4_12_0_clk _161_ 0.0187f
C1969 _264_ _648_/a_2002_114# 0
C1970 _663_/a_324_432# net43 0.00232f
C1971 hold88/a_56_118# net128 0
C1972 hold88/a_326_118# baud_inst.counter\[12\] 0.00157f
C1973 _057_ net25 0
C1974 _372_/a_22_110# net43 0
C1975 _644_/a_1785_429# _158_ 0.00115f
C1976 baud_inst.counter\[13\] net46 0.00192f
C1977 hold166/a_438_182# net49 0
C1978 baud_inst.counter\[21\] _303_ 0
C1979 _646_/a_1583_191# net64 0.00112f
C1980 VPWR _688_/a_681_505# 0
C1981 VPWR _162_ 0.17063f
C1982 _193_ tx_inst.data_reg\[2\] 0.00175f
C1983 hold57/a_326_118# net56 0.02877f
C1984 hold142/a_438_182# _697_/a_298_337# 0
C1985 net136 _039_ 0
C1986 _652_/a_298_337# net152 0
C1987 _292_ hold109/a_438_182# 0
C1988 FILLER_15_185/a_32_246# _153_ 0.00116f
C1989 baud_inst.counter\[23\] _695_/a_681_505# 0
C1990 baud_inst.counter\[22\] _695_/a_843_236# 0.04123f
C1991 net49 _692_/a_298_337# 0
C1992 _346_/a_354_412# net58 0
C1993 _346_/a_252_412# _316_ 0.0013f
C1994 baud_inst.counter\[30\] _556_/a_192_429# 0
C1995 baud_inst.counter\[28\] _556_/a_155_160# 0
C1996 _283_ VPWR 0.36005f
C1997 hold170/a_56_118# net54 0.00119f
C1998 net98 _039_ 0.00303f
C1999 _464_/a_22_110# _268_ 0.05317f
C2000 _633_/a_324_432# net77 0.00207f
C2001 _660_/a_681_505# clk 0
C2002 _645_/a_2250_412# _158_ 0.00525f
C2003 _654_/a_2250_412# VPWR 0.0042f
C2004 FILLER_8_21/a_32_246# _681_/a_741_93# 0.00112f
C2005 hold88/a_326_118# net88 0.00112f
C2006 FILLER_19_139/a_40_246# _261_ 0.01158f
C2007 rx_data[4] rx_inst.data_reg\[4\] 0
C2008 _675_/a_324_432# _088_ 0.02815f
C2009 hold153/a_326_118# _280_ 0.00432f
C2010 _411_/a_494_160# clknet_0_clk 0
C2011 _634_/a_2002_114# clknet_4_15_0_clk 0
C2012 VPWR _664_/a_1489_191# 0.00109f
C2013 _283_ _499_/a_474_130# 0.00309f
C2014 _451_/a_155_412# net24 0.00662f
C2015 _206_ _067_ 0.01086f
C2016 clknet_0_clk _684_/a_2250_412# 0.01251f
C2017 baud_inst.counter\[20\] hold147/a_56_118# 0.08688f
C2018 _361_/a_146_122# _363_/a_22_110# 0
C2019 baud_inst.counter\[28\] VPWR 0.97463f
C2020 _226_ net29 0.00474f
C2021 _651_/a_843_236# FILLER_9_169/a_32_246# 0
C2022 net92 hold93/a_438_182# 0.00716f
C2023 _283_ hold93/a_326_118# 0.00477f
C2024 _691_/a_843_236# clknet_4_10_0_clk 0
C2025 hold107/a_438_182# net107 0.0071f
C2026 _653_/a_741_93# net43 0.01558f
C2027 _663_/a_843_236# tx_inst.state\[4\] 0
C2028 _095_ _682_/a_298_337# 0.02026f
C2029 _544_/a_46_156# net46 0.00138f
C2030 net98 _682_/a_1583_191# 0
C2031 _166_ _666_/a_132_114# 0
C2032 _009_ _682_/a_1840_334# 0.00297f
C2033 _254_ _158_ 0
C2034 rx _704_/a_741_93# 0
C2035 net2 _704_/a_324_432# 0.00749f
C2036 hold119/a_326_118# _153_ 0
C2037 hold89/a_438_182# net87 0.01691f
C2038 net14 _634_/a_1489_191# 0.00106f
C2039 _551_/a_170_160# net49 0.0018f
C2040 _505_/a_170_160# _287_ 0
C2041 _200_ _366_/a_170_412# 0.00383f
C2042 _230_ _223_ 0.00126f
C2043 hold128/a_56_118# clknet_0_clk 0.01196f
C2044 _636_/a_324_432# hold73/a_326_118# 0
C2045 clknet_4_15_0_clk _649_/a_2250_412# 0.0065f
C2046 _358_/a_72_436# _184_ 0
C2047 baud_inst.counter\[14\] _684_/a_843_236# 0
C2048 _481_/a_22_110# _171_ 0.02061f
C2049 _481_/a_120_432# net26 0.00123f
C2050 tx_data[4] _389_/a_46_156# 0.00174f
C2051 _695_/a_298_337# _301_ 0
C2052 _128_ _049_ 0.00575f
C2053 _639_/a_843_236# rx_inst.state\[1\] 0.00261f
C2054 _682_/a_2250_412# clknet_4_2_0_clk 0
C2055 FILLER_15_67/a_40_246# clknet_4_8_0_clk 0
C2056 hold149/a_326_118# VPWR 0.01148f
C2057 _206_ _076_ 0.01208f
C2058 FILLER_8_118/a_32_246# _652_/a_324_432# 0
C2059 _412_/a_120_432# net26 0
C2060 _699_/a_38_114# net46 0.00209f
C2061 net33 tx_inst.state\[3\] 0.06245f
C2062 _223_ FILLER_22_175/a_32_246# 0
C2063 tx_inst.data_reg\[5\] _339_/a_1109_431# 0
C2064 net49 _164_ 0.00351f
C2065 net16 _047_ 0.03263f
C2066 _170_ fanout32/a_40_152# 0.00832f
C2067 net49 _690_/a_2250_412# 0.04642f
C2068 _412_/a_22_110# _170_ 0.02073f
C2069 hold53/a_56_118# VPWR 0.01569f
C2070 hold177/a_438_182# net128 0.00182f
C2071 FILLER_20_65/a_32_246# _308_ 0.01745f
C2072 _128_ _638_/a_1583_191# 0
C2073 _267_ _638_/a_1840_334# 0
C2074 _390_/a_59_156# _655_/a_1489_191# 0
C2075 hold154/a_56_118# baud_inst.counter\[5\] 0
C2076 rx_inst.state\[3\] _169_ 0.00856f
C2077 _637_/a_741_93# _634_/a_1489_191# 0
C2078 _637_/a_1583_191# _634_/a_2250_412# 0.00232f
C2079 _206_ _389_/a_46_156# 0.00106f
C2080 net48 _647_/a_2250_412# 0.0153f
C2081 _276_ _176_ 0
C2082 net26 net27 0.64898f
C2083 net35 _407_/a_248_122# 0
C2084 _267_ _043_ 0
C2085 VPWR _364_/a_155_412# 0.00911f
C2086 net2 net19 2.3747f
C2087 _675_/a_298_337# _087_ 0
C2088 baud_inst.counter\[31\] net59 0
C2089 net79 clknet_4_0_0_clk 0.35992f
C2090 _702_/a_741_93# _115_ 0
C2091 _702_/a_324_432# net68 0
C2092 _661_/a_1489_191# _072_ 0
C2093 _661_/a_1785_429# tx_inst.data_reg\[7\] 0
C2094 hold153/a_326_118# _191_ 0
C2095 FILLER_15_173/a_40_246# net29 0.01699f
C2096 _643_/a_298_337# hold112/a_438_182# 0
C2097 _117_ _705_/a_324_432# 0
C2098 net87 _544_/a_268_412# 0
C2099 hold144/a_56_118# hold112/a_56_118# 0
C2100 _141_ VPWR 0.1658f
C2101 FILLER_15_89/a_32_246# _180_ 0
C2102 FILLER_16_154/a_32_246# net49 0
C2103 _691_/a_1489_191# clknet_4_8_0_clk 0.0052f
C2104 _640_/a_1489_191# clknet_4_14_0_clk 0.00476f
C2105 net84 clknet_4_13_0_clk 0.01329f
C2106 _491_/a_341_118# _085_ 0
C2107 net179 _654_/a_1840_334# 0
C2108 _186_ net152 0.00924f
C2109 baud_inst.counter\[26\] _308_ 0
C2110 _677_/a_2250_412# _142_ 0.01416f
C2111 _694_/a_843_236# net107 0
C2112 hold66/a_438_182# _122_ 0.0133f
C2113 net42 _677_/a_2250_412# 0
C2114 _652_/a_1583_191# net43 0.02053f
C2115 _101_ net161 0.01108f
C2116 net83 _633_/a_2250_412# 0
C2117 hold67/a_326_118# _702_/a_324_432# 0
C2118 tx hold146/a_438_182# 0
C2119 net55 _202_ 0
C2120 rx hold51/a_438_182# 0
C2121 net2 hold51/a_326_118# 0.00204f
C2122 net163 _300_ 0
C2123 FILLER_6_205/a_40_246# _201_ 0.00334f
C2124 net177 baud_inst.counter\[15\] 0.00162f
C2125 net15 _636_/a_298_337# 0
C2126 FILLER_27_46/a_32_246# _313_ 0.0175f
C2127 net58 _703_/a_298_337# 0
C2128 _635_/a_1489_191# _264_ 0.00857f
C2129 tx_inst.data_reg\[6\] hold165/a_326_118# 0.0414f
C2130 hold91/a_438_182# net91 0.0012f
C2131 _028_ net134 0.00812f
C2132 clknet_0_clk _649_/a_38_114# 0.01104f
C2133 _640_/a_2250_412# _242_ 0
C2134 net131 clknet_0_clk 0
C2135 _646_/a_741_93# VPWR 0.02928f
C2136 baud_inst.counter\[7\] _678_/a_324_432# 0.00457f
C2137 clknet_4_3_0_clk _678_/a_741_93# 0.01169f
C2138 _179_ _549_/a_155_412# 0
C2139 net3 _656_/a_324_432# 0
C2140 _650_/a_741_93# rx_inst.data_reg\[7\] 0
C2141 hold77/a_56_118# _124_ 0.00425f
C2142 net31 _430_/a_170_412# 0
C2143 _216_ _651_/a_2250_412# 0
C2144 VPWR _703_/a_843_236# 0.00251f
C2145 _344_/a_252_412# VPWR 0
C2146 net109 net29 0.56109f
C2147 hold85/a_326_118# _156_ 0.01292f
C2148 net74 clkbuf_4_13_0_clk/a_27_118# 0
C2149 FILLER_26_88/a_40_246# _116_ 0.00167f
C2150 _178_ clkload2/Y 0.01783f
C2151 net156 hold157/a_438_182# 0.00394f
C2152 _277_ clknet_4_6_0_clk 0.01858f
C2153 clknet_4_0_0_clk net116 0.08002f
C2154 _136_ _647_/a_132_114# 0
C2155 _157_ _647_/a_1785_429# 0.00299f
C2156 hold169/a_326_118# _215_ 0
C2157 net176 _697_/a_1489_191# 0.00248f
C2158 hold126/a_56_118# net72 0
C2159 hold126/a_326_118# _048_ 0
C2160 hold147/a_438_182# _693_/a_1840_334# 0
C2161 clk _205_ 0.13777f
C2162 _294_ net90 0.07753f
C2163 _642_/a_38_114# net176 0.00414f
C2164 clknet_4_12_0_clk _641_/a_298_337# 0
C2165 _053_ _641_/a_324_432# 0
C2166 _642_/a_324_432# _052_ 0
C2167 _036_ net153 0
C2168 _304_ _105_ 0.00882f
C2169 _650_/a_1583_191# _264_ 0
C2170 net120 _694_/a_741_93# 0
C2171 _341_/a_295_385# tx_inst.data_reg\[2\] 0
C2172 _341_/a_382_118# clknet_4_4_0_clk 0.05588f
C2173 _705_/a_324_432# net11 0
C2174 _177_ FILLER_20_65/a_32_246# 0
C2175 net49 hold106/a_326_118# 0.00127f
C2176 net45 clknet_4_8_0_clk 0.03268f
C2177 baud_inst.counter\[8\] _502_/a_279_412# 0
C2178 FILLER_12_171/a_40_246# _041_ 0
C2179 _228_ net37 0
C2180 _230_ _261_ 0.01869f
C2181 _538_/a_175_118# _108_ 0
C2182 tx_inst.bit_index\[1\] _386_/a_382_118# 0
C2183 net110 net29 0.02941f
C2184 _083_ _676_/a_324_432# 0
C2185 hold143/a_326_118# _160_ 0.00177f
C2186 baud_inst.counter\[13\] _685_/a_741_93# 0.00817f
C2187 _646_/a_741_93# net144 0
C2188 _675_/a_1785_429# net60 0
C2189 _675_/a_2250_412# _181_ 0
C2190 _511_/a_150_412# _291_ 0
C2191 _073_ net172 1.00793f
C2192 _487_/a_248_122# _152_ -0
C2193 _034_ net29 0.0308f
C2194 clknet_4_12_0_clk _647_/a_298_337# 0.00601f
C2195 hold99/a_438_182# clknet_4_11_0_clk 0.00225f
C2196 _289_ baud_inst.counter\[9\] 0
C2197 _435_/a_72_436# _435_/a_411_436# -0
C2198 clk _654_/a_298_337# 0.00282f
C2199 _679_/a_612_127# _037_ 0.01671f
C2200 _076_ _202_ 0.00134f
C2201 net167 _670_/a_38_114# 0
C2202 hold167/a_56_118# _670_/a_1583_191# 0
C2203 _264_ hold84/a_326_118# 0.00332f
C2204 _699_/a_324_432# _312_ 0
C2205 _699_/a_38_114# _313_ 0.03923f
C2206 clknet_4_1_0_clk baud_inst.counter\[6\] 0.03218f
C2207 hold122/a_326_118# net43 0.02332f
C2208 _098_ hold90/a_438_182# 0.00357f
C2209 net18 _637_/a_2002_114# 0
C2210 hold162/a_56_118# _697_/a_38_114# 0.02058f
C2211 hold170/a_56_118# _065_ 0
C2212 baud_inst.counter\[26\] _177_ 0.01498f
C2213 _232_ _259_ 0.27385f
C2214 _166_ clknet_0_clk 0.08183f
C2215 _421_/a_354_412# net24 0
C2216 net35 FILLER_18_158/a_40_246# 0.00133f
C2217 net49 FILLER_26_172/a_40_246# 0
C2218 hold183/a_326_118# net122 0
C2219 net74 _636_/a_550_127# 0
C2220 rx_data[7] hold73/a_438_182# 0.00174f
C2221 hold163/a_56_118# baud_inst.counter\[20\] 0.02786f
C2222 hold120/a_56_118# net49 0
C2223 tx_inst.state\[1\] tx_busy 0
C2224 hold156/a_56_118# _682_/a_324_432# 0
C2225 clknet_4_13_0_clk _635_/a_741_93# 0.06115f
C2226 _655_/a_2250_412# VPWR 0.00759f
C2227 _679_/a_2250_412# net40 0.00278f
C2228 clkbuf_4_2_0_clk/a_27_118# _684_/a_843_236# 0
C2229 hold158/a_56_118# net157 0.02573f
C2230 baud_inst.counter\[12\] _295_ 0
C2231 VPWR hold91/a_56_118# 0.00862f
C2232 net45 _021_ 0.20257f
C2233 _339_/a_1453_124# _339_/a_1377_160# -0.00501f
C2234 net92 _184_ 0.0051f
C2235 net182 _034_ 0.00965f
C2236 _663_/a_2250_412# net43 0.05718f
C2237 hold155/a_56_118# net171 0
C2238 _355_/a_354_412# baud_inst.counter\[19\] 0
C2239 _055_ _158_ 0.00937f
C2240 _077_ _166_ 0
C2241 hold134/a_438_182# _700_/a_298_337# 0
C2242 hold134/a_326_118# _700_/a_38_114# 0
C2243 _646_/a_2002_114# net64 0
C2244 VPWR _688_/a_550_127# 0
C2245 _109_ _308_ 0.00297f
C2246 _277_ net29 0.20012f
C2247 net49 _692_/a_1583_191# 0.03763f
C2248 baud_inst.counter\[23\] _695_/a_550_127# 0
C2249 baud_inst.counter\[22\] _695_/a_612_127# 0.02711f
C2250 net52 net25 0
C2251 baud_inst.counter\[31\] _032_ 0
C2252 _179_ net58 0
C2253 baud_inst.counter\[30\] _316_ 0.04336f
C2254 _230_ _452_/a_257_140# 0.00188f
C2255 _095_ _039_ 0
C2256 net37 _153_ 0.03669f
C2257 tx_inst.data_reg\[6\] _214_ 0.04169f
C2258 _036_ _280_ 0.0052f
C2259 _295_ net88 0.02749f
C2260 _483_/a_22_110# FILLER_15_162/a_40_246# 0
C2261 _203_ _369_/a_146_122# 0
C2262 _201_ _369_/a_248_122# 0
C2263 _635_/a_324_432# _122_ 0
C2264 _680_/a_741_93# _680_/a_1489_191# 0
C2265 _229_ FILLER_18_160/a_32_246# 0
C2266 FILLER_24_229/a_32_246# rx_data[6] 0
C2267 _062_ net168 0
C2268 baud_inst.counter\[12\] clknet_4_2_0_clk 0
C2269 _646_/a_741_93# _647_/a_741_93# 0.00803f
C2270 _662_/a_298_337# net55 0.0306f
C2271 VPWR tx_inst.state\[2\] 0.18073f
C2272 hold98/a_56_118# _009_ 0.02794f
C2273 net75 FILLER_21_31/a_40_246# 0.00115f
C2274 net39 _494_/a_279_412# 0
C2275 hold144/a_56_118# _136_ 0.02612f
C2276 _677_/a_741_93# clknet_4_1_0_clk 0
C2277 _012_ FILLER_14_72/a_32_246# 0.03142f
C2278 net50 net27 0.09005f
C2279 net92 FILLER_9_72/a_32_246# 0
C2280 _041_ _671_/a_38_114# 0
C2281 net28 FILLER_15_185/a_32_246# 0
C2282 _661_/a_1583_191# net165 0
C2283 _656_/a_741_93# _208_ 0
C2284 hold86/a_56_118# VPWR 0.00972f
C2285 FILLER_14_148/a_40_246# _667_/a_843_236# 0
C2286 FILLER_0_174/a_32_246# VPWR 0.0822f
C2287 net49 net43 0
C2288 _653_/a_1785_429# net43 0.00164f
C2289 _025_ _099_ 0.00285f
C2290 clknet_4_12_0_clk FILLER_18_148/a_40_246# 0
C2291 FILLER_0_128/a_40_246# net171 0.00473f
C2292 _166_ _666_/a_1489_191# 0.00361f
C2293 hold98/a_326_118# clknet_4_2_0_clk 0.00161f
C2294 _482_/a_154_118# net29 0
C2295 hold121/a_326_118# _302_ 0
C2296 _644_/a_2250_412# clknet_0_clk 0
C2297 _637_/a_1583_191# hold71/a_326_118# 0.00234f
C2298 _314_ net49 0.24247f
C2299 net2 _205_ 0.03514f
C2300 _153_ _650_/a_298_337# 0.00894f
C2301 net118 _650_/a_38_114# 0
C2302 hold141/a_438_182# hold142/a_56_118# 0.00113f
C2303 VPWR clkbuf_4_3_0_clk/a_27_118# 0.02579f
C2304 _662_/a_1489_191# _042_ 0
C2305 _040_ _706_/a_1489_191# 0
C2306 net88 clknet_4_2_0_clk 0
C2307 _295_ net39 0
C2308 baud_inst.counter\[14\] _684_/a_612_127# 0
C2309 _671_/a_298_337# _169_ 0
C2310 net7 _213_ 0.06541f
C2311 _639_/a_298_337# _264_ 0
C2312 net48 hold73/a_56_118# 0.03703f
C2313 _112_ _701_/a_324_432# 0
C2314 _674_/a_1583_191# hold60/a_56_118# 0
C2315 FILLER_4_100/a_40_246# net38 0
C2316 _634_/a_1840_334# hold82/a_56_118# 0
C2317 _634_/a_741_93# hold72/a_56_118# 0
C2318 _634_/a_1583_191# hold82/a_326_118# 0
C2319 _231_ net26 1.06494f
C2320 _226_ net122 0
C2321 _697_/a_38_114# net141 0
C2322 _699_/a_1840_334# net46 0.01281f
C2323 _222_ _400_/a_341_118# 0
C2324 _403_/a_22_110# _221_ 0
C2325 hold112/a_438_182# _133_ 0
C2326 _449_/a_27_156# net175 0
C2327 net41 net172 0
C2328 _672_/a_324_432# baud_inst.counter\[0\] 0
C2329 _672_/a_741_93# clknet_4_0_0_clk 0.03947f
C2330 net27 FILLER_5_181/a_32_246# 0.00403f
C2331 net28 hold119/a_326_118# 0.0042f
C2332 _270_ clknet_0_clk 0.02587f
C2333 _390_/a_285_412# _145_ 0
C2334 _089_ hold108/a_56_118# 0.00105f
C2335 _048_ _634_/a_132_114# 0
C2336 net17 _634_/a_741_93# 0
C2337 _632_/a_1489_191# _122_ 0.00101f
C2338 net155 _213_ 0
C2339 clk _374_/a_142_412# 0
C2340 hold124/a_56_118# clknet_4_15_0_clk 0.00174f
C2341 VPWR _197_ 0.18855f
C2342 hold182/a_438_182# clknet_4_3_0_clk 0.00236f
C2343 rx _707_/a_1583_191# 0.01999f
C2344 rx_inst.data_reg\[4\] _635_/a_324_432# 0
C2345 _359_/a_22_110# net168 0.00249f
C2346 _705_/a_741_93# _275_ 0
C2347 net39 clknet_4_2_0_clk 0.74619f
C2348 baud_inst.counter\[23\] _022_ 0
C2349 _675_/a_1583_191# _087_ 0
C2350 _438_/a_248_122# net24 0
C2351 _072_ tx_inst.data_reg\[7\] 0.01509f
C2352 net156 net40 0.1417f
C2353 tx_inst.data_reg\[4\] _193_ 0
C2354 hold146/a_56_118# _166_ 0.07262f
C2355 clknet_4_11_0_clk hold133/a_56_118# 0.00513f
C2356 _116_ _702_/a_1840_334# 0
C2357 clknet_4_14_0_clk rx_inst.bit_index\[0\] 0.0397f
C2358 hold179/a_326_118# tx_inst.data_reg\[0\] 0.01197f
C2359 VPWR FILLER_25_36/a_32_246# 0.0817f
C2360 FILLER_20_65/a_32_246# VPWR 0.07908f
C2361 _175_ _071_ 0
C2362 _652_/a_2002_114# net43 0
C2363 _265_ _121_ 0
C2364 _029_ _701_/a_843_236# 0.00122f
C2365 tx net21 0.18938f
C2366 hold88/a_438_182# _294_ 0.01983f
C2367 hold67/a_438_182# _702_/a_1840_334# 0
C2368 _421_/a_252_412# VPWR 0
C2369 hold160/a_56_118# _301_ 0
C2370 _511_/a_150_412# baud_inst.counter\[4\] 0
C2371 _541_/a_474_130# _308_ 0.0022f
C2372 hold77/a_438_182# _648_/a_741_93# 0.00168f
C2373 hold77/a_326_118# _648_/a_843_236# 0.00189f
C2374 clknet_0_clk _649_/a_1840_334# 0
C2375 hold171/a_438_182# _206_ 0
C2376 clk FILLER_2_208/a_40_246# 0
C2377 _174_ _176_ 0.00174f
C2378 net34 net27 0.09071f
C2379 hold154/a_56_118# clknet_0_clk 0.02294f
C2380 net39 _676_/a_298_337# 0.01108f
C2381 net2 _671_/a_1583_191# 0
C2382 net48 output15/a_40_152# 0
C2383 _387_/a_46_156# net171 0.02145f
C2384 _188_ baud_inst.counter\[15\] 0
C2385 clknet_4_3_0_clk _678_/a_1785_429# 0.0035f
C2386 _671_/a_298_337# _084_ 0.03005f
C2387 VPWR _435_/a_166_436# 0
C2388 _179_ _027_ 0.0441f
C2389 hold140/a_326_118# net100 0
C2390 net3 _656_/a_2250_412# 0
C2391 _180_ net40 0.03578f
C2392 hold101/a_56_118# _690_/a_1583_191# 0
C2393 baud_inst.counter\[18\] _690_/a_324_432# 0
C2394 _650_/a_1785_429# rx_inst.data_reg\[7\] 0
C2395 _489_/a_494_160# net86 0
C2396 _663_/a_741_93# _078_ 0
C2397 _260_ _450_/a_127_96# 0
C2398 net31 _253_ 0.01702f
C2399 net39 _683_/a_298_337# 0
C2400 hold124/a_326_118# _637_/a_38_114# 0
C2401 hold124/a_56_118# _637_/a_324_432# 0
C2402 FILLER_23_204/a_40_246# net71 0
C2403 baud_inst.counter\[26\] VPWR 0.28869f
C2404 net4 net6 0.0131f
C2405 output13/a_40_152# VPWR 0.08438f
C2406 _421_/a_252_412# _239_ 0
C2407 FILLER_1_30/a_32_246# _033_ 0
C2408 _339_/a_382_118# VPWR 0
C2409 _269_ _650_/a_1583_191# 0
C2410 _637_/a_298_337# _271_ 0
C2411 _170_ _433_/a_142_412# 0.00134f
C2412 hold163/a_326_118# _104_ 0
C2413 _680_/a_612_127# VPWR 0.00103f
C2414 net31 net29 0.49712f
C2415 _539_/a_45_160# baud_inst.counter\[23\] 0.00162f
C2416 clknet_4_12_0_clk _641_/a_1583_191# 0.00733f
C2417 FILLER_0_154/a_40_246# net165 0
C2418 _305_ _693_/a_324_432# 0
C2419 net75 _693_/a_741_93# 0
C2420 _650_/a_2002_114# _264_ 0
C2421 _341_/a_500_118# tx_inst.data_reg\[2\] 0.00399f
C2422 _341_/a_810_118# clknet_4_4_0_clk 0
C2423 _705_/a_2250_412# net11 0
C2424 hold183/a_438_182# _062_ 0.00223f
C2425 net48 hold131/a_326_118# 0.0245f
C2426 _539_/a_45_160# _100_ 0
C2427 VPWR net24 1.22215f
C2428 hold177/a_56_118# FILLER_14_70/a_40_246# 0.00786f
C2429 _633_/a_843_236# _648_/a_843_236# 0
C2430 _699_/a_741_93# clknet_0_clk 0.00364f
C2431 net53 _641_/a_843_236# 0
C2432 baud_inst.counter\[23\] _108_ 0.09165f
C2433 _350_/a_279_412# net116 0
C2434 _350_/a_165_412# _039_ 0
C2435 _083_ _676_/a_2250_412# 0
C2436 _232_ FILLER_25_141/a_32_246# 0
C2437 _680_/a_843_236# VPWR 0.00515f
C2438 net145 _143_ 0
C2439 baud_inst.counter\[13\] _685_/a_1785_429# 0
C2440 hold164/a_56_118# net49 0.00179f
C2441 _390_/a_559_412# VPWR 0
C2442 FILLER_7_176/a_32_246# net168 0
C2443 net48 _054_ 0.00128f
C2444 _651_/a_1583_191# clknet_0_clk 0
C2445 fanout43/a_40_152# _374_/a_244_412# 0
C2446 FILLER_15_17/a_40_246# _101_ 0.00118f
C2447 hold132/a_326_118# clknet_4_14_0_clk 0.00472f
C2448 net150 _123_ 0
C2449 _105_ FILLER_22_22/a_32_246# 0
C2450 _097_ _096_ 0
C2451 _022_ FILLER_21_33/a_32_246# 0
C2452 _678_/a_2250_412# _209_ 0
C2453 _058_ _466_/a_22_110# 0
C2454 clknet_4_12_0_clk _647_/a_1583_191# 0.00277f
C2455 clknet_4_12_0_clk _154_ 0
C2456 net51 _405_/a_27_156# 0.02087f
C2457 clk _654_/a_1583_191# 0.00168f
C2458 _663_/a_298_337# _001_ 0.0024f
C2459 baud_inst.counter\[7\] net95 0
C2460 hold154/a_56_118# _182_ 0
C2461 hold167/a_326_118# _670_/a_1489_191# 0
C2462 _676_/a_550_127# _281_ 0
C2463 _690_/a_1489_191# _298_ 0
C2464 _699_/a_1840_334# _313_ 0
C2465 FILLER_5_164/a_40_246# _341_/a_1377_160# 0
C2466 net45 hold149/a_56_118# 0.03863f
C2467 clknet_4_3_0_clk FILLER_5_84/a_40_246# 0
C2468 _089_ net108 0
C2469 _205_ _169_ 0.00126f
C2470 net13 FILLER_28_204/a_32_246# 0.01345f
C2471 _239_ net24 0.58787f
C2472 _177_ net59 0
C2473 hold56/a_438_182# net27 0.05128f
C2474 tx_inst.bit_index\[1\] hold173/a_438_182# 0
C2475 _091_ _382_/a_59_156# 0
C2476 net183 _476_/a_146_122# 0
C2477 tx_inst.state\[1\] _704_/a_741_93# 0
C2478 clknet_4_7_0_clk _704_/a_843_236# 0.05076f
C2479 _305_ _535_/a_248_122# -0
C2480 _112_ net113 0.00159f
C2481 hold54/a_438_182# net21 0.00261f
C2482 hold156/a_326_118# _682_/a_1840_334# 0
C2483 hold121/a_56_118# _692_/a_1583_191# 0.0024f
C2484 net85 clknet_4_13_0_clk 0.043f
C2485 hold137/a_56_118# clknet_4_4_0_clk 0.00586f
C2486 _268_ _049_ 0
C2487 tx_data[2] _384_/a_285_118# 0
C2488 _077_ _665_/a_612_127# 0.00155f
C2489 net97 _505_/a_76_160# 0.00497f
C2490 baud_inst.counter\[11\] net40 0
C2491 _351_/a_46_156# net29 0.00693f
C2492 clknet_4_12_0_clk FILLER_20_198/a_40_246# 0.01592f
C2493 _286_ _186_ 0.00312f
C2494 net55 _380_/a_559_412# 0.00183f
C2495 FILLER_13_89/a_40_246# net29 0.00301f
C2496 _658_/a_38_114# clknet_4_1_0_clk 0.01436f
C2497 hold102/a_56_118# net40 0
C2498 clkbuf_4_7_0_clk/a_27_118# _668_/a_843_236# 0
C2499 FILLER_23_143/a_32_246# _161_ 0
C2500 hold109/a_326_118# _509_/a_155_412# 0
C2501 VPWR _438_/a_146_122# 0
C2502 clk _391_/a_268_412# 0
C2503 fanout37/a_40_152# net118 0
C2504 _431_/a_81_118# net48 0.00169f
C2505 _646_/a_1785_429# _266_ 0
C2506 _216_ _401_/a_120_432# 0
C2507 _398_/a_115_308# _142_ 0.00106f
C2508 _688_/a_741_93# baud_inst.counter\[16\] 0
C2509 net49 _692_/a_2002_114# 0.00101f
C2510 baud_inst.counter\[22\] net76 0.0192f
C2511 _487_/a_146_122# _200_ 0.00553f
C2512 FILLER_12_171/a_40_246# _651_/a_843_236# 0
C2513 rx_data[2] _469_/a_22_110# 0
C2514 _638_/a_38_114# _273_ 0.01112f
C2515 clknet_4_5_0_clk clk 0.59619f
C2516 clknet_4_7_0_clk _707_/a_38_114# 0.0061f
C2517 FILLER_25_198/a_32_246# _264_ 0
C2518 hold139/a_326_118# _433_/a_244_412# 0
C2519 output13/a_40_152# _266_ 0
C2520 _662_/a_1583_191# net55 0
C2521 clknet_4_6_0_clk _666_/a_38_114# 0.00124f
C2522 clknet_4_13_0_clk _650_/a_843_236# 0.01388f
C2523 FILLER_1_67/a_40_246# net40 0.01434f
C2524 net109 _288_ 0.12615f
C2525 _464_/a_120_432# net30 0.00137f
C2526 clknet_4_12_0_clk _160_ 0.11586f
C2527 hold170/a_56_118# VPWR 0.04976f
C2528 VPWR FILLER_27_210/a_40_246# 0.14392f
C2529 _675_/a_324_432# hold61/a_326_118# 0.00102f
C2530 _225_ _435_/a_166_436# 0
C2531 baud_inst.counter\[20\] net75 0.06524f
C2532 tx_inst.data_reg\[5\] _653_/a_38_114# 0
C2533 FILLER_21_33/a_32_246# _108_ 0.00177f
C2534 _644_/a_38_114# hold151/a_56_118# 0.02058f
C2535 _656_/a_2250_412# _150_ 0.00293f
C2536 tx_inst.data_reg\[2\] _380_/a_59_156# 0
C2537 _641_/a_741_93# net24 0.00173f
C2538 _680_/a_1583_191# _680_/a_2250_412# 0
C2539 net37 net28 1.65989f
C2540 _390_/a_496_118# net159 0
C2541 _090_ _677_/a_38_114# 0.01436f
C2542 net39 _677_/a_324_432# 0.03117f
C2543 _125_ output19/a_40_152# 0
C2544 _109_ VPWR 0.13089f
C2545 _694_/a_324_432# FILLER_25_25/a_40_246# 0
C2546 hold100/a_438_182# net99 0.01319f
C2547 hold100/a_56_118# baud_inst.counter\[25\] 0
C2548 _092_ net97 0
C2549 net43 _665_/a_843_236# 0.05423f
C2550 net73 _639_/a_38_114# 0
C2551 hold117/a_326_118# _681_/a_324_432# 0
C2552 _669_/a_1489_191# net29 0.00117f
C2553 _153_ _650_/a_1583_191# 0.00574f
C2554 net118 _650_/a_1840_334# 0.00695f
C2555 _674_/a_1840_334# net135 0.00358f
C2556 _674_/a_1583_191# _287_ 0
C2557 _092_ net86 0.05805f
C2558 _040_ _042_ 0.20825f
C2559 _217_ FILLER_9_169/a_32_246# 0
C2560 _166_ net43 0.05635f
C2561 _205_ _084_ 0
C2562 _167_ net24 0
C2563 net48 _060_ 0.08701f
C2564 _112_ _701_/a_2250_412# 0
C2565 _643_/a_741_93# clknet_4_12_0_clk 0.03311f
C2566 _171_ net172 0.04657f
C2567 _158_ _472_/a_120_432# 0
C2568 clknet_4_12_0_clk hold144/a_326_118# 0.00109f
C2569 net110 _288_ 0.00264f
C2570 net44 _538_/a_175_118# 0.00148f
C2571 _459_/a_27_156# _000_ 0.04339f
C2572 tx_inst.data_reg\[5\] _172_ 0
C2573 _404_/a_46_156# net29 0
C2574 net168 FILLER_8_191/a_32_246# 0.02098f
C2575 _102_ net160 0
C2576 _644_/a_2250_412# FILLER_26_172/a_40_246# 0.00162f
C2577 _657_/a_324_432# _209_ 0
C2578 _143_ hold137/a_438_182# 0.0118f
C2579 net49 _249_ 0.01242f
C2580 rx_inst.state\[2\] _454_/a_155_412# 0.00666f
C2581 _672_/a_2250_412# baud_inst.counter\[0\] 0.00284f
C2582 baud_inst.counter\[6\] hold94/a_438_182# 0
C2583 net28 _650_/a_298_337# 0.03111f
C2584 hold66/a_326_118# clknet_4_15_0_clk 0
C2585 net159 _145_ 0
C2586 fanout33/a_40_152# _275_ 0
C2587 _219_ clknet_4_4_0_clk 0
C2588 net72 _634_/a_550_127# 0
C2589 _048_ _634_/a_1489_191# 0
C2590 net17 _634_/a_1785_429# 0
C2591 _660_/a_324_432# _206_ 0.02566f
C2592 _431_/a_81_118# _250_ 0.00135f
C2593 hold59/a_438_182# _314_ 0
C2594 baud_inst.counter\[8\] _674_/a_2250_412# 0
C2595 rx _707_/a_2002_114# 0
C2596 hold123/a_56_118# FILLER_12_128/a_40_246# 0.00786f
C2597 net2 _707_/a_1489_191# 0.0092f
C2598 clknet_4_15_0_clk _648_/a_324_432# 0
C2599 baud_inst.counter\[12\] FILLER_14_70/a_40_246# 0.0483f
C2600 hold138/a_326_118# _635_/a_1489_191# 0
C2601 _045_ hold83/a_438_182# 0
C2602 net138 _635_/a_1840_334# 0
C2603 _537_/a_341_118# _305_ 0.00731f
C2604 net50 hold50/a_326_118# 0.01159f
C2605 net158 _299_ -0
C2606 _398_/a_358_436# FILLER_6_151/a_40_246# 0
C2607 net21 _665_/a_324_432# 0.03932f
C2608 _394_/a_22_110# clknet_0_clk 0.0024f
C2609 hold150/a_326_118# rx_data[1] 0
C2610 net55 tx_data[0] 0.00797f
C2611 _499_/a_380_412# VPWR 0
C2612 net54 net9 0.01184f
C2613 _175_ net26 0
C2614 FILLER_8_92/a_32_246# clknet_0_clk 0
C2615 net62 clknet_4_6_0_clk 0.59452f
C2616 _422_/a_248_122# net29 0
C2617 _692_/a_741_93# _105_ 0.00192f
C2618 hold77/a_438_182# _059_ 0
C2619 _661_/a_298_337# _210_ 0.00389f
C2620 _127_ FILLER_27_210/a_40_246# 0
C2621 hold153/a_438_182# VPWR 0.00508f
C2622 _658_/a_843_236# net41 0.02681f
C2623 _158_ _648_/a_324_432# 0
C2624 hold141/a_326_118# net141 0
C2625 hold141/a_56_118# _310_ 0.00748f
C2626 net79 _093_ 0.00154f
C2627 FILLER_5_164/a_40_246# _195_ 0
C2628 VPWR hold93/a_56_118# 0.01115f
C2629 _645_/a_741_93# net48 0.00722f
C2630 _029_ _701_/a_612_127# 0.00119f
C2631 _683_/a_843_236# clknet_4_2_0_clk 0.01566f
C2632 hold182/a_438_182# baud_inst.counter\[5\] 0
C2633 _688_/a_2250_412# _684_/a_38_114# 0
C2634 _432_/a_350_122# rx_inst.state\[2\] 0
C2635 FILLER_16_166/a_32_246# _170_ 0.00457f
C2636 _125_ _636_/a_843_236# 0.00402f
C2637 hold67/a_56_118# _115_ 0.00239f
C2638 tx_inst.data_reg\[6\] hold179/a_56_118# 0
C2639 net48 _468_/a_22_110# 0
C2640 _032_ _703_/a_550_127# 0
C2641 _177_ _032_ 0
C2642 _019_ _655_/a_38_114# 0.00112f
C2643 _374_/a_142_412# _169_ 0.00641f
C2644 clknet_4_8_0_clk FILLER_17_22/a_40_246# 0.0144f
C2645 net89 baud_inst.counter\[15\] 0.12233f
C2646 _135_ net47 0.00401f
C2647 _069_ _657_/a_324_432# 0
C2648 hold153/a_56_118# _284_ 0.02171f
C2649 net39 _676_/a_1583_191# 0.00173f
C2650 net5 _148_ 0
C2651 _489_/a_115_308# hold115/a_438_182# 0
C2652 _489_/a_358_436# hold115/a_326_118# 0
C2653 hold153/a_326_118# hold93/a_438_182# 0
C2654 hold153/a_438_182# hold93/a_326_118# 0
C2655 FILLER_15_67/a_40_246# _515_/a_76_160# 0.00989f
C2656 baud_inst.counter\[18\] _164_ 0
C2657 net31 FILLER_24_156/a_32_246# 0.00109f
C2658 hold156/a_326_118# _296_ 0
C2659 _514_/a_155_412# baud_inst.counter\[13\] 0.00364f
C2660 tx_data[0] _067_ 0.00434f
C2661 _061_ rx_inst.data_reg\[7\] 0
C2662 baud_inst.counter\[18\] _690_/a_2250_412# 0.00268f
C2663 net36 _407_/a_146_122# 0
C2664 _266_ FILLER_27_210/a_40_246# 0.00155f
C2665 _178_ net58 0
C2666 _448_/a_550_140# net24 0
C2667 _653_/a_1583_191# _222_ 0
C2668 net39 _683_/a_1583_191# 0
C2669 VPWR net59 0.1147f
C2670 tx clknet_4_5_0_clk 0.00157f
C2671 net42 clkbuf_4_7_0_clk/a_27_118# 0
C2672 _098_ baud_inst.counter\[12\] 0.03371f
C2673 _639_/a_1583_191# _639_/a_2250_412# 0
C2674 _639_/a_741_93# _639_/a_1489_191# 0
C2675 FILLER_15_0/a_40_246# _296_ 0.02068f
C2676 FILLER_23_204/a_40_246# _273_ 0.01165f
C2677 _165_ net140 0
C2678 _691_/a_843_236# VPWR 0.01073f
C2679 FILLER_9_79/a_32_246# _499_/a_209_168# 0
C2680 _671_/a_1840_334# FILLER_14_185/a_32_246# 0
C2681 _637_/a_132_114# _124_ 0
C2682 _691_/a_324_432# FILLER_17_24/a_32_246# 0
C2683 _170_ _156_ 0.00204f
C2684 net46 net29 0.04998f
C2685 _159_ _633_/a_681_505# 0
C2686 hold155/a_56_118# net155 0.00201f
C2687 _307_ baud_inst.counter\[22\] 0.00147f
C2688 clknet_4_12_0_clk _641_/a_2002_114# 0
C2689 _009_ clknet_4_0_0_clk 0
C2690 _706_/a_324_432# _200_ 0.02692f
C2691 _090_ _497_/a_170_412# 0
C2692 net48 _649_/a_741_93# 0
C2693 _305_ _693_/a_2250_412# 0.02175f
C2694 net120 _107_ 0
C2695 clk tx_inst.data_reg\[5\] 0.00747f
C2696 net36 _453_/a_170_412# 0
C2697 _093_ net116 0
C2698 tx_inst.bit_index\[2\] clknet_4_4_0_clk 0.88865f
C2699 _216_ _667_/a_324_432# 0
C2700 _228_ net26 0.59744f
C2701 baud_inst.counter\[8\] net29 0
C2702 _083_ FILLER_11_125/a_32_246# 0
C2703 _633_/a_1583_191# _648_/a_1840_334# 0
C2704 _699_/a_1785_429# clknet_0_clk 0
C2705 _183_ _039_ 0.01727f
C2706 _170_ rx_inst.state\[2\] 0.00949f
C2707 net151 net49 0.02918f
C2708 _377_/a_46_156# input10/a_40_152# 0.00211f
C2709 baud_inst.counter\[15\] _310_ 0.0067f
C2710 baud_inst.counter\[14\] net141 0
C2711 _228_ net32 0
C2712 _643_/a_38_114# _273_ 0
C2713 _699_/a_612_127# hold114/a_438_182# 0
C2714 net6 net40 0.25409f
C2715 _142_ net137 0.00704f
C2716 net49 _703_/a_298_337# 0.01094f
C2717 _641_/a_324_432# VPWR 0.00163f
C2718 hold100/a_326_118# net140 0.00215f
C2719 net42 net137 0.00198f
C2720 clknet_0_clk net25 0.10934f
C2721 net62 net29 0.11443f
C2722 VPWR net30 1.21861f
C2723 net31 net122 0.00101f
C2724 _650_/a_1489_191# _156_ 0
C2725 fanout29/a_40_152# _297_ 0
C2726 _339_/a_71_118# _653_/a_741_93# 0
C2727 _449_/a_27_156# FILLER_18_148/a_40_246# 0.01151f
C2728 hold181/a_438_182# _673_/a_1840_334# 0
C2729 FILLER_27_194/a_40_246# _633_/a_324_432# 0
C2730 _245_ _426_/a_154_118# 0
C2731 _384_/a_285_118# _210_ 0.00117f
C2732 _291_ FILLER_9_70/a_40_246# 0
C2733 rx_inst.data_reg\[0\] _632_/a_38_114# 0.03716f
C2734 _183_ _682_/a_1583_191# 0
C2735 net12 _637_/a_1583_191# 0
C2736 _680_/a_324_432# _181_ 0
C2737 _657_/a_324_432# clknet_4_4_0_clk 0.00252f
C2738 net183 _274_ 0.00101f
C2739 VPWR _647_/a_324_432# 0.0291f
C2740 net53 net45 0.20737f
C2741 _388_/a_59_156# net165 0.02354f
C2742 _215_ _394_/a_120_432# 0.00784f
C2743 _678_/a_741_93# clknet_0_clk 0.02138f
C2744 clknet_4_7_0_clk _704_/a_612_127# 0.0106f
C2745 _098_ net39 0.01707f
C2746 FILLER_12_89/a_40_246# _098_ 0.01988f
C2747 output19/a_40_152# _129_ 0
C2748 hold89/a_56_118# clknet_4_8_0_clk 0
C2749 tx_data[2] _148_ 0.00915f
C2750 hold112/a_56_118# FILLER_22_175/a_32_246# 0.00404f
C2751 rx_inst.bit_index\[2\] _224_ 0.05655f
C2752 _691_/a_2250_412# baud_inst.counter\[19\] 0.01291f
C2753 _360_/a_1453_124# tx_inst.data_reg\[0\] 0
C2754 _696_/a_38_114# _024_ 0.00606f
C2755 net55 _208_ 0.02611f
C2756 _206_ _659_/a_741_93# 0.00795f
C2757 _541_/a_177_436# net162 0
C2758 hold66/a_438_182# hold111/a_56_118# 0.00113f
C2759 _112_ baud_inst.counter\[29\] 0
C2760 hold109/a_326_118# _290_ 0.02608f
C2761 _286_ _511_/a_252_412# 0.00618f
C2762 _216_ _142_ 0.0292f
C2763 net26 _153_ 0.2789f
C2764 net146 net172 0.00138f
C2765 _152_ _200_ 0.02571f
C2766 hold156/a_56_118# net39 0.01975f
C2767 _698_/a_550_127# clknet_0_clk 0
C2768 net42 _216_ 0.02331f
C2769 _638_/a_1840_334# _273_ 0
C2770 clkbuf_4_4_0_clk/a_27_118# _221_ 0
C2771 net32 _153_ 0
C2772 _489_/a_494_160# net38 0
C2773 clknet_4_7_0_clk _707_/a_1840_334# 0
C2774 rx_data[4] FILLER_18_210/a_32_246# 0
C2775 net98 _095_ 0.35805f
C2776 _519_/a_175_118# _292_ 0.00293f
C2777 _043_ _273_ 0.02212f
C2778 _662_/a_2002_114# net55 0
C2779 clknet_4_6_0_clk _666_/a_1840_334# 0.00117f
C2780 hold88/a_56_118# _292_ 0
C2781 net180 _261_ 0
C2782 clknet_4_13_0_clk _650_/a_612_127# 0
C2783 hold71/a_438_182# hold72/a_56_118# 0
C2784 _236_ _161_ 0.8875f
C2785 _640_/a_324_432# net52 0
C2786 _640_/a_1583_191# _455_/a_155_412# 0
C2787 net51 _140_ 0
C2788 net38 _681_/a_843_236# 0.05172f
C2789 _064_ fanout41/a_40_152# 0
C2790 _127_ net30 0.00659f
C2791 _178_ _027_ 0.0236f
C2792 _206_ _664_/a_38_114# 0
C2793 net173 _217_ 0.02442f
C2794 _705_/a_324_432# hold50/a_56_118# 0.00186f
C2795 _246_ fanout25/a_40_152# 0.06097f
C2796 _428_/a_252_412# net24 0.00328f
C2797 _675_/a_843_236# net61 0.00315f
C2798 _706_/a_38_114# _119_ 0.03104f
C2799 _651_/a_1583_191# net43 0
C2800 _031_ _555_/a_380_412# 0.00537f
C2801 _112_ _695_/a_1583_191# 0
C2802 _067_ _208_ 0
C2803 _661_/a_324_432# net55 0.0074f
C2804 _190_ net90 0.00357f
C2805 _641_/a_1785_429# net24 0
C2806 _556_/a_155_160# _032_ 0
C2807 _556_/a_341_118# _316_ 0.0015f
C2808 _090_ _677_/a_1840_334# 0.00202f
C2809 _678_/a_741_93# _182_ 0
C2810 net43 _665_/a_612_127# 0.00129f
C2811 baud_inst.counter\[27\] net45 0.01667f
C2812 _440_/a_244_140# _056_ 0
C2813 baud_inst.counter\[20\] _532_/a_155_412# 0
C2814 _030_ _504_/a_474_130# 0
C2815 _674_/a_1489_191# _038_ 0
C2816 _270_ clkbuf_4_13_0_clk/a_27_118# 0.0261f
C2817 _448_/a_244_140# VPWR 0
C2818 FILLER_21_194/a_32_246# clknet_0_clk 0
C2819 _641_/a_324_432# _641_/a_741_93# 0
C2820 _173_ hold173/a_326_118# 0
C2821 _694_/a_38_114# _302_ 0
C2822 net4 net8 0.21434f
C2823 _129_ _636_/a_843_236# 0
C2824 baud_inst.counter\[20\] _695_/a_298_337# 0.00297f
C2825 _546_/a_435_412# _310_ 0.00228f
C2826 hold55/a_326_118# net146 0
C2827 _645_/a_38_114# net151 0.01682f
C2828 _645_/a_324_432# _135_ 0.0017f
C2829 hold181/a_438_182# _086_ 0.00224f
C2830 baud_inst.counter\[2\] hold60/a_326_118# 0.00138f
C2831 _158_ _123_ 0.02852f
C2832 _694_/a_550_127# net46 0
C2833 net3 FILLER_0_163/a_32_246# 0
C2834 baud_inst.counter\[6\] _185_ 0.04443f
C2835 net44 baud_inst.counter\[23\] 0
C2836 _032_ VPWR 0.02662f
C2837 _646_/a_1489_191# FILLER_20_198/a_40_246# 0
C2838 net30 _266_ 0.21284f
C2839 net49 net51 0.01553f
C2840 _020_ _104_ 0.26848f
C2841 net2 _450_/a_127_436# 0
C2842 _673_/a_1840_334# net135 0
C2843 baud_inst.counter\[1\] _181_ 0.01079f
C2844 _673_/a_1583_191# _287_ 0.00548f
C2845 _226_ _170_ 0.15629f
C2846 rx_inst.state\[2\] _263_ 0.06822f
C2847 _390_/a_59_156# _066_ 0
C2848 net44 _100_ 0.02001f
C2849 _179_ net49 0
C2850 _231_ hold180/a_438_182# 0
C2851 net30 _167_ 0.29297f
C2852 _499_/a_177_436# _184_ 0
C2853 _287_ hold95/a_56_118# 0
C2854 net102 net101 0.03276f
C2855 _378_/a_285_412# net38 0
C2856 _232_ _421_/a_252_412# 0
C2857 hold175/a_326_118# rx_inst.state\[2\] 0.00464f
C2858 hold135/a_326_118# baud_inst.counter\[2\] 0
C2859 _544_/a_46_156# _686_/a_1583_191# 0.00203f
C2860 clknet_4_15_0_clk _648_/a_2250_412# 0
C2861 _175_ FILLER_5_181/a_32_246# 0.01589f
C2862 net87 _301_ 0
C2863 net79 hold181/a_56_118# 0.01188f
C2864 output12/a_40_152# _267_ 0.00351f
C2865 _474_/a_22_110# _264_ 0.00113f
C2866 clk _339_/a_805_385# 0
C2867 FILLER_15_185/a_32_246# _223_ 0
C2868 hold101/a_56_118# baud_inst.counter\[17\] 0.01955f
C2869 _486_/a_115_308# VPWR 0.00611f
C2870 FILLER_13_102/a_32_246# VPWR 0.07053f
C2871 clknet_4_12_0_clk net49 0.01232f
C2872 _647_/a_324_432# _647_/a_741_93# 0
C2873 _349_/a_248_122# _037_ 0
C2874 _265_ net43 0.00123f
C2875 FILLER_16_154/a_32_246# net25 0
C2876 _658_/a_612_127# net41 0.0015f
C2877 hold154/a_56_118# net152 0
C2878 hold177/a_438_182# _292_ 0.00993f
C2879 output16/a_40_152# net19 0.01489f
C2880 _158_ _648_/a_2250_412# 0.00142f
C2881 hold137/a_326_118# clknet_0_clk 0.00146f
C2882 _685_/a_741_93# net29 0.00102f
C2883 hold74/a_326_118# VPWR 0.00495f
C2884 _139_ clknet_0_clk 0.00331f
C2885 _505_/a_76_160# net38 0
C2886 hold63/a_438_182# net29 0
C2887 _645_/a_1785_429# net48 0
C2888 _029_ net107 0.11545f
C2889 hold168/a_438_182# tx_inst.state\[2\] 0.00376f
C2890 baud_inst.counter\[8\] hold95/a_438_182# 0
C2891 _096_ _682_/a_1489_191# 0
C2892 _683_/a_612_127# clknet_4_2_0_clk 0
C2893 hold182/a_56_118# rx_inst.state\[3\] 0
C2894 _125_ _636_/a_612_127# 0
C2895 FILLER_16_221/a_32_246# _264_ 0
C2896 net44 _527_/a_435_412# 0
C2897 _343_/a_155_412# _196_ 0.0357f
C2898 clknet_4_5_0_clk _665_/a_324_432# 0.03429f
C2899 _036_ hold93/a_438_182# 0.00451f
C2900 net42 _666_/a_843_236# 0.05769f
C2901 hold116/a_56_118# baud_inst.counter\[9\] 0
C2902 FILLER_15_185/a_32_246# _240_ 0
C2903 _129_ hold81/a_438_182# 0
C2904 net124 clknet_4_15_0_clk 0
C2905 _044_ _048_ 0
C2906 _152_ _705_/a_132_114# 0
C2907 _246_ FILLER_17_162/a_32_246# 0.01979f
C2908 net98 _102_ 0
C2909 net50 _705_/a_741_93# 0
C2910 _170_ FILLER_15_173/a_40_246# 0
C2911 hold119/a_326_118# _223_ 0
C2912 _293_ baud_inst.counter\[13\] 0.02371f
C2913 rx_inst.state\[3\] clknet_4_6_0_clk 0.01137f
C2914 net48 _257_ 0.03615f
C2915 hold101/a_438_182# clknet_4_8_0_clk 0
C2916 _478_/a_27_156# _665_/a_1583_191# 0
C2917 clknet_0_clk _668_/a_324_432# 0.0021f
C2918 _075_ _078_ 0
C2919 VPWR FILLER_20_106/a_32_246# 0.07884f
C2920 _232_ net24 0.76524f
C2921 net34 _175_ 0.36981f
C2922 net133 _028_ 0.00298f
C2923 hold111/a_56_118# _635_/a_324_432# 0
C2924 hold111/a_326_118# _635_/a_38_114# 0.00113f
C2925 hold111/a_438_182# _635_/a_298_337# 0
C2926 net178 _684_/a_324_432# 0.02727f
C2927 hold133/a_326_118# net133 0.00391f
C2928 net182 _685_/a_741_93# 0
C2929 net124 _158_ 0
C2930 _638_/a_681_505# VPWR 0
C2931 _639_/a_843_236# clknet_4_13_0_clk 0.02699f
C2932 _639_/a_681_505# net81 0
C2933 _639_/a_132_114# _050_ 0
C2934 _463_/a_22_110# _649_/a_843_236# 0
C2935 tx_inst.bit_index\[1\] hold165/a_438_182# 0.00383f
C2936 _691_/a_612_127# VPWR 0.00143f
C2937 net44 FILLER_21_33/a_32_246# 0.00112f
C2938 _696_/a_298_337# _311_ 0
C2939 _696_/a_38_114# baud_inst.counter\[25\] 0
C2940 _355_/a_354_412# baud_inst.counter\[16\] 0.0035f
C2941 hold182/a_438_182# clknet_0_clk 0.00223f
C2942 hold162/a_438_182# FILLER_19_77/a_32_246# 0.00985f
C2943 _236_ clkbuf_4_14_0_clk/a_27_118# 0
C2944 _092_ net38 0.12898f
C2945 hold119/a_326_118# _240_ 0.01143f
C2946 _643_/a_132_114# net24 0
C2947 baud_inst.counter\[15\] _528_/a_81_118# 0.00231f
C2948 net23 FILLER_10_222/a_32_246# 0
C2949 hold172/a_56_118# clknet_4_7_0_clk 0
C2950 _230_ _642_/a_1489_191# 0
C2951 net53 net176 0
C2952 _658_/a_741_93# _388_/a_59_156# 0
C2953 hold109/a_56_118# net97 0.0024f
C2954 hold109/a_326_118# net108 0
C2955 hold162/a_438_182# clknet_4_8_0_clk 0.00129f
C2956 _428_/a_150_412# VPWR 0
C2957 net156 net128 0
C2958 net55 tx_data[7] 0
C2959 _643_/a_1840_334# _273_ 0.0314f
C2960 net114 hold114/a_438_182# 0
C2961 _639_/a_298_337# hold80/a_56_118# 0
C2962 _303_ _693_/a_741_93# 0
C2963 hold56/a_56_118# net168 0.00777f
C2964 _083_ clknet_4_3_0_clk 0
C2965 net49 _703_/a_1583_191# 0.02011f
C2966 FILLER_24_229/a_32_246# net69 0.01244f
C2967 _641_/a_2250_412# VPWR 0.00414f
C2968 hold57/a_56_118# net183 0
C2969 net57 _400_/a_192_429# 0
C2970 _705_/a_298_337# net172 0
C2971 _675_/a_741_93# _674_/a_38_114# 0
C2972 _656_/a_1489_191# net41 0.00126f
C2973 _675_/a_843_236# _674_/a_298_337# 0
C2974 net16 output19/a_40_152# 0.00239f
C2975 _022_ hold147/a_56_118# 0.01671f
C2976 net120 hold147/a_438_182# 0.00319f
C2977 _033_ net38 0.05567f
C2978 _675_/a_2250_412# _279_ 0
C2979 _652_/a_324_432# VPWR 0.00288f
C2980 net49 _355_/a_150_412# 0
C2981 _339_/a_1453_124# _653_/a_2250_412# 0
C2982 _339_/a_886_118# _653_/a_843_236# 0
C2983 _442_/a_248_122# net24 0
C2984 net123 hold128/a_56_118# 0
C2985 hold112/a_326_118# hold127/a_326_118# 0
C2986 _673_/a_1583_191# clkbuf_4_0_0_clk/a_27_118# 0
C2987 _148_ _210_ 0.00362f
C2988 net156 _014_ 0
C2989 _232_ _438_/a_146_122# 0
C2990 rx_inst.bit_index\[2\] FILLER_23_158/a_40_246# 0.00437f
C2991 _680_/a_2250_412# _181_ 0
C2992 _657_/a_2250_412# clknet_4_4_0_clk 0.00368f
C2993 hold128/a_326_118# _191_ 0
C2994 clknet_0_clk _667_/a_298_337# 0
C2995 VPWR _647_/a_2250_412# 0.00233f
C2996 FILLER_26_227/a_40_246# clknet_4_15_0_clk 0.00432f
C2997 baud_inst.counter\[23\] _302_ 0
C2998 _257_ _250_ 0
C2999 _388_/a_496_118# _146_ 0
C3000 _678_/a_1785_429# clknet_0_clk 0
C3001 _012_ FILLER_14_70/a_40_246# 0.00697f
C3002 _302_ _100_ 0
C3003 hold74/a_438_182# net30 0.01316f
C3004 _021_ _105_ 0.00197f
C3005 hold121/a_438_182# clknet_4_10_0_clk 0.0029f
C3006 net122 net62 0.01031f
C3007 hold59/a_56_118# _703_/a_324_432# 0.00352f
C3008 net128 _180_ 0.04215f
C3009 clkbuf_4_10_0_clk/a_27_118# baud_inst.counter\[23\] 0.01f
C3010 clknet_4_0_0_clk FILLER_5_74/a_32_246# 0
C3011 rx_inst.state\[3\] net29 0.02469f
C3012 _696_/a_324_432# _180_ 0.01731f
C3013 _339_/a_308_118# _172_ 0
C3014 _360_/a_1377_160# tx_inst.data_reg\[0\] 0.00102f
C3015 FILLER_6_191/a_32_246# clkbuf_4_5_0_clk/a_27_118# 0.01277f
C3016 input11/a_40_152# net11 0.01129f
C3017 tx_inst.data_reg\[7\] _658_/a_843_236# 0.03312f
C3018 _661_/a_1583_191# _069_ 0.00809f
C3019 net2 net175 0.21089f
C3020 _674_/a_1583_191# net181 0
C3021 _147_ _382_/a_559_412# 0
C3022 _121_ _668_/a_2250_412# 0.00273f
C3023 net42 _484_/a_154_118# 0
C3024 tx_inst.data_reg\[6\] _360_/a_71_118# 0.02717f
C3025 hold76/a_56_118# _695_/a_38_114# 0
C3026 net35 fanout35/a_40_152# 0.00803f
C3027 baud_inst.counter\[26\] _052_ 0.00998f
C3028 _089_ _162_ 0.20658f
C3029 rx_inst.bit_index\[2\] FILLER_19_139/a_40_246# 0
C3030 net45 _550_/a_380_412# 0.02628f
C3031 _673_/a_298_337# net181 0.01321f
C3032 _282_ _502_/a_279_412# 0.00182f
C3033 clkbuf_0_clk/a_116_82# VPWR 0.05088f
C3034 _638_/a_681_505# _266_ 0
C3035 tx_inst.data_reg\[1\] _653_/a_324_432# 0
C3036 _461_/a_22_110# net30 0.00255f
C3037 _535_/a_146_122# net107 0
C3038 clk FILLER_1_201/a_40_246# 0.00459f
C3039 _050_ rx_inst.data_reg\[7\] 0
C3040 net16 _636_/a_843_236# 0.00672f
C3041 rx_data[4] _636_/a_741_93# 0.00157f
C3042 _640_/a_1583_191# _130_ 0.0019f
C3043 _640_/a_2250_412# net52 0.01795f
C3044 net38 _681_/a_612_127# 0.00794f
C3045 baud_inst.counter\[12\] hold129/a_56_118# 0.01392f
C3046 clknet_4_8_0_clk _543_/a_248_122# 0
C3047 net125 _429_/a_550_140# 0
C3048 _206_ _664_/a_1840_334# 0
C3049 _675_/a_612_127# net61 0.00466f
C3050 _673_/a_843_236# _182_ 0
C3051 FILLER_26_227/a_40_246# _637_/a_324_432# 0
C3052 _112_ _695_/a_2002_114# 0
C3053 net28 net26 0.07735f
C3054 _661_/a_2250_412# net55 0.00392f
C3055 net55 clknet_4_1_0_clk 0.21752f
C3056 _098_ _012_ 0
C3057 clknet_4_8_0_clk _025_ 0
C3058 FILLER_21_147/a_40_246# VPWR 0.15688f
C3059 net120 _693_/a_298_337# 0.00509f
C3060 _052_ net24 0.0033f
C3061 tx_data[7] _389_/a_46_156# 0
C3062 hold102/a_438_182# _296_ 0.00452f
C3063 _638_/a_38_114# _154_ 0.00771f
C3064 _638_/a_324_432# net126 0
C3065 net184 net54 0.00104f
C3066 clknet_4_4_0_clk FILLER_2_183/a_32_246# 0
C3067 hold98/a_438_182# _010_ 0
C3068 _353_/a_146_122# _186_ 0
C3069 _170_ _277_ 0
C3070 net28 net32 0
C3071 _637_/a_843_236# hold70/a_326_118# 0
C3072 _637_/a_741_93# hold70/a_438_182# 0
C3073 _070_ net137 0
C3074 _079_ _667_/a_324_432# 0
C3075 _410_/a_257_140# rx_inst.state\[2\] 0.0019f
C3076 baud_inst.counter\[20\] _303_ 0.17222f
C3077 FILLER_5_84/a_40_246# clknet_0_clk 0.00671f
C3078 VPWR _221_ 0.03651f
C3079 _677_/a_2250_412# _676_/a_843_236# 0
C3080 _694_/a_1840_334# _302_ 0
C3081 net7 net38 0.00634f
C3082 baud_inst.counter\[8\] _288_ 0.0309f
C3083 _555_/a_209_168# hold114/a_56_118# 0
C3084 _026_ _310_ 0.00584f
C3085 baud_inst.counter\[26\] FILLER_20_95/a_40_246# 0.00133f
C3086 FILLER_0_42/a_32_246# _033_ 0
C3087 _360_/a_382_118# VPWR 0.0072f
C3088 _206_ FILLER_3_207/a_40_246# 0.00267f
C3089 net109 clknet_4_2_0_clk 0.00816f
C3090 _699_/a_1583_191# clknet_4_8_0_clk 0
C3091 baud_inst.counter\[27\] FILLER_21_96/a_40_246# 0
C3092 tx_inst.bit_index\[1\] _196_ 0
C3093 clk FILLER_11_142/a_40_246# 0.01599f
C3094 _423_/a_279_412# VPWR 0
C3095 _650_/a_741_93# FILLER_17_199/a_40_246# 0
C3096 _635_/a_298_337# clknet_0_clk 0.00109f
C3097 clkbuf_4_0_0_clk/a_27_118# net40 0
C3098 net145 _659_/a_741_93# 0.00301f
C3099 net168 _200_ 0.13313f
C3100 hold56/a_326_118# tx_inst.bit_index\[0\] 0.0032f
C3101 FILLER_4_100/a_40_246# VPWR 0.13213f
C3102 net2 _161_ 1.70533f
C3103 clkbuf_4_10_0_clk/a_27_118# net114 0.00928f
C3104 _696_/a_38_114# baud_inst.counter\[24\] 0.00534f
C3105 _673_/a_2002_114# _287_ 0
C3106 _436_/a_550_140# net25 0
C3107 _277_ hold62/a_56_118# 0.00206f
C3108 _483_/a_22_110# rx_inst.state\[4\] 0
C3109 net28 hold62/a_326_118# 0.00591f
C3110 FILLER_21_33/a_32_246# _302_ 0
C3111 _555_/a_380_412# _313_ 0.01703f
C3112 hold105/a_326_118# _701_/a_1583_191# 0.00263f
C3113 _663_/a_843_236# VPWR 0.00321f
C3114 _117_ _121_ 0.04496f
C3115 _643_/a_681_505# VPWR 0
C3116 tx_inst.data_reg\[7\] _656_/a_132_114# 0
C3117 FILLER_8_92/a_32_246# net152 0
C3118 _234_ fanout32/a_40_152# 0.026f
C3119 net155 net38 0.76465f
C3120 _266_ _647_/a_2250_412# 0.00744f
C3121 _641_/a_2250_412# _225_ 0
C3122 _025_ _686_/a_1840_334# 0
C3123 _310_ _686_/a_2250_412# 0.00165f
C3124 hold109/a_56_118# clkbuf_4_2_0_clk/a_27_118# 0.00154f
C3125 FILLER_13_100/a_40_246# _098_ 0
C3126 net132 net48 0
C3127 _641_/a_298_337# _111_ 0.00178f
C3128 _641_/a_38_114# net45 0
C3129 _009_ _096_ 0.31238f
C3130 net39 hold129/a_56_118# 0
C3131 clknet_4_6_0_clk hold51/a_326_118# 0
C3132 FILLER_15_67/a_40_246# clkbuf_4_8_0_clk/a_27_118# 0.00279f
C3133 net37 _223_ 0.96914f
C3134 _201_ FILLER_7_210/a_40_246# 0
C3135 rx_data[4] hold81/a_326_118# 0
C3136 net16 hold81/a_438_182# 0
C3137 _285_ _092_ 0.01698f
C3138 FILLER_12_46/a_32_246# net178 0.01244f
C3139 tx_inst.data_reg\[1\] _066_ 0
C3140 _678_/a_843_236# FILLER_6_98/a_40_246# 0
C3141 _482_/a_154_118# hold62/a_56_118# 0
C3142 _269_ FILLER_16_221/a_32_246# 0.01029f
C3143 clk hold179/a_438_182# 0.01041f
C3144 _442_/a_146_122# VPWR 0
C3145 _305_ _695_/a_843_236# 0
C3146 net75 _695_/a_681_505# 0
C3147 _023_ _695_/a_741_93# 0
C3148 net7 _383_/a_268_412# 0
C3149 _062_ FILLER_9_169/a_32_246# 0
C3150 _516_/a_279_412# _180_ 0
C3151 net9 VPWR 0.22145f
C3152 _411_/a_115_308# _161_ 0
C3153 _418_/a_268_412# _236_ 0
C3154 hold120/a_326_118# baud_inst.counter\[21\] 0.00733f
C3155 _646_/a_612_127# _054_ 0
C3156 FILLER_9_79/a_32_246# _186_ 0
C3157 net42 _079_ 0
C3158 clknet_4_5_0_clk _665_/a_2250_412# 0
C3159 net42 _666_/a_612_127# 0.01202f
C3160 clknet_4_8_0_clk FILLER_17_79/a_40_246# 0
C3161 _095_ _102_ 0
C3162 _680_/a_298_337# _681_/a_324_432# 0
C3163 tx_inst.bit_index\[1\] _339_/a_1453_124# 0.00947f
C3164 _040_ input11/a_40_152# 0
C3165 hold154/a_56_118# _035_ 0.04546f
C3166 net37 _240_ 1.71303f
C3167 _139_ FILLER_26_172/a_40_246# 0
C3168 _141_ _651_/a_741_93# 0.00426f
C3169 net111 _264_ 0.02433f
C3170 net55 _392_/a_382_118# 0
C3171 baud_inst.counter\[20\] _536_/a_341_118# 0.00263f
C3172 hold163/a_56_118# _022_ 0
C3173 net155 _383_/a_268_412# 0
C3174 _477_/a_120_432# _197_ 0
C3175 net110 _683_/a_298_337# 0
C3176 hold63/a_438_182# net122 0.00105f
C3177 hold63/a_326_118# net37 0.01394f
C3178 _491_/a_341_118# net60 0.00175f
C3179 _464_/a_22_110# net47 0.01369f
C3180 _113_ net67 0
C3181 net88 FILLER_15_42/a_40_246# 0
C3182 clknet_4_11_0_clk hold59/a_326_118# 0.00434f
C3183 _138_ net30 0
C3184 _638_/a_550_127# VPWR 0
C3185 _639_/a_612_127# clknet_4_13_0_clk 0
C3186 net73 hold138/a_56_118# 0
C3187 FILLER_19_75/a_40_246# _547_/a_81_118# 0
C3188 _465_/a_22_110# rx_inst.data_reg\[4\] 0
C3189 FILLER_16_176/a_40_246# _417_/a_22_110# 0
C3190 FILLER_2_110/a_32_246# net7 0
C3191 FILLER_17_94/a_40_246# hold90/a_326_118# 0
C3192 _201_ _664_/a_1583_191# 0
C3193 _202_ _664_/a_1840_334# 0.00109f
C3194 rx_inst.state\[3\] _667_/a_681_505# 0
C3195 net89 _687_/a_741_93# 0
C3196 net138 _264_ 0.01047f
C3197 clknet_0_clk _648_/a_1840_334# 0
C3198 _143_ clknet_4_1_0_clk 0
C3199 net55 net27 0.00215f
C3200 _683_/a_38_114# _096_ 0.02974f
C3201 _119_ net172 0.03315f
C3202 net44 hold90/a_326_118# 0
C3203 _170_ FILLER_26_151/a_32_246# 0.00181f
C3204 _290_ net40 0
C3205 hold125/a_56_118# _154_ 0
C3206 _225_ FILLER_21_147/a_40_246# 0
C3207 hold168/a_326_118# VPWR 0.00464f
C3208 _199_ _665_/a_324_432# 0.05547f
C3209 hold77/a_326_118# clknet_4_14_0_clk 0
C3210 _230_ rx_inst.bit_index\[2\] 1.27782f
C3211 _539_/a_45_160# _296_ 0
C3212 net113 _545_/a_350_122# 0
C3213 FILLER_23_204/a_40_246# _154_ 0.0029f
C3214 hold165/a_56_118# _206_ 0
C3215 _659_/a_298_337# _657_/a_298_337# 0.00269f
C3216 _228_ hold180/a_438_182# 0
C3217 rx_inst.state\[2\] hold180/a_326_118# 0.02059f
C3218 hold100/a_326_118# _697_/a_298_337# 0
C3219 _639_/a_38_114# net80 0.04349f
C3220 VPWR hold73/a_56_118# 0.00623f
C3221 net48 _238_ 0
C3222 _701_/a_741_93# _701_/a_1489_191# -0
C3223 FILLER_2_110/a_32_246# net155 0
C3224 hold96/a_326_118# _679_/a_298_337# 0
C3225 net49 _703_/a_2002_114# 0
C3226 FILLER_6_23/a_32_246# _093_ 0.00135f
C3227 clknet_4_4_0_clk _071_ 0
C3228 _675_/a_1583_191# _674_/a_843_236# 0
C3229 _675_/a_1840_334# _674_/a_741_93# 0.00102f
C3230 tx_inst.data_reg\[2\] net41 0.07545f
C3231 net45 FILLER_23_83/a_32_246# 0.00207f
C3232 _660_/a_38_114# net3 0
C3233 hold137/a_438_182# _659_/a_741_93# 0
C3234 hold137/a_326_118# _659_/a_843_236# 0
C3235 rx_inst.state\[3\] fanout42/a_40_152# 0.00783f
C3236 _678_/a_741_93# net152 0
C3237 hold182/a_438_182# FILLER_10_110/a_40_246# 0
C3238 clkload0/Y baud_inst.counter\[13\] 0.00127f
C3239 hold137/a_326_118# net43 0.03154f
C3240 _652_/a_2250_412# VPWR 0.00852f
C3241 _671_/a_298_337# net29 0.01676f
C3242 net49 baud_inst.counter\[19\] 0.14417f
C3243 _638_/a_843_236# _049_ 0.00104f
C3244 _339_/a_1377_160# _653_/a_2250_412# 0
C3245 VPWR _684_/a_843_236# 0.00233f
C3246 FILLER_15_89/a_32_246# _686_/a_324_432# 0
C3247 _414_/a_279_412# _231_ 0
C3248 _233_ _412_/a_22_110# 0.06946f
C3249 _233_ fanout32/a_40_152# 0.00583f
C3250 _178_ net49 0
C3251 net31 _170_ 0.24922f
C3252 hold120/a_56_118# _694_/a_1583_191# 0
C3253 net45 _106_ 0.08558f
C3254 clknet_0_clk hold90/a_56_118# 0.00772f
C3255 _316_ net45 0
C3256 tx_inst.data_reg\[6\] clk 0.13418f
C3257 net54 FILLER_2_237/a_40_246# 0.00105f
C3258 _673_/a_612_127# clknet_0_clk 0
C3259 _002_ net167 0
C3260 _465_/a_120_432# _047_ 0
C3261 _643_/a_38_114# _154_ 0.00165f
C3262 _481_/a_120_432# _076_ 0
C3263 _479_/a_120_432# clknet_0_clk 0
C3264 clknet_0_clk _667_/a_1583_191# 0.00164f
C3265 _392_/a_382_118# _076_ 0.00136f
C3266 hold108/a_56_118# net40 0
C3267 hold154/a_326_118# _280_ 0.04452f
C3268 _047_ _264_ 0.14215f
C3269 hold150/a_438_182# FILLER_28_176/a_32_246# 0
C3270 _117_ clknet_0_clk 0
C3271 _230_ _243_ 0.00987f
C3272 net35 _451_/a_257_140# 0
C3273 net84 _636_/a_324_432# 0
C3274 clknet_4_14_0_clk _633_/a_843_236# 0.01957f
C3275 _043_ _638_/a_741_93# 0
C3276 _267_ rx_inst.data_reg\[6\] 0.03961f
C3277 _267_ _632_/a_324_432# 0
C3278 _313_ _702_/a_38_114# 0.00438f
C3279 net43 _668_/a_324_432# 0
C3280 hold178/a_326_118# baud_inst.counter\[13\] 0.00125f
C3281 hold178/a_438_182# _187_ 0
C3282 clknet_4_12_0_clk _270_ 0
C3283 tx_inst.bit_index\[1\] tx_inst.data_reg\[0\] 0.17596f
C3284 _154_ _236_ 0.0052f
C3285 _699_/a_681_505# clknet_4_10_0_clk 0
C3286 _661_/a_2002_114# _069_ 0
C3287 tx_inst.data_reg\[7\] _658_/a_612_127# 0.0048f
C3288 fanout38/a_40_152# net116 0.001f
C3289 hold55/a_326_118# _705_/a_1583_191# 0
C3290 hold55/a_56_118# _705_/a_1840_334# 0
C3291 fanout40/a_40_152# net49 0.03002f
C3292 hold76/a_326_118# _303_ 0
C3293 baud_inst.counter\[7\] hold94/a_56_118# 0.03248f
C3294 net27 _076_ 0.00157f
C3295 clknet_4_3_0_clk hold94/a_326_118# 0.00375f
C3296 net53 _051_ 0.12629f
C3297 tx_inst.data_reg\[6\] _360_/a_1109_431# 0.00169f
C3298 net55 _706_/a_298_337# 0.03204f
C3299 _156_ _247_ 0.00468f
C3300 FILLER_23_204/a_40_246# _160_ 0
C3301 _673_/a_1583_191# net181 0
C3302 _668_/a_1583_191# net19 0.00413f
C3303 _449_/a_27_156# net49 0.00298f
C3304 _448_/a_244_412# _133_ 0.00149f
C3305 _455_/a_155_412# _263_ 0.00186f
C3306 _656_/a_38_114# _146_ 0.02445f
C3307 _656_/a_741_93# net165 0.0026f
C3308 net108 hold95/a_56_118# 0
C3309 net122 rx_inst.state\[3\] 0.6659f
C3310 output15/a_40_152# VPWR 0.00426f
C3311 output12/a_40_152# net71 0
C3312 hold133/a_438_182# net45 0.00188f
C3313 _170_ _440_/a_550_140# 0
C3314 _638_/a_1489_191# net30 0
C3315 _638_/a_550_127# _266_ 0
C3316 _205_ clknet_4_6_0_clk 0
C3317 _168_ _650_/a_681_505# 0
C3318 rx_data[4] _636_/a_1785_429# 0
C3319 _640_/a_2002_114# _130_ 0
C3320 net38 net117 0.25251f
C3321 _690_/a_681_505# net101 0
C3322 _690_/a_324_432# _300_ 0.00703f
C3323 VPWR _634_/a_38_114# 0
C3324 _224_ _418_/a_46_156# 0.00736f
C3325 rx_inst.state\[2\] _247_ 0
C3326 hold65/a_56_118# _632_/a_741_93# 0
C3327 hold65/a_326_118# rx_inst.data_reg\[6\] 0
C3328 _706_/a_1489_191# _042_ 0.01686f
C3329 net48 rx_data[4] 0.05751f
C3330 net90 _685_/a_324_432# 0
C3331 _055_ _135_ 0
C3332 net120 _693_/a_1583_191# 0.00441f
C3333 net33 _706_/a_1840_334# 0
C3334 net82 net17 0
C3335 _643_/a_38_114# _160_ 0
C3336 net131 _429_/a_142_412# 0
C3337 _043_ _154_ 0
C3338 fanout36/a_40_152# _236_ 0.0077f
C3339 hold173/a_438_182# _219_ 0
C3340 _677_/a_1583_191# _676_/a_1489_191# 0
C3341 _677_/a_324_432# _034_ 0
C3342 _641_/a_324_432# _052_ 0.03094f
C3343 _641_/a_38_114# net176 0.02178f
C3344 clknet_0_clk net11 0
C3345 hold154/a_326_118# _191_ 0
C3346 FILLER_22_86/a_32_246# net99 0
C3347 _069_ FILLER_0_130/a_32_246# 0
C3348 _117_ _704_/a_298_337# 0.03206f
C3349 net30 hold73/a_326_118# 0
C3350 _179_ _699_/a_741_93# 0
C3351 _360_/a_810_118# VPWR 0
C3352 FILLER_13_68/a_40_246# _189_ 0.00835f
C3353 _431_/a_81_118# FILLER_18_169/a_40_246# 0.00945f
C3354 hold131/a_326_118# VPWR 0.01233f
C3355 _089_ clkbuf_4_3_0_clk/a_27_118# 0.01951f
C3356 _514_/a_155_412# net29 0
C3357 _696_/a_1840_334# baud_inst.counter\[24\] 0.00193f
C3358 _415_/a_170_412# _226_ 0.00354f
C3359 net151 _437_/a_154_118# 0
C3360 _226_ hold180/a_326_118# 0.00238f
C3361 _249_ net25 0.41056f
C3362 _054_ VPWR 0.11419f
C3363 _513_/a_192_429# _684_/a_741_93# 0.00157f
C3364 _663_/a_612_127# VPWR 0.00169f
C3365 net94 _678_/a_38_114# 0.00127f
C3366 fanout41/a_40_152# tx_inst.data_reg\[3\] 0
C3367 net92 _678_/a_298_337# 0
C3368 _691_/a_2250_412# hold103/a_56_118# 0.00115f
C3369 _643_/a_550_127# VPWR 0
C3370 hold174/a_326_118# _274_ 0
C3371 _547_/a_81_118# _309_ 0
C3372 _547_/a_277_118# baud_inst.counter\[24\] 0
C3373 _077_ net11 0.00405f
C3374 _045_ _469_/a_22_110# 0.04343f
C3375 net54 _074_ 0.0434f
C3376 _043_ FILLER_20_198/a_40_246# 0
C3377 baud_inst.counter\[26\] hold142/a_438_182# 0.00215f
C3378 _545_/a_146_122# net99 0.00187f
C3379 _660_/a_38_114# _150_ 0.01091f
C3380 _058_ hold119/a_56_118# 0
C3381 baud_inst.counter\[23\] FILLER_22_32/a_40_246# 0
C3382 clknet_4_0_0_clk baud_inst.counter\[10\] 0
C3383 net40 FILLER_12_42/a_32_246# 0.00144f
C3384 hold88/a_438_182# net87 0
C3385 clknet_4_11_0_clk _699_/a_324_432# 0
C3386 net174 _005_ 0.00183f
C3387 hold161/a_326_118# _015_ 0.00115f
C3388 hold161/a_438_182# _296_ 0.00837f
C3389 FILLER_8_171/a_32_246# _396_/a_155_412# 0
C3390 FILLER_15_89/a_32_246# clknet_4_9_0_clk 0.00159f
C3391 _170_ _404_/a_46_156# 0
C3392 _647_/a_38_114# net139 0.03751f
C3393 _064_ _386_/a_285_118# 0
C3394 _217_ _396_/a_257_140# 0
C3395 _218_ _396_/a_155_412# 0.00304f
C3396 net161 _299_ 0
C3397 net182 _514_/a_155_412# 0
C3398 _153_ _137_ 0
C3399 net108 net40 0
C3400 FILLER_11_142/a_40_246# _169_ 0.00208f
C3401 _671_/a_1583_191# clknet_4_6_0_clk 0.0135f
C3402 hold101/a_438_182# _688_/a_612_127# 0
C3403 baud_inst.counter\[18\] _688_/a_1840_334# 0
C3404 FILLER_25_177/a_40_246# hold131/a_326_118# 0
C3405 _114_ net105 0
C3406 net31 _237_ 0.00372f
C3407 hold155/a_438_182# _657_/a_741_93# 0
C3408 net40 net181 0.03439f
C3409 net54 _665_/a_1489_191# 0.00644f
C3410 _205_ net29 0.035f
C3411 _305_ _695_/a_612_127# 0
C3412 net75 _695_/a_550_127# 0
C3413 net129 _189_ 0.04329f
C3414 net49 FILLER_23_143/a_32_246# 0
C3415 output18/a_40_152# _637_/a_2250_412# 0.00232f
C3416 _680_/a_1583_191# _489_/a_115_308# 0
C3417 _518_/a_139_160# net88 0.00113f
C3418 _518_/a_45_160# _014_ 0
C3419 hold52/a_326_118# _161_ 0
C3420 _172_ net183 0
C3421 _160_ _043_ 0.61526f
C3422 _701_/a_1583_191# baud_inst.counter\[29\] 0.00108f
C3423 _201_ FILLER_5_207/a_32_246# 0.01696f
C3424 FILLER_7_82/a_32_246# net93 0.02803f
C3425 net49 FILLER_17_24/a_32_246# 0
C3426 baud_inst.counter\[31\] _698_/a_1583_191# 0
C3427 _152_ net22 0
C3428 _670_/a_681_505# clknet_0_clk 0
C3429 FILLER_16_176/a_40_246# _241_ 0
C3430 tx_inst.bit_index\[1\] _339_/a_1377_160# 0.01712f
C3431 _680_/a_38_114# _681_/a_1840_334# 0
C3432 hold173/a_56_118# _220_ 0
C3433 _265_ net51 0.00267f
C3434 _431_/a_81_118# VPWR 0.00785f
C3435 net56 _651_/a_1489_191# 0
C3436 _170_ _422_/a_248_122# 0.0034f
C3437 net36 _250_ 0
C3438 _684_/a_2250_412# _297_ 0
C3439 net32 _422_/a_146_122# 0.00258f
C3440 _634_/a_38_114# _266_ 0
C3441 _173_ FILLER_3_177/a_32_246# 0
C3442 _363_/a_22_110# _197_ 0
C3443 _007_ _197_ 0
C3444 net26 _666_/a_298_337# 0.04336f
C3445 rx_inst.data_reg\[0\] _635_/a_612_127# 0
C3446 hold173/a_438_182# tx_inst.bit_index\[2\] 0.03199f
C3447 hold182/a_326_118# baud_inst.counter\[4\] 0.00536f
C3448 hold182/a_438_182# net152 0
C3449 hold132/a_438_182# FILLER_26_151/a_32_246# 0.00985f
C3450 _555_/a_209_168# net105 0
C3451 _112_ _312_ 0
C3452 _679_/a_1489_191# FILLER_5_74/a_32_246# 0
C3453 clknet_4_3_0_clk _676_/a_324_432# 0.05392f
C3454 net72 _648_/a_1583_191# 0
C3455 _259_ _258_ 0.02596f
C3456 _666_/a_324_432# FILLER_8_191/a_32_246# 0
C3457 VPWR net171 0.1417f
C3458 net167 _669_/a_298_337# 0.00516f
C3459 hold167/a_438_182# _669_/a_843_236# 0
C3460 net81 clknet_4_13_0_clk 0.06424f
C3461 _246_ _157_ 0
C3462 net133 net49 0
C3463 net71 _649_/a_1489_191# 0
C3464 _643_/a_741_93# _043_ 0.0013f
C3465 _246_ _432_/a_248_122# 0.00106f
C3466 net48 _472_/a_22_110# 0.00402f
C3467 net129 hold129/a_438_182# 0
C3468 net37 _447_/a_81_118# 0.03479f
C3469 VPWR FILLER_12_82/a_32_246# 0.07801f
C3470 net2 _418_/a_268_412# 0.00338f
C3471 _201_ _664_/a_2002_114# 0
C3472 net147 _693_/a_324_432# 0
C3473 _304_ _693_/a_38_114# 0
C3474 _693_/a_324_432# net46 0.02801f
C3475 hold131/a_438_182# net30 0
C3476 _699_/a_2250_412# _703_/a_38_114# 0
C3477 net53 _698_/a_324_432# 0.01625f
C3478 clknet_4_11_0_clk _698_/a_843_236# 0.02729f
C3479 FILLER_10_14/a_40_246# net40 0.01252f
C3480 net167 clkbuf_4_9_0_clk/a_27_118# 0.00218f
C3481 net3 _387_/a_46_156# 0
C3482 _069_ _388_/a_59_156# 0
C3483 _658_/a_1840_334# net165 0.00637f
C3484 net26 clknet_4_4_0_clk 0
C3485 net33 net172 0
C3486 net113 _311_ 0.16262f
C3487 hold171/a_438_182# _661_/a_2250_412# 0.00887f
C3488 hold126/a_56_118# _638_/a_324_432# 0
C3489 _659_/a_843_236# _657_/a_741_93# 0
C3490 _659_/a_741_93# _657_/a_843_236# 0
C3491 _374_/a_142_412# clknet_4_6_0_clk 0.00123f
C3492 net37 FILLER_12_166/a_40_246# 0
C3493 FILLER_17_160/a_40_246# FILLER_17_162/a_32_246# 0.0524f
C3494 _054_ _266_ 0
C3495 net100 _697_/a_324_432# 0
C3496 _094_ _681_/a_324_432# 0.01063f
C3497 _689_/a_298_337# _296_ 0
C3498 _639_/a_1840_334# net80 0
C3499 FILLER_15_116/a_40_246# clknet_4_9_0_clk 0.00672f
C3500 _060_ VPWR 0.16018f
C3501 _657_/a_741_93# net43 0
C3502 _095_ _183_ 0
C3503 net42 tx_inst.state\[4\] 0.00101f
C3504 net35 _435_/a_411_436# 0.00362f
C3505 rx_inst.data_reg\[4\] _156_ 0.22615f
C3506 hold68/a_438_182# net68 0.02856f
C3507 _081_ _668_/a_132_114# 0
C3508 FILLER_21_33/a_32_246# FILLER_22_32/a_40_246# 0
C3509 tx_data[1] net38 0.00134f
C3510 rx_inst.state\[2\] _669_/a_324_432# 0
C3511 tx_inst.bit_index\[1\] tx_inst.data_reg\[1\] 0.05647f
C3512 _678_/a_1840_334# _282_ 0
C3513 _691_/a_1583_191# net49 0.02291f
C3514 tx_inst.bit_index\[1\] hold57/a_326_118# 0
C3515 _638_/a_612_127# _049_ 0
C3516 _023_ net120 0.0073f
C3517 net75 _022_ 0.07036f
C3518 net92 baud_inst.counter\[9\] 0
C3519 hold120/a_326_118# _694_/a_1489_191# 0
C3520 hold102/a_438_182# net104 0
C3521 net54 _201_ 0
C3522 hold157/a_326_118# baud_inst.counter\[17\] 0.0014f
C3523 net44 hold87/a_326_118# 0.01787f
C3524 _269_ _047_ 0.01714f
C3525 baud_inst.counter\[6\] _382_/a_496_118# 0
C3526 _686_/a_1583_191# net29 0
C3527 _643_/a_1840_334# _154_ 0
C3528 _643_/a_2250_412# net126 0.00119f
C3529 net42 _671_/a_741_93# 0
C3530 _006_ clknet_0_clk 0
C3531 _216_ _393_/a_170_412# 0
C3532 hold159/a_56_118# tx_inst.data_reg\[1\] 0.03008f
C3533 net55 _388_/a_285_412# 0.00226f
C3534 _661_/a_324_432# hold155/a_326_118# 0
C3535 _661_/a_741_93# hold155/a_56_118# 0
C3536 tx_busy rx_inst.state\[1\] 0.00157f
C3537 _013_ hold90/a_438_182# 0
C3538 _644_/a_843_236# VPWR 0
C3539 _680_/a_324_432# _279_ 0
C3540 hold128/a_438_182# VPWR 0.0032f
C3541 _040_ _077_ 0.0013f
C3542 hold55/a_326_118# net33 0.00524f
C3543 clknet_4_14_0_clk _633_/a_612_127# 0
C3544 hold134/a_56_118# VPWR 0.03198f
C3545 baud_inst.counter\[28\] hold107/a_326_118# 0.00385f
C3546 baud_inst.counter\[7\] baud_inst.counter\[6\] 0.02875f
C3547 _217_ _402_/a_154_118# 0.00167f
C3548 hold172/a_326_118# tx_inst.state\[3\] 0
C3549 clk net183 0.00108f
C3550 _170_ net62 0
C3551 _098_ _034_ 0.04148f
C3552 baud_inst.counter\[14\] hold90/a_438_182# 0
C3553 net141 hold91/a_326_118# 0
C3554 _310_ hold91/a_56_118# 0
C3555 FILLER_18_65/a_40_246# _296_ 0.00126f
C3556 _694_/a_324_432# clknet_4_10_0_clk 0.03182f
C3557 _341_/a_1377_160# _364_/a_155_412# 0
C3558 net96 clknet_4_0_0_clk 0
C3559 _082_ _083_ 0
C3560 hold55/a_438_182# _705_/a_1489_191# 0
C3561 FILLER_14_202/a_40_246# _650_/a_1489_191# 0
C3562 net67 _700_/a_324_432# 0
C3563 baud_inst.counter\[2\] net86 0
C3564 _653_/a_843_236# _652_/a_843_236# 0
C3565 net44 net100 0.01218f
C3566 _118_ tx_inst.state\[1\] 0.00766f
C3567 _645_/a_741_93# VPWR 0.00228f
C3568 hold151/a_326_118# _253_ 0.00186f
C3569 baud_inst.counter\[27\] _698_/a_324_432# 0
C3570 baud_inst.counter\[26\] _698_/a_38_114# 0
C3571 _077_ _006_ 0.00155f
C3572 _372_/a_120_432# _224_ 0
C3573 _691_/a_741_93# FILLER_17_22/a_40_246# 0
C3574 clkbuf_4_12_0_clk/a_27_118# _223_ 0.01254f
C3575 _431_/a_81_118# _167_ 0.00328f
C3576 _282_ net29 0.04466f
C3577 net62 hold62/a_56_118# 0.00774f
C3578 hold87/a_326_118# _517_/a_380_412# 0
C3579 _673_/a_1489_191# net86 0.01362f
C3580 hold57/a_56_118# _651_/a_298_337# 0
C3581 _668_/a_2002_114# net19 0
C3582 _130_ _263_ 0.08575f
C3583 clknet_4_4_0_clk _388_/a_59_156# 0
C3584 net18 net30 0.19843f
C3585 _206_ _144_ 0.02546f
C3586 _183_ _683_/a_2250_412# 0
C3587 hold136/a_326_118# _038_ 0.0087f
C3588 baud_inst.counter\[18\] _355_/a_150_412# 0
C3589 _164_ _300_ 0.12372f
C3590 _017_ _104_ 0
C3591 hold75/a_326_118# _695_/a_843_236# 0
C3592 hold75/a_438_182# _695_/a_741_93# 0
C3593 _201_ _368_/a_155_412# 0.00378f
C3594 _083_ clknet_0_clk 0.01996f
C3595 clknet_4_8_0_clk net103 0.23684f
C3596 _445_/a_165_412# VPWR 0
C3597 hold142/a_326_118# VPWR 0.00511f
C3598 _690_/a_550_127# net101 0
C3599 VPWR _634_/a_1840_334# 0
C3600 _443_/a_354_412# VPWR 0
C3601 hold156/a_326_118# _096_ 0
C3602 hold182/a_56_118# FILLER_12_117/a_40_246# 0.00786f
C3603 _360_/a_382_118# _360_/a_589_385# -0
C3604 VPWR _681_/a_843_236# 0.02551f
C3605 _635_/a_298_337# clkbuf_4_13_0_clk/a_27_118# 0
C3606 _673_/a_38_114# _655_/a_38_114# 0.03256f
C3607 _074_ _065_ 0
C3608 baud_inst.counter\[6\] _209_ 0.00147f
C3609 _696_/a_741_93# _099_ 0
C3610 _696_/a_843_236# net46 0.01768f
C3611 _651_/a_1583_191# _274_ 0
C3612 FILLER_14_185/a_32_246# _000_ 0.00156f
C3613 _644_/a_1583_191# clkbuf_4_14_0_clk/a_27_118# 0.00115f
C3614 net75 _108_ 0.01707f
C3615 _048_ hold70/a_438_182# 0
C3616 _643_/a_1840_334# _160_ 0.01206f
C3617 _242_ net52 0.02631f
C3618 _092_ FILLER_8_63/a_40_246# 0.00123f
C3619 baud_inst.counter\[26\] hold162/a_326_118# 0
C3620 tx_inst.data_reg\[4\] net41 0.03416f
C3621 _181_ _087_ 0.0036f
C3622 clkload3/Y _154_ 0.003f
C3623 FILLER_10_78/a_32_246# _683_/a_2250_412# 0.01061f
C3624 _117_ _704_/a_1583_191# 0
C3625 _060_ _266_ 0
C3626 baud_inst.counter\[28\] _699_/a_1489_191# 0
C3627 net184 VPWR 0.18657f
C3628 _512_/a_279_412# net109 0.00206f
C3629 clknet_4_3_0_clk _677_/a_843_236# 0.04328f
C3630 VPWR _649_/a_741_93# 0.00837f
C3631 _662_/a_324_432# _654_/a_2250_412# 0
C3632 net43 _667_/a_1583_191# 0.01664f
C3633 clk _653_/a_741_93# 0
C3634 _061_ FILLER_17_199/a_40_246# 0
C3635 _264_ clknet_4_15_0_clk 0.04168f
C3636 rx_inst.bit_index\[1\] fanout35/a_40_152# 0.0245f
C3637 net92 _673_/a_38_114# 0
C3638 net94 _673_/a_324_432# 0
C3639 net154 _683_/a_2250_412# 0
C3640 _293_ net29 0.01431f
C3641 _643_/a_298_337# net47 0.00186f
C3642 _117_ net43 0.80871f
C3643 net2 _405_/a_27_156# 0.00943f
C3644 _414_/a_279_412# _228_ 0.00113f
C3645 net44 _296_ 0.20132f
C3646 net163 FILLER_20_0/a_40_246# 0
C3647 _163_ _684_/a_843_236# 0.01441f
C3648 _011_ _684_/a_324_432# 0
C3649 _657_/a_38_114# _211_ 0
C3650 _190_ _683_/a_1840_334# 0
C3651 _189_ _683_/a_2250_412# 0
C3652 _514_/a_155_412# _493_/a_45_160# 0
C3653 hold147/a_56_118# _302_ 0.01025f
C3654 tx_inst.data_reg\[7\] tx_inst.data_reg\[2\] 0
C3655 hold160/a_56_118# hold156/a_326_118# 0
C3656 hold160/a_326_118# hold156/a_56_118# 0
C3657 _278_ _670_/a_2250_412# 0
C3658 hold125/a_56_118# net49 0
C3659 FILLER_8_118/a_32_246# _142_ 0
C3660 FILLER_8_14/a_32_246# _039_ 0
C3661 _158_ _264_ 0.4413f
C3662 _378_/a_285_412# VPWR 0
C3663 net42 FILLER_8_118/a_32_246# 0.01229f
C3664 net2 fanout36/a_40_152# 0
C3665 _073_ hold146/a_438_182# 0
C3666 hold110/a_438_182# net109 0
C3667 hold110/a_56_118# _010_ 0.02347f
C3668 hold110/a_326_118# _292_ 0.01481f
C3669 _062_ FILLER_12_171/a_40_246# 0
C3670 _653_/a_1840_334# net183 0
C3671 rx_inst.state\[3\] FILLER_11_123/a_40_246# 0.00115f
C3672 rx_done _639_/a_132_114# 0
C3673 net26 _223_ 0.80888f
C3674 _215_ _275_ 0
C3675 _524_/a_146_122# baud_inst.counter\[16\] 0.00485f
C3676 _082_ _670_/a_550_127# 0
C3677 _248_ _423_/a_165_412# 0
C3678 clknet_4_11_0_clk _699_/a_2250_412# 0.00315f
C3679 hold121/a_438_182# VPWR 0.01262f
C3680 _068_ clknet_0_clk 0.29703f
C3681 hold85/a_56_118# _636_/a_1840_334# 0
C3682 hold85/a_326_118# _636_/a_1583_191# 0.00352f
C3683 clknet_4_12_0_clk net25 0.15499f
C3684 net182 _293_ 0.00653f
C3685 net32 _223_ 0.05038f
C3686 _671_/a_2002_114# clknet_4_6_0_clk 0
C3687 _662_/a_38_114# net54 0.02316f
C3688 net79 FILLER_2_46/a_40_246# 0
C3689 hold146/a_326_118# _275_ 0
C3690 _292_ _683_/a_1489_191# 0
C3691 net44 hold163/a_56_118# 0.00964f
C3692 tx_inst.data_reg\[0\] FILLER_1_212/a_32_246# 0.02921f
C3693 net54 tx_inst.state\[3\] 0.05491f
C3694 _305_ net76 0.00409f
C3695 FILLER_20_65/a_32_246# _310_ 0
C3696 FILLER_24_229/a_32_246# FILLER_26_229/a_32_246# 0
C3697 VPWR _505_/a_76_160# 0.05565f
C3698 VPWR _651_/a_324_432# 0.00363f
C3699 _454_/a_155_412# _262_ 0
C3700 _662_/a_843_236# clknet_4_5_0_clk 0.02734f
C3701 _350_/a_279_412# baud_inst.counter\[10\] 0.00135f
C3702 _350_/a_165_412# _183_ 0.00224f
C3703 _517_/a_380_412# _296_ 0
C3704 net44 _696_/a_298_337# 0
C3705 clkbuf_4_9_0_clk/a_27_118# _669_/a_38_114# 0
C3706 _637_/a_324_432# _264_ 0
C3707 net47 _049_ 0.13825f
C3708 hold110/a_438_182# net110 0
C3709 net42 clkload1/Y 0.00227f
C3710 FILLER_16_166/a_32_246# _234_ 0.02023f
C3711 _468_/a_22_110# _266_ 0.00568f
C3712 clknet_4_0_0_clk FILLER_3_21/a_40_246# 0
C3713 hold143/a_56_118# _635_/a_38_114# 0.02058f
C3714 _088_ _087_ 0.00774f
C3715 _701_/a_2002_114# baud_inst.counter\[29\] 0
C3716 net26 _240_ 0.00997f
C3717 hold138/a_326_118# net138 0.00105f
C3718 hold138/a_438_182# rx_inst.data_reg\[4\] 0.00111f
C3719 _244_ net78 0.00139f
C3720 clkload3/Y _160_ 0
C3721 _670_/a_550_127# clknet_0_clk 0
C3722 _223_ hold62/a_326_118# 0
C3723 _072_ _213_ 0
C3724 FILLER_5_59/a_40_246# _287_ 0
C3725 _686_/a_843_236# hold90/a_326_118# 0
C3726 _686_/a_741_93# hold90/a_438_182# 0
C3727 _424_/a_142_412# net24 0.00121f
C3728 net94 net29 0.08488f
C3729 FILLER_8_189/a_40_246# _216_ 0.0038f
C3730 clk _652_/a_1583_191# 0.00246f
C3731 fanout35/a_40_152# FILLER_22_152/a_32_246# 0
C3732 _363_/a_120_432# VPWR 0
C3733 baud_inst.counter\[8\] _683_/a_298_337# 0
C3734 hold96/a_56_118# _292_ 0
C3735 VPWR net169 0.11322f
C3736 net32 _240_ 0.05649f
C3737 hold63/a_326_118# net26 0.00183f
C3738 net58 hold59/a_56_118# 0.04362f
C3739 net43 net11 0.02532f
C3740 net49 _236_ 0.06969f
C3741 FILLER_6_205/a_40_246# net172 0.00261f
C3742 FILLER_7_40/a_32_246# hold136/a_56_118# 0
C3743 clknet_4_3_0_clk _676_/a_2250_412# 0
C3744 net122 _205_ 0.00118f
C3745 baud_inst.counter\[26\] _310_ 0.02991f
C3746 baud_inst.counter\[22\] clknet_4_10_0_clk 0.47949f
C3747 _679_/a_843_236# baud_inst.counter\[7\] 0
C3748 _068_ _386_/a_59_156# 0.00384f
C3749 _679_/a_132_114# net96 0
C3750 hold167/a_56_118# _669_/a_1489_191# 0
C3751 _002_ _669_/a_1840_334# 0.00375f
C3752 net71 rx_inst.data_reg\[6\] 0.00103f
C3753 _217_ _222_ 0.14912f
C3754 _195_ _141_ 0.00619f
C3755 _180_ net99 0.02662f
C3756 hold55/a_326_118# net23 0
C3757 _267_ hold70/a_56_118# 0.06084f
C3758 hold126/a_438_182# _049_ 0
C3759 _341_/a_382_118# tx_inst.data_reg\[0\] 0.03102f
C3760 _203_ tx_inst.state\[2\] 0.0785f
C3761 _278_ net63 0
C3762 _240_ hold62/a_326_118# 0
C3763 hold150/a_56_118# _644_/a_2250_412# 0
C3764 clknet_4_4_0_clk FILLER_5_181/a_32_246# 0
C3765 input11/a_40_152# FILLER_8_238/a_32_246# 0
C3766 net128 _517_/a_209_168# 0.00195f
C3767 _693_/a_2250_412# net46 0.00581f
C3768 rx_inst.bit_index\[1\] _132_ 0
C3769 hold152/a_56_118# _142_ 0
C3770 _517_/a_209_168# _696_/a_324_432# 0
C3771 _266_ _649_/a_741_93# 0
C3772 net30 _649_/a_843_236# 0.00132f
C3773 _352_/a_268_412# _287_ 0
C3774 clknet_4_11_0_clk _698_/a_612_127# 0
C3775 baud_inst.counter\[27\] _699_/a_1583_191# 0
C3776 _092_ VPWR 0.09905f
C3777 net42 hold152/a_56_118# 0.00832f
C3778 hold169/a_56_118# net183 0
C3779 _519_/a_81_118# baud_inst.counter\[15\] 0
C3780 hold53/a_326_118# net36 0
C3781 hold138/a_326_118# _047_ 0.00155f
C3782 _659_/a_1583_191# _657_/a_1583_191# 0.0061f
C3783 net182 FILLER_12_117/a_40_246# 0
C3784 net48 _059_ 0.12715f
C3785 _698_/a_298_337# VPWR 0.00381f
C3786 _689_/a_1583_191# _296_ 0
C3787 hold162/a_326_118# _109_ 0
C3788 _701_/a_550_127# net107 0
C3789 _206_ _390_/a_496_118# 0
C3790 net155 _390_/a_285_118# 0
C3791 clknet_4_0_0_clk hold60/a_438_182# 0.05139f
C3792 _045_ _648_/a_1583_191# 0
C3793 _178_ _699_/a_741_93# 0.00996f
C3794 hold55/a_56_118# net55 0
C3795 _460_/a_22_110# VPWR -0
C3796 hold101/a_56_118# VPWR 0.02372f
C3797 rx_inst.state\[2\] _234_ 0
C3798 _675_/a_1583_191# _030_ 0
C3799 baud_inst.counter\[5\] _683_/a_324_432# 0
C3800 rx_inst.state\[2\] _669_/a_2250_412# 0.00546f
C3801 net48 _159_ 0.23546f
C3802 _282_ hold95/a_438_182# 0
C3803 _414_/a_165_412# _226_ 0
C3804 _691_/a_2002_114# net49 0
C3805 net70 _049_ 0.01278f
C3806 VPWR _033_ 0.16384f
C3807 _677_/a_612_127# net154 0
C3808 input2/a_40_152# rx 0.02683f
C3809 _268_ _124_ 0
C3810 _670_/a_38_114# clknet_4_9_0_clk 0
C3811 _205_ _670_/a_741_93# 0
C3812 hold65/a_56_118# hold70/a_326_118# 0.00145f
C3813 _374_/a_244_412# _667_/a_843_236# 0
C3814 net103 _687_/a_324_432# 0.00563f
C3815 clknet_4_10_0_clk FILLER_22_54/a_40_246# 0.02243f
C3816 hold144/a_438_182# net139 0
C3817 hold135/a_438_182# clknet_4_0_0_clk 0.01131f
C3818 _230_ _418_/a_46_156# 0
C3819 hold116/a_438_182# _682_/a_2250_412# 0
C3820 _704_/a_741_93# rx_inst.state\[1\] 0
C3821 net55 net165 0.02636f
C3822 hold155/a_326_118# clknet_4_1_0_clk 0.00553f
C3823 hold52/a_438_182# _418_/a_46_156# 0
C3824 _461_/a_120_432# net18 0.00229f
C3825 _302_ _296_ 0
C3826 hold69/a_438_182# clknet_4_15_0_clk 0.00172f
C3827 _206_ _145_ 0
C3828 net34 clknet_4_4_0_clk 0.13456f
C3829 net128 _685_/a_681_505# 0
C3830 clknet_4_14_0_clk net78 0
C3831 FILLER_2_237/a_40_246# VPWR 0.12798f
C3832 hold145/a_326_118# _339_/a_382_118# 0
C3833 _357_/a_150_412# _190_ 0
C3834 _690_/a_2250_412# net160 0
C3835 _357_/a_252_412# _189_ 0.00475f
C3836 _358_/a_166_436# net40 0.00109f
C3837 _690_/a_1840_334# _296_ 0
C3838 hold162/a_56_118# VPWR 0.04341f
C3839 _659_/a_324_432# _070_ 0.01149f
C3840 _341_/a_71_118# VPWR 0.09146f
C3841 net97 _682_/a_2250_412# 0.00287f
C3842 net182 hold123/a_326_118# 0
C3843 _405_/a_27_156# _169_ 0
C3844 baud_inst.counter\[23\] _540_/a_45_160# 0
C3845 _694_/a_2250_412# clknet_4_10_0_clk 0.02181f
C3846 net67 _700_/a_2250_412# 0.0017f
C3847 net99 net140 0.02159f
C3848 _660_/a_741_93# _392_/a_59_156# 0
C3849 _660_/a_324_432# _392_/a_382_118# 0
C3850 _403_/a_22_110# _142_ 0.05056f
C3851 hold55/a_438_182# net22 0.00273f
C3852 net23 _705_/a_843_236# 0
C3853 output23/a_40_152# _705_/a_1583_191# 0
C3854 VPWR hold71/a_56_118# 0.00541f
C3855 _699_/a_1840_334# hold113/a_438_182# 0
C3856 _699_/a_2250_412# hold113/a_326_118# 0
C3857 clkbuf_4_10_0_clk/a_27_118# _296_ 0
C3858 clknet_4_6_0_clk _001_ 0
C3859 net13 _471_/a_22_110# 0
C3860 _233_ FILLER_16_166/a_32_246# 0
C3861 baud_inst.counter\[26\] _698_/a_1840_334# 0.00185f
C3862 baud_inst.counter\[27\] _698_/a_2250_412# 0.00309f
C3863 FILLER_8_70/a_32_246# _183_ 0.00147f
C3864 tx_inst.bit_index\[2\] net56 0
C3865 net48 _155_ 0.01883f
C3866 hold103/a_438_182# baud_inst.counter\[16\] 0
C3867 FILLER_8_189/a_40_246# _666_/a_843_236# 0
C3868 _483_/a_22_110# _004_ 0.0197f
C3869 clkbuf_4_6_0_clk/a_27_118# clknet_0_clk 0.0616f
C3870 net51 _668_/a_324_432# 0.03331f
C3871 _707_/a_298_337# rx_inst.state\[1\] 0.00113f
C3872 net44 _531_/a_209_168# 0.05225f
C3873 hold125/a_56_118# _649_/a_38_114# 0.00136f
C3874 _175_ _076_ 0.03216f
C3875 net57 _651_/a_38_114# 0.01869f
C3876 rx_inst.bit_index\[2\] net180 0
C3877 _067_ net165 0.01868f
C3878 hold89/a_56_118# clkbuf_4_8_0_clk/a_27_118# 0.04144f
C3879 hold131/a_326_118# _138_ 0
C3880 hold131/a_56_118# net125 0
C3881 FILLER_0_117/a_32_246# _209_ 0
C3882 baud_inst.counter\[10\] _096_ 0.00416f
C3883 _292_ _180_ 0.09899f
C3884 VPWR FILLER_1_237/a_40_246# 0.13575f
C3885 net55 _705_/a_741_93# 0.00179f
C3886 hold177/a_56_118# baud_inst.counter\[14\] 0
C3887 baud_inst.counter\[18\] baud_inst.counter\[19\] 0.52202f
C3888 hold64/a_326_118# net64 0.00156f
C3889 _466_/a_22_110# _647_/a_1583_191# 0
C3890 _257_ VPWR 0.43707f
C3891 _689_/a_741_93# clknet_4_2_0_clk 0.03404f
C3892 clknet_4_8_0_clk net101 0.02015f
C3893 net35 _260_ 0
C3894 hold131/a_326_118# _232_ 0
C3895 _256_ VPWR 0.32231f
C3896 FILLER_5_59/a_40_246# clkbuf_4_0_0_clk/a_27_118# 0.01205f
C3897 net106 net105 0.05267f
C3898 hold170/a_438_182# _206_ 0
C3899 VPWR _681_/a_612_127# 0.00218f
C3900 _098_ FILLER_13_89/a_40_246# 0.01141f
C3901 _369_/a_248_122# net172 0.00216f
C3902 _439_/a_150_412# net24 0.00101f
C3903 _040_ net43 0.00159f
C3904 _696_/a_612_127# net46 0.0079f
C3905 _232_ _054_ 0
C3906 _133_ net47 0
C3907 net36 _451_/a_155_412# 0.00681f
C3908 _651_/a_2002_114# _274_ 0
C3909 hold53/a_438_182# FILLER_22_118/a_32_246# 0.00985f
C3910 _109_ _310_ 0.01297f
C3911 net74 net15 0.00248f
C3912 _659_/a_741_93# clknet_4_1_0_clk 0.05139f
C3913 net31 _247_ 0.00249f
C3914 rx_inst.state\[1\] hold51/a_438_182# 0.04423f
C3915 _489_/a_115_308# _181_ 0
C3916 net39 _689_/a_132_114# 0
C3917 _292_ _010_ 0.62322f
C3918 clknet_4_3_0_clk _677_/a_612_127# 0.00408f
C3919 _372_/a_22_110# _169_ 0.02386f
C3920 VPWR _649_/a_1785_429# 0
C3921 _257_ _239_ 0
C3922 net7 VPWR 0.13012f
C3923 _662_/a_38_114# _065_ 0
C3924 _006_ net43 0
C3925 net43 _667_/a_2002_114# 0
C3926 _460_/a_22_110# _266_ 0.02888f
C3927 hold99/a_438_182# _698_/a_843_236# 0
C3928 hold154/a_438_182# VPWR 0.00509f
C3929 _697_/a_38_114# _696_/a_1840_334# 0
C3930 _697_/a_324_432# _696_/a_1583_191# 0
C3931 rx_inst.data_reg\[3\] _270_ 0.00311f
C3932 _276_ clknet_0_clk 0
C3933 baud_inst.counter\[12\] hold108/a_326_118# 0
C3934 net122 _374_/a_142_412# 0.00146f
C3935 baud_inst.counter\[18\] fanout40/a_40_152# 0.02447f
C3936 _663_/a_1583_191# _663_/a_2250_412# -0
C3937 _643_/a_1583_191# net47 0.01628f
C3938 _073_ _664_/a_843_236# 0.00306f
C3939 _233_ rx_inst.state\[2\] 0
C3940 output19/a_40_152# _650_/a_2250_412# 0
C3941 clkbuf_4_12_0_clk/a_27_118# _447_/a_81_118# 0
C3942 _695_/a_298_337# _108_ 0.02938f
C3943 _652_/a_324_432# _063_ 0.03268f
C3944 _163_ _684_/a_612_127# 0.01588f
C3945 _227_ clknet_0_clk 0.00347f
C3946 _420_/a_350_122# VPWR 0
C3947 _643_/a_298_337# net112 0
C3948 net94 hold95/a_438_182# 0.00252f
C3949 net92 hold95/a_326_118# 0.01952f
C3950 hold158/a_438_182# _296_ 0
C3951 hold158/a_326_118# _015_ 0.00207f
C3952 _293_ _493_/a_45_160# 0
C3953 _226_ _234_ 0.04959f
C3954 net144 _257_ 0
C3955 hold182/a_438_182# net123 0.00495f
C3956 hold160/a_438_182# net156 0.00843f
C3957 clknet_0_clk hold94/a_326_118# 0.00207f
C3958 _446_/a_146_122# net24 0.00504f
C3959 fanout24/a_40_152# VPWR 0.07202f
C3960 net155 VPWR 0.19526f
C3961 _556_/a_192_429# _699_/a_1583_191# 0
C3962 VPWR net141 0.10641f
C3963 _073_ net21 0
C3964 _677_/a_843_236# baud_inst.counter\[5\] 0
C3965 net51 _667_/a_298_337# 0
C3966 _639_/a_1840_334# _121_ 0
C3967 hold151/a_56_118# _056_ 0.01326f
C3968 net50 _666_/a_1583_191# 0.00131f
C3969 _679_/a_324_432# net135 0.00385f
C3970 _679_/a_38_114# _287_ 0.03337f
C3971 _117_ _707_/a_612_127# 0
C3972 clknet_4_1_0_clk FILLER_6_98/a_40_246# 0.00837f
C3973 _248_ _241_ 1.49742f
C3974 _008_ _675_/a_1583_191# 0.00335f
C3975 tx_inst.bit_index\[1\] _653_/a_324_432# 0.00336f
C3976 net173 hold184/a_326_118# 0.04586f
C3977 rx_data[7] rx_inst.state\[1\] 0
C3978 clknet_0_clk hold62/a_438_182# 0.0036f
C3979 _538_/a_81_118# baud_inst.counter\[19\] 0
C3980 _074_ VPWR 0.10131f
C3981 hold117/a_326_118# _039_ 0.02119f
C3982 hold117/a_438_182# net116 0.02615f
C3983 _345_/a_252_412# baud_inst.counter\[23\] 0.00597f
C3984 _345_/a_150_412# baud_inst.counter\[22\] 0.00654f
C3985 _662_/a_1840_334# net54 0.01356f
C3986 net30 hold71/a_326_118# 0.00244f
C3987 hold75/a_438_182# net120 0
C3988 _670_/a_843_236# baud_inst.counter\[4\] 0
C3989 _439_/a_354_412# _161_ 0
C3990 _699_/a_681_505# VPWR 0
C3991 _093_ baud_inst.counter\[10\] 0
C3992 _292_ baud_inst.counter\[11\] 0
C3993 _696_/a_1583_191# FILLER_17_94/a_40_246# 0
C3994 baud_inst.counter\[2\] net38 0.10248f
C3995 clkbuf_4_11_0_clk/a_27_118# clknet_0_clk 0.05029f
C3996 _263_ _262_ 0.0144f
C3997 VPWR _651_/a_2250_412# 0.00813f
C3998 FILLER_17_199/a_40_246# _156_ 0.01001f
C3999 FILLER_29_221/a_32_246# net47 0
C4000 _662_/a_612_127# clknet_4_5_0_clk 0
C4001 hold130/a_438_182# net90 0
C4002 _227_ hold166/a_438_182# 0
C4003 net44 _696_/a_1583_191# 0.00399f
C4004 VPWR _416_/a_248_122# 0
C4005 net43 FILLER_10_145/a_40_246# 0
C4006 clkload0/Y net29 0.02302f
C4007 FILLER_19_132/a_40_246# _451_/a_155_412# 0.01004f
C4008 net49 baud_inst.counter\[16\] 0.00185f
C4009 baud_inst.counter\[18\] _297_ 0
C4010 VPWR _665_/a_1489_191# 0
C4011 _680_/a_741_93# baud_inst.counter\[9\] 0.00428f
C4012 _663_/a_298_337# _166_ 0.00257f
C4013 net39 hold108/a_326_118# 0.00288f
C4014 _694_/a_741_93# FILLER_25_36/a_32_246# 0
C4015 hold175/a_326_118# _262_ 0.00453f
C4016 _673_/a_1489_191# net38 0.00403f
C4017 _655_/a_324_432# net40 0.0408f
C4018 baud_inst.counter\[28\] _114_ 0.01252f
C4019 _658_/a_38_114# _069_ 0.0334f
C4020 _282_ _288_ 0
C4021 _191_ _667_/a_38_114# 0
C4022 _695_/a_38_114# net76 0.01623f
C4023 _542_/a_155_412# _309_ 0.00207f
C4024 FILLER_15_173/a_40_246# _234_ 0
C4025 clknet_4_3_0_clk FILLER_11_125/a_32_246# 0
C4026 _060_ _138_ 0.00343f
C4027 net2 _140_ 0
C4028 _091_ _655_/a_38_114# 0
C4029 VPWR hold92/a_326_118# 0.00132f
C4030 net177 _684_/a_843_236# 0
C4031 _044_ net13 0.0284f
C4032 net168 _666_/a_741_93# 0.00234f
C4033 _257_ _167_ 0.02556f
C4034 _064_ _283_ 0
C4035 tx_inst.bit_index\[0\] _216_ 0
C4036 net49 _409_/a_167_412# 0
C4037 net48 _650_/a_741_93# 0.00381f
C4038 _162_ net40 0.00793f
C4039 net104 _690_/a_38_114# 0
C4040 _679_/a_612_127# baud_inst.counter\[7\] 0
C4041 hold145/a_56_118# VPWR 0.04817f
C4042 _060_ _232_ 0
C4043 _181_ _490_/a_45_160# 0.01218f
C4044 _081_ _650_/a_681_505# 0
C4045 _245_ FILLER_25_163/a_32_246# 0
C4046 _225_ _257_ 0
C4047 net92 _086_ 0
C4048 _283_ net40 0.35234f
C4049 net150 _633_/a_38_114# 0
C4050 _632_/a_324_432# _273_ 0
C4051 _273_ rx_inst.data_reg\[6\] 0
C4052 _632_/a_741_93# net64 0
C4053 net32 _447_/a_81_118# 0
C4054 net182 clkload0/Y 0.00757f
C4055 _080_ hold122/a_438_182# 0
C4056 _310_ _541_/a_474_130# 0
C4057 baud_inst.counter\[12\] _013_ 0.09707f
C4058 _531_/a_209_168# _302_ 0.01562f
C4059 rx_data[0] VPWR 0.14994f
C4060 net44 net75 0
C4061 baud_inst.counter\[28\] _555_/a_209_168# 0
C4062 _266_ _649_/a_1785_429# 0
C4063 _547_/a_81_118# clknet_0_clk 0.00175f
C4064 _414_/a_279_412# net28 0.00152f
C4065 net163 _690_/a_324_432# 0
C4066 net92 _091_ 0
C4067 hold92/a_438_182# hold93/a_56_118# 0
C4068 hold68/a_438_182# baud_inst.counter\[29\] 0
C4069 net100 _546_/a_341_118# 0
C4070 net128 baud_inst.counter\[15\] 0
C4071 FILLER_2_79/a_40_246# _066_ 0.00208f
C4072 net55 _658_/a_741_93# 0
C4073 net179 _206_ 0.0866f
C4074 tx_inst.data_reg\[6\] _341_/a_295_385# 0.00274f
C4075 _676_/a_2250_412# baud_inst.counter\[5\] 0.0013f
C4076 baud_inst.counter\[12\] baud_inst.counter\[14\] 0.00756f
C4077 net3 net54 0.01896f
C4078 tx_inst.data_reg\[4\] tx_inst.data_reg\[7\] 0.09449f
C4079 _659_/a_843_236# _068_ 0.00436f
C4080 _659_/a_38_114# tx_inst.data_reg\[3\] 0
C4081 hold183/a_56_118# _143_ 0
C4082 hold183/a_326_118# _216_ 0.04774f
C4083 FILLER_15_17/a_40_246# hold101/a_438_182# 0.00941f
C4084 _696_/a_324_432# baud_inst.counter\[15\] 0
C4085 _698_/a_1583_191# VPWR 0.00863f
C4086 net85 _157_ 0.01231f
C4087 FILLER_7_9/a_32_246# net38 0.01125f
C4088 hold173/a_56_118# net27 0
C4089 net49 net2 0.03732f
C4090 _392_/a_382_118# _664_/a_38_114# 0
C4091 _392_/a_59_156# _664_/a_324_432# 0
C4092 _073_ _376_/a_76_160# 0.05409f
C4093 _644_/a_843_236# _232_ 0
C4094 _068_ net43 0.0288f
C4095 _254_ _252_ 0.01456f
C4096 net37 _136_ 0.00104f
C4097 _183_ net115 0.09446f
C4098 net26 _215_ 0
C4099 hold158/a_326_118# net39 0
C4100 net126 _649_/a_1583_191# 0.0067f
C4101 _154_ _649_/a_132_114# 0
C4102 hold165/a_56_118# _208_ 0.00327f
C4103 net41 _664_/a_843_236# 0
C4104 baud_inst.counter\[5\] _683_/a_2250_412# 0
C4105 _081_ rx_inst.state\[1\] 0
C4106 _241_ net139 0.00811f
C4107 _299_ _524_/a_248_122# 0.00318f
C4108 _013_ net88 0
C4109 _233_ _226_ 0.00397f
C4110 hold75/a_56_118# _108_ 0
C4111 hold147/a_56_118# FILLER_22_32/a_40_246# 0.00786f
C4112 _098_ net46 0.00186f
C4113 baud_inst.counter\[20\] _692_/a_38_114# 0.00514f
C4114 _670_/a_1840_334# clknet_4_9_0_clk 0.00177f
C4115 baud_inst.counter\[14\] net88 0.44421f
C4116 baud_inst.counter\[15\] _014_ 1.14338f
C4117 net27 _664_/a_38_114# 0
C4118 _530_/a_155_412# _104_ 0.05444f
C4119 FILLER_19_75/a_40_246# _309_ 0.00134f
C4120 hold151/a_326_118# fanout47/a_40_152# 0
C4121 hold136/a_326_118# net86 0
C4122 hold136/a_438_182# net181 0
C4123 clknet_4_12_0_clk _635_/a_298_337# 0
C4124 _022_ _303_ 0.87915f
C4125 _656_/a_741_93# FILLER_0_161/a_40_246# 0.00249f
C4126 _699_/a_38_114# _027_ 0
C4127 _534_/a_46_156# _693_/a_298_337# 0
C4128 _072_ hold155/a_56_118# 0
C4129 net132 VPWR 0.17391f
C4130 _658_/a_741_93# _067_ 0
C4131 _658_/a_38_114# clknet_4_4_0_clk 0.00175f
C4132 _658_/a_2250_412# _656_/a_612_127# 0
C4133 _198_ _200_ 0.0037f
C4134 _242_ _452_/a_155_412# 0
C4135 _201_ VPWR 0.03376f
C4136 FILLER_13_68/a_40_246# clknet_0_clk 0
C4137 _384_/a_382_118# _148_ 0
C4138 _384_/a_559_412# net171 0
C4139 net37 hold123/a_56_118# 0
C4140 net128 _685_/a_550_127# 0
C4141 _650_/a_1489_191# net19 0.00116f
C4142 net64 FILLER_21_229/a_32_246# 0.01364f
C4143 net145 _339_/a_886_118# 0.01078f
C4144 _650_/a_843_236# _157_ 0
C4145 net47 hold83/a_56_118# 0.00149f
C4146 _676_/a_324_432# clknet_0_clk 0.01978f
C4147 _341_/a_1109_431# VPWR 0
C4148 _046_ _270_ 0.05511f
C4149 rx_data[6] _267_ 0
C4150 tx_inst.bit_index\[2\] _196_ 0
C4151 _679_/a_38_114# clkbuf_4_0_0_clk/a_27_118# 0
C4152 _375_/a_170_412# net172 0
C4153 FILLER_12_117/a_40_246# _670_/a_741_93# 0.0024f
C4154 _170_ _671_/a_298_337# 0
C4155 _411_/a_115_308# net49 0
C4156 _073_ FILLER_2_208/a_40_246# 0.03708f
C4157 net44 net104 0.03676f
C4158 _113_ hold105/a_438_182# 0.00112f
C4159 _653_/a_1489_191# _652_/a_2250_412# 0
C4160 clknet_0_clk _683_/a_324_432# 0.00154f
C4161 _698_/a_38_114# FILLER_20_106/a_32_246# 0
C4162 _167_ _416_/a_248_122# 0
C4163 rx_data[0] _127_ 0
C4164 _660_/a_550_127# net41 0
C4165 net44 _294_ 0
C4166 hold122/a_438_182# _041_ 0
C4167 FILLER_28_176/a_32_246# net131 0.01725f
C4168 fanout33/a_40_152# net55 0
C4169 clknet_4_3_0_clk _183_ 0
C4170 net27 _671_/a_843_236# 0
C4171 net51 _668_/a_2250_412# 0.0179f
C4172 _506_/a_257_140# _289_ 0
C4173 _449_/a_27_156# net25 0.03354f
C4174 _644_/a_298_337# net49 0.02129f
C4175 net47 _634_/a_741_93# 0.00144f
C4176 net55 _656_/a_681_505# 0
C4177 net39 net97 0.00371f
C4178 baud_inst.counter\[13\] _186_ 0
C4179 _671_/a_298_337# hold62/a_56_118# 0
C4180 _233_ FILLER_15_173/a_40_246# 0.00387f
C4181 _267_ rx_inst.data_reg\[5\] 0
C4182 hold150/a_56_118# _044_ 0.06322f
C4183 FILLER_23_204/a_40_246# _649_/a_1840_334# 0
C4184 _232_ _649_/a_741_93# 0
C4185 hold122/a_326_118# _169_ 0
C4186 net167 _099_ 0.00822f
C4187 _538_/a_277_118# VPWR 0
C4188 _072_ FILLER_0_128/a_40_246# 0
C4189 output22/a_40_152# _705_/a_741_93# 0
C4190 _689_/a_1785_429# clknet_4_2_0_clk 0.00172f
C4191 hold129/a_438_182# _189_ 0
C4192 hold129/a_326_118# _190_ 0.01464f
C4193 tx_inst.data_reg\[0\] _380_/a_382_118# 0
C4194 _276_ FILLER_6_189/a_40_246# 0.01861f
C4195 VPWR net117 0.11841f
C4196 hold88/a_56_118# clknet_4_8_0_clk 0
C4197 hold107/a_56_118# VPWR 0.00725f
C4198 _010_ _289_ 0
C4199 _024_ net46 0.11603f
C4200 hold124/a_438_182# FILLER_27_210/a_40_246# 0.00217f
C4201 hold65/a_326_118# rx_data[6] 0
C4202 _537_/a_192_429# hold148/a_56_118# 0
C4203 hold123/a_438_182# _670_/a_324_432# 0
C4204 hold123/a_326_118# _670_/a_741_93# 0.00332f
C4205 net42 _204_ 0
C4206 net159 FILLER_4_108/a_40_246# 0
C4207 _659_/a_1785_429# clknet_4_1_0_clk 0
C4208 _277_ _234_ 0.01614f
C4209 _661_/a_298_337# _378_/a_382_118# 0
C4210 net41 _211_ 0
C4211 _517_/a_380_412# _294_ 0
C4212 _676_/a_324_432# _182_ 0
C4213 _271_ FILLER_27_210/a_40_246# 0.01173f
C4214 net39 _689_/a_1489_191# 0.00399f
C4215 clknet_4_3_0_clk net154 0.0042f
C4216 _170_ _058_ 0.01713f
C4217 rx_data[1] _469_/a_22_110# 0
C4218 hold86/a_326_118# hold79/a_326_118# 0
C4219 hold86/a_56_118# hold79/a_438_182# 0
C4220 hold86/a_438_182# hold79/a_56_118# 0
C4221 _073_ _654_/a_1583_191# 0
C4222 FILLER_7_40/a_32_246# clknet_4_0_0_clk 0.00531f
C4223 _551_/a_76_160# net68 0
C4224 rx_inst.bit_index\[0\] FILLER_24_133/a_32_246# 0
C4225 _656_/a_741_93# clknet_4_4_0_clk 0.02633f
C4226 _656_/a_324_432# tx_inst.data_reg\[2\] 0
C4227 hold135/a_56_118# _506_/a_155_412# 0
C4228 tx_inst.bit_index\[2\] _339_/a_1453_124# 0.02212f
C4229 net93 _280_ 0.00409f
C4230 rx_inst.state\[2\] _407_/a_146_122# 0
C4231 _536_/a_341_118# _022_ 0.01988f
C4232 _073_ _664_/a_612_127# 0
C4233 _182_ _683_/a_324_432# 0
C4234 _663_/a_741_93# tx_inst.state\[1\] 0
C4235 hold109/a_56_118# VPWR 0.04397f
C4236 _663_/a_843_236# clknet_4_7_0_clk 0.02894f
C4237 _169_ _140_ 0
C4238 _643_/a_2002_114# net47 0
C4239 net179 _202_ 0.05671f
C4240 _705_/a_550_127# net22 0
C4241 baud_inst.counter\[1\] _674_/a_2250_412# 0
C4242 _684_/a_1583_191# _684_/a_2250_412# 0
C4243 hold58/a_326_118# _702_/a_1583_191# 0.00263f
C4244 _238_ VPWR 0.05468f
C4245 _070_ net38 0
C4246 hold127/a_326_118# _154_ 0.01322f
C4247 _346_/a_150_412# _313_ 0.00243f
C4248 _214_ net170 0.066f
C4249 net54 _150_ 0
C4250 FILLER_5_59/a_40_246# net181 0.01613f
C4251 net75 _302_ 0
C4252 hold110/a_56_118# _287_ 0
C4253 _258_ net24 0.11704f
C4254 _651_/a_741_93# _221_ 0
C4255 _316_ _699_/a_1583_191# 0.00157f
C4256 net58 _699_/a_1840_334# 0
C4257 hold140/a_438_182# _697_/a_741_93# 0.00357f
C4258 hold140/a_326_118# _697_/a_843_236# 0
C4259 _006_ _664_/a_2250_412# 0
C4260 net50 _704_/a_38_114# 0.02378f
C4261 net51 _667_/a_1583_191# 0
C4262 net71 hold70/a_56_118# 0.00907f
C4263 rx_inst.state\[3\] hold167/a_56_118# 0.00132f
C4264 hold124/a_326_118# VPWR 0.00897f
C4265 hold86/a_56_118# _673_/a_1583_191# 0
C4266 _679_/a_1840_334# _287_ 0
C4267 _117_ net51 0
C4268 _707_/a_741_93# FILLER_13_228/a_40_246# 0.00171f
C4269 rx_inst.state\[2\] _453_/a_170_412# 0
C4270 net6 _382_/a_59_156# 0
C4271 _669_/a_1583_191# _669_/a_1840_334# 0
C4272 tx_inst.bit_index\[1\] _653_/a_2250_412# 0.00594f
C4273 output19/a_40_152# _264_ 0.0113f
C4274 clkbuf_4_6_0_clk/a_27_118# net43 0.0026f
C4275 net49 _169_ 0
C4276 net49 fanout45/a_40_152# 0
C4277 _639_/a_843_236# hold81/a_56_118# 0
C4278 _639_/a_741_93# hold81/a_326_118# 0.00222f
C4279 _548_/a_76_160# _311_ 0
C4280 _049_ _649_/a_2250_412# 0
C4281 net129 _182_ 0
C4282 _082_ hold167/a_438_182# 0
C4283 net163 _692_/a_298_337# 0
C4284 _694_/a_324_432# VPWR 0.02658f
C4285 _239_ _238_ 0.0254f
C4286 _670_/a_612_127# baud_inst.counter\[4\] 0
C4287 _639_/a_741_93# _707_/a_324_432# 0
C4288 _639_/a_324_432# _707_/a_741_93# 0
C4289 _253_ _161_ 0.03244f
C4290 FILLER_21_165/a_40_246# _223_ 0.00273f
C4291 _097_ _688_/a_2250_412# 0
C4292 _639_/a_132_114# net19 0
C4293 _173_ _360_/a_71_118# 0
C4294 hold98/a_56_118# hold117/a_56_118# 0
C4295 hold110/a_438_182# baud_inst.counter\[8\] 0.00145f
C4296 _102_ _689_/a_38_114# 0.00315f
C4297 hold171/a_438_182# net165 0.00312f
C4298 hold171/a_56_118# _146_ 0.0142f
C4299 net41 FILLER_2_208/a_40_246# 0.00758f
C4300 _674_/a_132_114# VPWR 0
C4301 _073_ clknet_4_5_0_clk 0.04889f
C4302 hold177/a_438_182# clknet_4_8_0_clk 0
C4303 net44 _696_/a_2002_114# 0
C4304 _230_ _224_ 2.8606f
C4305 baud_inst.counter\[28\] _165_ 0
C4306 _662_/a_38_114# VPWR 0.00913f
C4307 hold52/a_438_182# _224_ 0.02237f
C4308 hold96/a_56_118# net135 0
C4309 net3 _065_ 0
C4310 VPWR tx_inst.state\[3\] 0.15712f
C4311 _663_/a_1583_191# _166_ 0.00305f
C4312 input11/a_40_152# _705_/a_2250_412# 0
C4313 _636_/a_324_432# FILLER_19_228/a_40_246# 0
C4314 clknet_4_11_0_clk _640_/a_38_114# 0
C4315 hold53/a_438_182# _640_/a_741_93# 0
C4316 hold53/a_326_118# _640_/a_843_236# 0
C4317 _686_/a_1489_191# net90 0
C4318 _215_ net50 0.04297f
C4319 _677_/a_843_236# clknet_0_clk 0.02157f
C4320 _537_/a_192_429# _534_/a_268_412# 0
C4321 _087_ hold61/a_326_118# 0
C4322 _097_ hold178/a_56_118# 0
C4323 hold167/a_438_182# clknet_0_clk 0
C4324 _200_ _666_/a_2250_412# 0
C4325 net104 _302_ 0.09794f
C4326 _692_/a_324_432# _104_ 0
C4327 FILLER_1_90/a_32_246# net55 0
C4328 fanout27/a_40_152# _651_/a_1840_334# 0
C4329 _098_ _685_/a_741_93# 0.00407f
C4330 _170_ _205_ 0
C4331 clknet_4_13_0_clk _168_ 0.01943f
C4332 net68 _700_/a_741_93# 0.00426f
C4333 _115_ _700_/a_843_236# 0.04107f
C4334 clkbuf_4_5_0_clk/a_27_118# net168 0.05323f
C4335 tx_inst.state\[4\] _393_/a_170_412# 0.00152f
C4336 hold146/a_326_118# net50 0.03892f
C4337 hold146/a_438_182# net146 0.05857f
C4338 _696_/a_1489_191# clknet_0_clk 0
C4339 hold108/a_438_182# _683_/a_741_93# 0.00164f
C4340 hold108/a_326_118# _683_/a_843_236# 0.00243f
C4341 baud_inst.counter\[13\] _684_/a_324_432# 0.02333f
C4342 _187_ _684_/a_741_93# 0.00366f
C4343 FILLER_24_218/a_40_246# net30 0.00427f
C4344 _058_ hold139/a_438_182# 0.00871f
C4345 _659_/a_1489_191# net41 0
C4346 output23/a_40_152# net23 0.02469f
C4347 FILLER_11_142/a_40_246# clknet_4_6_0_clk 0
C4348 _227_ net43 0.00202f
C4349 hold171/a_56_118# _656_/a_298_337# 0
C4350 _465_/a_22_110# _636_/a_741_93# 0
C4351 rx_data[4] VPWR 0.19294f
C4352 net35 _442_/a_350_122# 0
C4353 _632_/a_1785_429# net64 0
C4354 tx_inst.bit_index\[2\] tx_inst.data_reg\[0\] 0
C4355 hold96/a_326_118# baud_inst.counter\[8\] 0
C4356 _678_/a_298_337# _036_ 0.00112f
C4357 net163 _164_ 0
C4358 hold124/a_326_118# _127_ 0
C4359 hold176/a_438_182# _262_ 0
C4360 hold176/a_326_118# _131_ 0.004f
C4361 baud_inst.counter\[31\] net67 0.00124f
C4362 _632_/a_298_337# net30 0.00798f
C4363 net39 clkbuf_4_2_0_clk/a_27_118# 0.01914f
C4364 _233_ _277_ 0
C4365 net35 _248_ 0.01473f
C4366 baud_inst.counter\[20\] hold120/a_326_118# 0.01035f
C4367 _431_/a_379_118# net49 0
C4368 _424_/a_244_140# _154_ 0.0012f
C4369 _444_/a_244_412# net24 0.00178f
C4370 _636_/a_843_236# _264_ 0.03763f
C4371 rx_inst.state\[3\] _676_/a_1583_191# 0
C4372 _655_/a_843_236# tx_data[7] 0
C4373 _659_/a_612_127# _068_ 0.00596f
C4374 _659_/a_1840_334# tx_inst.data_reg\[3\] 0.00282f
C4375 _171_ _664_/a_843_236# 0
C4376 _698_/a_2002_114# VPWR 0
C4377 hold140/a_438_182# clknet_0_clk 0.01115f
C4378 clkbuf_4_4_0_clk/a_27_118# _142_ 0
C4379 hold102/a_56_118# net102 0.00113f
C4380 hold102/a_326_118# _017_ 0.05179f
C4381 _654_/a_1583_191# net41 0.00199f
C4382 baud_inst.counter\[17\] _015_ 0.00393f
C4383 _178_ _694_/a_1583_191# 0
C4384 _382_/a_559_412# _209_ 0.0069f
C4385 rx_inst.data_reg\[2\] hold150/a_438_182# 0.00303f
C4386 net36 VPWR 0.50754f
C4387 _154_ _649_/a_1489_191# 0.00474f
C4388 net66 net64 0.00307f
C4389 _661_/a_681_505# _210_ 0
C4390 _351_/a_268_412# baud_inst.counter\[11\] 0
C4391 _223_ _137_ 0.00411f
C4392 _395_/a_146_122# net168 0
C4393 _688_/a_38_114# net160 0.00117f
C4394 FILLER_18_210/a_32_246# _156_ 0
C4395 _536_/a_192_429# net147 0.04623f
C4396 _343_/a_155_412# hold174/a_56_118# 0
C4397 _536_/a_192_429# net46 0.01887f
C4398 tx_data[1] VPWR 0.02692f
C4399 _483_/a_22_110# _168_ 0.02211f
C4400 tx _665_/a_843_236# 0
C4401 hold87/a_438_182# _292_ 0
C4402 baud_inst.counter\[20\] _692_/a_1840_334# 0.00494f
C4403 hold124/a_326_118# _266_ 0
C4404 hold124/a_438_182# net30 0
C4405 hold59/a_56_118# net49 0
C4406 _677_/a_843_236# _182_ 0.02855f
C4407 net31 _234_ 0.08606f
C4408 _644_/a_132_114# net47 0
C4409 baud_inst.counter\[25\] net46 0.16376f
C4410 VPWR _503_/a_279_412# 0
C4411 _192_ _664_/a_132_114# 0
C4412 tx _166_ 0
C4413 _018_ _104_ 0.00554f
C4414 _114_ FILLER_25_36/a_32_246# 0.00159f
C4415 _173_ _172_ 0.12703f
C4416 _099_ _669_/a_38_114# 0.00141f
C4417 _662_/a_298_337# net179 0.005f
C4418 _699_/a_1840_334# _027_ 0.00381f
C4419 _021_ _693_/a_38_114# 0.04818f
C4420 _680_/a_298_337# _030_ 0
C4421 VPWR _401_/a_120_432# 0
C4422 _062_ _222_ 0
C4423 net30 _271_ 0.00407f
C4424 _658_/a_1785_429# _067_ 0
C4425 _658_/a_1840_334# clknet_4_4_0_clk 0.00874f
C4426 rx_inst.bit_index\[2\] net37 0.13111f
C4427 net128 clknet_4_9_0_clk 0.02264f
C4428 rx_inst.data_reg\[7\] net19 0.0363f
C4429 _240_ _137_ 0
C4430 net35 _245_ 0
C4431 rx_inst.state\[2\] hold166/a_56_118# 0.00167f
C4432 _391_/a_46_156# _071_ 0.07377f
C4433 tx_inst.state\[3\] FILLER_7_234/a_32_246# 0
C4434 _003_ _191_ 0.12196f
C4435 hold153/a_56_118# net29 0
C4436 rx_data[5] VPWR 0.04811f
C4437 hold106/a_56_118# _701_/a_324_432# 0
C4438 _232_ _257_ 0.75651f
C4439 _232_ _256_ 0.07754f
C4440 hold52/a_326_118# net49 0.00141f
C4441 _672_/a_132_114# net38 0
C4442 net43 hold50/a_56_118# 0.00364f
C4443 clknet_0_clk _683_/a_2250_412# 0.00368f
C4444 clknet_4_5_0_clk net41 0.05216f
C4445 FILLER_26_88/a_40_246# _703_/a_324_432# 0
C4446 _095_ _689_/a_1840_334# 0
C4447 _264_ hold81/a_438_182# 0.00113f
C4448 _548_/a_272_160# net140 0
C4449 _548_/a_170_160# baud_inst.counter\[24\] 0
C4450 _699_/a_843_236# net45 0.02315f
C4451 net39 FILLER_8_118/a_32_246# 0
C4452 hold147/a_326_118# clknet_4_10_0_clk 0
C4453 _676_/a_324_432# FILLER_10_110/a_40_246# 0
C4454 hold57/a_438_182# clknet_4_6_0_clk 0
C4455 baud_inst.counter\[17\] net88 0
C4456 _644_/a_1583_191# net49 0
C4457 net47 _634_/a_1785_429# 0
C4458 _023_ _692_/a_843_236# 0
C4459 net174 _480_/a_22_110# 0.06239f
C4460 _671_/a_324_432# rx_inst.state\[4\] 0.02813f
C4461 _170_ hold112/a_326_118# 0.04525f
C4462 _643_/a_132_114# _257_ 0
C4463 _341_/a_1453_124# net9 0
C4464 hold169/a_56_118# _166_ 0.00338f
C4465 _160_ _649_/a_1489_191# 0
C4466 baud_inst.counter\[22\] VPWR 0.69494f
C4467 _506_/a_155_412# _287_ 0.0117f
C4468 net37 _243_ 0.00169f
C4469 _437_/a_154_118# _236_ 0
C4470 rx_data[4] _266_ 0.00474f
C4471 net12 net30 0.04325f
C4472 _313_ _701_/a_1489_191# 0
C4473 net182 hold153/a_56_118# 0
C4474 FILLER_19_132/a_40_246# VPWR 0.14192f
C4475 clknet_4_1_0_clk _655_/a_843_236# 0.04061f
C4476 _660_/a_324_432# _175_ 0
C4477 _679_/a_38_114# net108 0
C4478 hold57/a_438_182# _218_ 0
C4479 net48 _639_/a_741_93# 0
C4480 _180_ _099_ 0.00192f
C4481 _696_/a_741_93# clknet_4_8_0_clk 0.02453f
C4482 _158_ _633_/a_38_114# 0.0056f
C4483 hold120/a_56_118# _701_/a_38_114# 0
C4484 hold68/a_326_118# _031_ 0.00877f
C4485 _645_/a_132_114# net49 0
C4486 _232_ _420_/a_350_122# 0
C4487 net75 hold148/a_326_118# 0.01097f
C4488 _305_ hold148/a_56_118# 0.00305f
C4489 tx_inst.data_reg\[6\] _380_/a_59_156# 0
C4490 net108 _683_/a_681_505# 0
C4491 _679_/a_38_114# net181 0
C4492 _679_/a_298_337# net86 0
C4493 hold174/a_326_118# hold169/a_56_118# 0
C4494 net123 _670_/a_681_505# 0
C4495 VPWR _472_/a_22_110# 0.0113f
C4496 _054_ _649_/a_843_236# 0
C4497 _292_ _287_ 0
C4498 _010_ net135 0
C4499 _525_/a_268_412# _016_ 0
C4500 output16/a_40_152# _647_/a_1583_191# 0
C4501 rx_inst.bit_index\[1\] _641_/a_843_236# 0
C4502 _661_/a_298_337# _206_ 0
C4503 _013_ _012_ 0.00238f
C4504 hold139/a_56_118# _157_ 0
C4505 _643_/a_2250_412# _649_/a_1583_191# 0
C4506 hold123/a_326_118# FILLER_11_123/a_40_246# 0
C4507 net39 baud_inst.counter\[17\] 0.02382f
C4508 _704_/a_1489_191# FILLER_13_228/a_40_246# 0
C4509 hold157/a_326_118# VPWR 0.00931f
C4510 baud_inst.counter\[28\] net106 0.17332f
C4511 _171_ _376_/a_76_160# 0
C4512 VPWR _632_/a_132_114# 0
C4513 _679_/a_681_505# _182_ 0
C4514 _314_ _115_ 0.00116f
C4515 rx_inst.bit_index\[2\] _134_ 0
C4516 _656_/a_550_127# _067_ 0
C4517 _656_/a_2250_412# tx_inst.data_reg\[2\] 0.00477f
C4518 _360_/a_886_118# _206_ 0
C4519 _279_ _087_ 0
C4520 _012_ baud_inst.counter\[14\] 0
C4521 _341_/a_589_385# _172_ 0
C4522 tx_inst.bit_index\[2\] _339_/a_1377_160# 0.08777f
C4523 _663_/a_612_127# clknet_4_7_0_clk 0
C4524 _663_/a_1785_429# tx_inst.state\[1\] 0
C4525 _182_ _683_/a_2250_412# 0.01126f
C4526 _315_ _701_/a_1583_191# 0
C4527 hold120/a_438_182# _693_/a_2250_412# 0.00887f
C4528 net36 _167_ 0
C4529 rx_data[5] _127_ 0
C4530 _706_/a_843_236# net21 0
C4531 baud_inst.counter\[12\] _358_/a_268_436# 0
C4532 VPWR _668_/a_843_236# 0.00285f
C4533 rx_inst.data_reg\[0\] clknet_4_13_0_clk 0
C4534 tx_data[3] net6 0.00822f
C4535 hold171/a_438_182# _658_/a_741_93# 0.00357f
C4536 hold171/a_326_118# _658_/a_843_236# 0
C4537 FILLER_10_78/a_32_246# baud_inst.counter\[5\] 0
C4538 _444_/a_142_412# VPWR 0
C4539 baud_inst.counter\[20\] net148 0.03378f
C4540 _041_ _651_/a_38_114# 0.00227f
C4541 rx_inst.bit_index\[1\] _260_ 0
C4542 _554_/a_146_122# _180_ 0.00457f
C4543 net36 _225_ 0.82968f
C4544 net45 _698_/a_132_114# 0
C4545 net110 _509_/a_257_140# 0
C4546 _696_/a_324_432# _686_/a_2250_412# 0
C4547 _696_/a_741_93# _686_/a_1840_334# 0
C4548 _696_/a_843_236# _686_/a_1583_191# 0
C4549 _696_/a_1583_191# _686_/a_843_236# 0
C4550 baud_inst.counter\[30\] _702_/a_843_236# 0.0644f
C4551 VPWR FILLER_22_54/a_40_246# 0.14252f
C4552 hold66/a_438_182# VPWR 0.00367f
C4553 net31 _233_ 0.0905f
C4554 _316_ _699_/a_2002_114# 0
C4555 hold136/a_326_118# net38 0.00747f
C4556 net154 baud_inst.counter\[5\] 0.01751f
C4557 _269_ output19/a_40_152# 0
C4558 hold86/a_326_118# _673_/a_1489_191# 0
C4559 baud_inst.counter\[1\] _673_/a_2250_412# 0.02547f
C4560 _078_ net27 0.00105f
C4561 VPWR _648_/a_741_93# 0.03055f
C4562 VPWR _380_/a_285_118# 0
C4563 FILLER_2_81/a_32_246# _655_/a_38_114# 0
C4564 net18 _634_/a_1840_334# 0.00308f
C4565 _532_/a_155_412# _302_ 0.01636f
C4566 _635_/a_132_114# net64 0
C4567 _273_ hold70/a_56_118# 0.00161f
C4568 _040_ FILLER_5_213/a_32_246# 0
C4569 hold152/a_56_118# net39 0
C4570 clkbuf_4_12_0_clk/a_27_118# _136_ 0.0047f
C4571 _230_ FILLER_23_158/a_40_246# 0.00527f
C4572 net111 _223_ 0
C4573 _217_ _400_/a_192_429# 0.0023f
C4574 _312_ _311_ 0.15439f
C4575 _551_/a_76_160# _701_/a_2250_412# 0.001f
C4576 net105 _701_/a_843_236# 0
C4577 _314_ _701_/a_38_114# 0
C4578 _313_ baud_inst.counter\[25\] 0.19096f
C4579 hold79/a_326_118# VPWR 0.00403f
C4580 _020_ _692_/a_681_505# 0
C4581 net163 _692_/a_1583_191# 0
C4582 _694_/a_2250_412# VPWR 0.00569f
C4583 net136 hold117/a_326_118# 0
C4584 hold104/a_56_118# baud_inst.counter\[17\] 0
C4585 FILLER_17_0/a_40_246# net101 0
C4586 FILLER_19_178/a_40_246# _448_/a_244_412# 0
C4587 _159_ FILLER_29_179/a_40_246# 0
C4588 _134_ _243_ 0.01326f
C4589 _639_/a_1489_191# net19 0.01081f
C4590 baud_inst.counter\[18\] hold103/a_56_118# 0
C4591 baud_inst.counter\[24\] net46 0.13401f
C4592 rx_inst.data_reg\[0\] net65 0.13564f
C4593 net55 _209_ 0.14974f
C4594 net98 hold117/a_326_118# 0.0016f
C4595 _102_ _689_/a_1840_334# 0
C4596 _226_ hold166/a_56_118# 0
C4597 _674_/a_1489_191# VPWR 0.00111f
C4598 FILLER_5_213/a_32_246# _006_ 0
C4599 hold76/a_326_118# hold120/a_326_118# 0.0062f
C4600 baud_inst.counter\[0\] net86 0.00149f
C4601 _662_/a_1840_334# VPWR 0.00547f
C4602 _638_/a_741_93# rx_inst.data_reg\[6\] 0
C4603 _638_/a_324_432# _632_/a_741_93# 0
C4604 _638_/a_741_93# _632_/a_324_432# 0
C4605 tx_inst.bit_index\[2\] tx_inst.data_reg\[1\] 0
C4606 clknet_4_11_0_clk _702_/a_324_432# 0.03227f
C4607 tx_inst.bit_index\[2\] hold57/a_326_118# 0
C4608 net7 _384_/a_559_412# 0
C4609 _072_ net38 0.01475f
C4610 _663_/a_2002_114# _166_ 0
C4611 _107_ FILLER_25_36/a_32_246# 0
C4612 baud_inst.counter\[20\] hold164/a_326_118# 0
C4613 _645_/a_843_236# _644_/a_843_236# 0
C4614 _673_/a_132_114# VPWR 0
C4615 _677_/a_612_127# clknet_0_clk 0.02563f
C4616 _537_/a_155_160# _021_ 0
C4617 net111 _240_ 0.0838f
C4618 _236_ net25 0.00208f
C4619 hold87/a_56_118# FILLER_17_81/a_32_246# 0
C4620 hold64/a_438_182# _046_ 0
C4621 hold170/a_326_118# net3 0.00115f
C4622 VPWR _667_/a_324_432# 0.00228f
C4623 _639_/a_1489_191# hold51/a_326_118# 0
C4624 fanout29/a_40_152# net29 0.00602f
C4625 _234_ _422_/a_248_122# 0
C4626 _636_/a_1583_191# rx_inst.data_reg\[7\] 0
C4627 _230_ FILLER_19_139/a_40_246# 0
C4628 _692_/a_2250_412# _104_ 0
C4629 net48 _061_ 0.0153f
C4630 _115_ _700_/a_612_127# 0
C4631 _674_/a_843_236# _181_ 0.00188f
C4632 net146 net21 0
C4633 _357_/a_252_412# clknet_0_clk 0
C4634 hold104/a_438_182# clknet_4_8_0_clk 0.00253f
C4635 _266_ _472_/a_22_110# 0.00263f
C4636 FILLER_10_147/a_32_246# VPWR 0.07037f
C4637 _188_ _684_/a_612_127# 0
C4638 baud_inst.counter\[13\] _684_/a_2250_412# 0.008f
C4639 _206_ _384_/a_285_118# 0.00179f
C4640 _120_ _367_/a_170_412# 0
C4641 tx_inst.data_reg\[5\] net41 0
C4642 _173_ FILLER_5_156/a_32_246# 0.00147f
C4643 rx_data[6] net71 0
C4644 _060_ _649_/a_843_236# 0
C4645 tx_inst.data_reg\[4\] _656_/a_324_432# 0.01281f
C4646 FILLER_13_100/a_40_246# _685_/a_1489_191# 0
C4647 _269_ _636_/a_843_236# 0.00208f
C4648 net13 _648_/a_1840_334# 0
C4649 net35 _255_ 0.00192f
C4650 _642_/a_324_432# hold176/a_56_118# 0
C4651 hold155/a_326_118# FILLER_3_123/a_32_246# 0
C4652 _645_/a_1583_191# FILLER_29_165/a_40_246# 0.00208f
C4653 _657_/a_324_432# tx_inst.data_reg\[1\] 0.01941f
C4654 _073_ _199_ 0.23454f
C4655 net48 _465_/a_22_110# 0.00339f
C4656 _687_/a_681_505# _296_ 0
C4657 _464_/a_22_110# _648_/a_2250_412# 0
C4658 hold67/a_438_182# _700_/a_2250_412# 0.00887f
C4659 _632_/a_1583_191# net30 0
C4660 _632_/a_132_114# _266_ 0
C4661 FILLER_21_165/a_40_246# _447_/a_81_118# 0.01553f
C4662 net55 FILLER_0_161/a_40_246# 0.00456f
C4663 net55 _069_ 0
C4664 _636_/a_612_127# _264_ 0.00376f
C4665 fanout37/a_40_152# net51 0.00764f
C4666 _163_ hold109/a_56_118# 0
C4667 hold128/a_56_118# baud_inst.counter\[13\] 0.03417f
C4668 _083_ net123 0.29549f
C4669 hold181/a_56_118# hold60/a_438_182# 0
C4670 clknet_4_3_0_clk baud_inst.counter\[5\] 0.12564f
C4671 _000_ _668_/a_132_114# 0
C4672 _266_ _668_/a_843_236# 0.00519f
C4673 net156 _689_/a_843_236# 0
C4674 _431_/a_277_118# net35 0.00103f
C4675 net132 _232_ 0.00492f
C4676 net44 _303_ 0.0044f
C4677 _680_/a_298_337# _039_ 0
C4678 _166_ _665_/a_324_432# 0
C4679 net166 _002_ 0.15622f
C4680 net15 _270_ 0
C4681 _353_/a_350_122# net29 0
C4682 hold74/a_438_182# rx_data[4] 0.00457f
C4683 _538_/a_81_118# hold103/a_56_118# 0
C4684 net71 rx_inst.data_reg\[5\] 0.05084f
C4685 _154_ rx_inst.data_reg\[6\] 0.04943f
C4686 _661_/a_550_127# _210_ 0
C4687 _072_ _383_/a_268_412# 0
C4688 hold149/a_326_118# _693_/a_298_337# 0
C4689 clkbuf_4_2_0_clk/a_27_118# _683_/a_843_236# 0
C4690 _688_/a_1583_191# _296_ 0
C4691 net32 _136_ 0
C4692 net120 _304_ 0.08037f
C4693 hold173/a_438_182# net34 0.01353f
C4694 baud_inst.counter\[18\] baud_inst.counter\[16\] 1.2392f
C4695 _644_/a_1583_191# net131 0
C4696 hold53/a_438_182# net100 0
C4697 hold66/a_438_182# _266_ 0.00128f
C4698 net3 VPWR 0.02941f
C4699 hold130/a_56_118# _294_ 0.07574f
C4700 hold114/a_438_182# baud_inst.counter\[29\] 0.01546f
C4701 _448_/a_244_140# _258_ 0.00123f
C4702 _517_/a_209_168# _292_ 0
C4703 _636_/a_741_93# _156_ 0.00376f
C4704 _703_/a_741_93# _702_/a_1583_191# 0.0012f
C4705 _703_/a_324_432# _702_/a_1840_334# 0
C4706 net75 FILLER_22_32/a_40_246# 0
C4707 hold143/a_56_118# _264_ 0
C4708 hold163/a_438_182# net164 0
C4709 _677_/a_612_127# _182_ 0.00541f
C4710 net48 _433_/a_142_412# 0
C4711 net30 _648_/a_843_236# 0.00413f
C4712 _266_ _648_/a_741_93# 0.00455f
C4713 tx_inst.state\[4\] net172 0
C4714 _676_/a_324_432# net152 0.00113f
C4715 _676_/a_38_114# baud_inst.counter\[4\] 0.01055f
C4716 FILLER_11_144/a_32_246# VPWR 0.06979f
C4717 _440_/a_244_140# _158_ 0
C4718 hold181/a_56_118# hold135/a_438_182# 0
C4719 hold181/a_326_118# hold135/a_326_118# 0.00127f
C4720 fanout30/a_40_152# hold119/a_56_118# 0.00117f
C4721 _397_/a_279_412# _172_ 0
C4722 net124 _464_/a_22_110# 0.00138f
C4723 _155_ _464_/a_120_432# 0
C4724 _213_ _381_/a_46_156# 0.02729f
C4725 _067_ FILLER_0_161/a_40_246# 0
C4726 _662_/a_1583_191# net179 0
C4727 fanout42/a_40_152# FILLER_11_142/a_40_246# 0.01f
C4728 rx_done net23 0.54984f
C4729 net20 tx_done 0.02631f
C4730 _021_ _693_/a_1840_334# 0
C4731 net55 _207_ 0.13776f
C4732 _069_ _067_ 0.00499f
C4733 VPWR _142_ 0.46002f
C4734 _357_/a_252_412# _182_ 0
C4735 _240_ _047_ 0
C4736 fanout45/a_40_152# FILLER_24_4/a_40_246# 0.01226f
C4737 _392_/a_59_156# _214_ 0.00868f
C4738 _392_/a_285_412# net54 0.00226f
C4739 net42 VPWR 1.5348f
C4740 FILLER_0_35/a_40_246# _675_/a_324_432# 0
C4741 input6/a_40_152# input8/a_40_152# 0.0015f
C4742 _674_/a_843_236# _088_ 0
C4743 _175_ _664_/a_38_114# 0
C4744 net26 _671_/a_1489_191# 0.015f
C4745 net119 _157_ 0.00294f
C4746 _534_/a_268_412# _020_ 0
C4747 net49 hold127/a_326_118# 0
C4748 _696_/a_2250_412# clknet_4_9_0_clk 0.00126f
C4749 hold64/a_438_182# _638_/a_1840_334# 0
C4750 _233_ _404_/a_46_156# 0
C4751 net84 net30 0.31326f
C4752 net12 _461_/a_120_432# 0
C4753 clknet_4_5_0_clk _171_ 0.43349f
C4754 _314_ hold105/a_56_118# 0.01124f
C4755 baud_inst.counter\[25\] _262_ 0
C4756 baud_inst.counter\[26\] _165_ 0
C4757 FILLER_2_110/a_32_246# _072_ 0.00135f
C4758 _234_ net62 0.00289f
C4759 hold64/a_438_182# _043_ 0
C4760 _356_/a_350_122# baud_inst.counter\[13\] 0
C4761 _485_/a_22_110# VPWR 0
C4762 _687_/a_843_236# net88 0
C4763 _687_/a_741_93# _014_ 0.00101f
C4764 net62 _669_/a_2250_412# 0
C4765 _540_/a_45_160# _296_ 0.04664f
C4766 hold161/a_326_118# _017_ 0.00464f
C4767 hold161/a_56_118# net102 0
C4768 hold75/a_56_118# clkbuf_4_10_0_clk/a_27_118# 0
C4769 hold169/a_56_118# _651_/a_1583_191# 0
C4770 net146 _376_/a_76_160# 0.00298f
C4771 net45 _694_/a_38_114# 0.00506f
C4772 _499_/a_380_412# net40 0.00147f
C4773 net2 _265_ 1.92065f
C4774 _313_ baud_inst.counter\[24\] 0.00931f
C4775 _699_/a_612_127# net45 0.00297f
C4776 _697_/a_1583_191# clkbuf_4_9_0_clk/a_27_118# 0
C4777 hold153/a_438_182# net40 0.0476f
C4778 _410_/a_257_140# _205_ 0
C4779 _537_/a_192_429# clknet_4_10_0_clk 0.02339f
C4780 net55 clknet_4_4_0_clk 0.00375f
C4781 hold117/a_56_118# clknet_4_0_0_clk 0.00281f
C4782 hold110/a_56_118# net108 0.06133f
C4783 _671_/a_2250_412# rx_inst.state\[4\] 0.01415f
C4784 _292_ _685_/a_681_505# 0
C4785 net40 hold93/a_56_118# 0.02097f
C4786 _160_ _632_/a_324_432# 0
C4787 baud_inst.counter\[26\] hold100/a_326_118# 0.03088f
C4788 baud_inst.counter\[27\] hold100/a_438_182# 0
C4789 _289_ _287_ 0.32667f
C4790 _044_ FILLER_28_176/a_32_246# 0.0012f
C4791 _657_/a_681_505# VPWR 0
C4792 _192_ _364_/a_155_412# 0
C4793 _359_/a_120_432# _197_ 0.00153f
C4794 clknet_4_13_0_clk _636_/a_38_114# 0
C4795 clknet_4_14_0_clk FILLER_25_141/a_32_246# 0
C4796 _021_ FILLER_24_19/a_40_246# 0.03005f
C4797 tx_inst.data_reg\[0\] FILLER_2_183/a_32_246# 0
C4798 _509_/a_155_412# _289_ 0
C4799 output20/a_40_152# rx_done 0.00735f
C4800 _649_/a_741_93# _649_/a_843_236# 0
C4801 clknet_4_1_0_clk _655_/a_612_127# 0.00805f
C4802 rx_inst.state\[3\] _669_/a_324_432# 0
C4803 _696_/a_1785_429# clknet_4_8_0_clk 0
C4804 _158_ _633_/a_1840_334# 0.00877f
C4805 hold141/a_56_118# net99 0
C4806 _688_/a_741_93# clknet_4_2_0_clk 0.03837f
C4807 _046_ _632_/a_843_236# 0
C4808 _504_/a_209_168# net135 0.00652f
C4809 _705_/a_324_432# net43 0.02036f
C4810 _157_ _433_/a_244_412# 0.00775f
C4811 hold164/a_56_118# net163 0.00563f
C4812 _232_ _238_ 0.25011f
C4813 net108 _683_/a_550_127# 0
C4814 net122 FILLER_11_142/a_40_246# 0
C4815 clknet_4_11_0_clk _112_ 0
C4816 rx_inst.data_reg\[3\] _635_/a_298_337# 0
C4817 _679_/a_1840_334# net181 0
C4818 net174 hold169/a_438_182# 0
C4819 net123 _670_/a_550_127# 0
C4820 _646_/a_1785_429# net85 0
C4821 net67 _703_/a_550_127# 0
C4822 _551_/a_76_160# baud_inst.counter\[29\] 0.11592f
C4823 baud_inst.counter\[6\] baud_inst.counter\[4\] 0
C4824 FILLER_8_70/a_32_246# _182_ 0.01484f
C4825 _292_ _290_ 0.00161f
C4826 hold125/a_56_118# _648_/a_38_114# 0
C4827 rx_inst.bit_index\[1\] _641_/a_612_127# 0
C4828 _191_ _670_/a_1489_191# 0.00284f
C4829 _082_ _669_/a_843_236# 0.00161f
C4830 net44 _669_/a_681_505# 0
C4831 FILLER_21_194/a_32_246# _043_ 0.00135f
C4832 _388_/a_285_118# _212_ 0.00364f
C4833 _388_/a_496_118# net5 0
C4834 net165 _387_/a_268_412# 0
C4835 _674_/a_324_432# _087_ 0.03229f
C4836 _254_ _255_ 0.08214f
C4837 VPWR _632_/a_1489_191# 0
C4838 _679_/a_550_127# _182_ 0
C4839 _110_ _696_/a_1489_191# 0
C4840 _139_ _236_ 0
C4841 _489_/a_115_308# _279_ 0.00176f
C4842 _067_ clknet_4_4_0_clk 0.03947f
C4843 _670_/a_298_337# VPWR 0.00225f
C4844 net18 hold71/a_56_118# 0.03157f
C4845 _090_ _162_ 0
C4846 _270_ _466_/a_22_110# 0.00141f
C4847 _075_ tx_inst.state\[1\] 0
C4848 _413_/a_170_412# net49 0
C4849 _046_ hold66/a_56_118# 0
C4850 hold52/a_438_182# _230_ 0.01163f
C4851 hold168/a_438_182# _201_ 0
C4852 hold168/a_326_118# _203_ 0
C4853 net167 _686_/a_38_114# 0.00233f
C4854 _059_ VPWR 0.11449f
C4855 _377_/a_46_156# _213_ 0.00268f
C4856 _207_ _389_/a_46_156# 0.00144f
C4857 FILLER_7_40/a_32_246# _093_ 0
C4858 VPWR _668_/a_612_127# 0
C4859 _055_ _245_ 0
C4860 hold135/a_56_118# net135 0
C4861 _283_ _090_ 1.00046f
C4862 baud_inst.counter\[3\] _672_/a_681_505# 0
C4863 tx_inst.data_reg\[4\] _658_/a_1583_191# 0.00566f
C4864 hold164/a_438_182# _104_ 0.00246f
C4865 _533_/a_248_122# _304_ 0
C4866 hold68/a_326_118# _313_ 0.03659f
C4867 _159_ VPWR 0.37327f
C4868 hold105/a_56_118# _700_/a_612_127# 0
C4869 clkbuf_4_10_0_clk/a_27_118# baud_inst.counter\[29\] 0
C4870 _694_/a_612_127# _106_ 0
C4871 FILLER_0_40/a_40_246# _085_ 0.02709f
C4872 _111_ _698_/a_550_127# 0
C4873 hold137/a_56_118# _653_/a_324_432# 0.0017f
C4874 clknet_4_6_0_clk net183 0.00141f
C4875 baud_inst.counter\[30\] _702_/a_612_127# 0.00272f
C4876 input4/a_40_152# _066_ 0
C4877 net54 _706_/a_38_114# 0.00684f
C4878 clknet_0_clk _669_/a_843_236# 0
C4879 hold140/a_326_118# net142 0.00187f
C4880 VPWR _507_/a_170_412# 0
C4881 tx_inst.state\[4\] _705_/a_843_236# 0
C4882 net42 _266_ 0
C4883 _642_/a_741_93# rx_inst.state\[2\] 0
C4884 _698_/a_1583_191# FILLER_20_95/a_40_246# 0
C4885 VPWR _150_ 0.18129f
C4886 _076_ clknet_4_4_0_clk 0.0267f
C4887 _303_ _302_ 0.08989f
C4888 _635_/a_1489_191# net64 0.0019f
C4889 net47 _470_/a_120_432# 0
C4890 clknet_4_5_0_clk _706_/a_843_236# 0.05196f
C4891 FILLER_8_171/a_32_246# net183 0
C4892 hold108/a_56_118# _292_ 0
C4893 _098_ _514_/a_155_412# 0.00375f
C4894 _635_/a_741_93# net30 0.00858f
C4895 _635_/a_324_432# _266_ 0.00402f
C4896 _068_ _339_/a_71_118# 0.02003f
C4897 clknet_4_3_0_clk _496_/a_170_412# 0
C4898 _195_ _221_ 0
C4899 _218_ net183 0.13642f
C4900 _050_ hold81/a_326_118# 0
C4901 net81 hold81/a_56_118# 0
C4902 _020_ _692_/a_550_127# 0
C4903 _531_/a_380_412# net164 0
C4904 _314_ _701_/a_1840_334# 0.00162f
C4905 _663_/a_324_432# clknet_4_6_0_clk 0.04302f
C4906 hold88/a_56_118# _515_/a_76_160# 0
C4907 hold135/a_326_118# baud_inst.counter\[8\] 0.00441f
C4908 net76 net46 0
C4909 _363_/a_22_110# net184 0.01377f
C4910 _057_ clknet_0_clk 0.23006f
C4911 _644_/a_1583_191# _644_/a_2250_412# 0
C4912 _644_/a_741_93# _644_/a_1489_191# 0
C4913 rx_inst.bit_index\[2\] _454_/a_257_140# 0
C4914 hold115/a_326_118# clknet_4_0_0_clk 0.01254f
C4915 _677_/a_324_432# _282_ 0
C4916 _677_/a_843_236# net152 0.00496f
C4917 net57 _220_ 0.02057f
C4918 hold101/a_56_118# _298_ 0.00575f
C4919 _233_ net62 0
C4920 clkbuf_4_10_0_clk/a_27_118# _695_/a_1583_191# 0.00423f
C4921 net172 FILLER_7_210/a_40_246# 0.008f
C4922 FILLER_25_177/a_40_246# _059_ 0.00355f
C4923 baud_inst.counter\[2\] VPWR 0.06548f
C4924 VPWR _682_/a_324_432# 0.0206f
C4925 _121_ net80 0
C4926 net79 _680_/a_1840_334# 0
C4927 hold97/a_438_182# net29 0.00459f
C4928 clknet_4_11_0_clk _702_/a_2250_412# 0.06148f
C4929 FILLER_10_78/a_32_246# clknet_0_clk 0
C4930 _663_/a_741_93# _217_ 0
C4931 net51 clkbuf_4_6_0_clk/a_27_118# 0
C4932 tx_start net22 0.01476f
C4933 _017_ _690_/a_298_337# 0.00209f
C4934 hold53/a_56_118# clknet_4_14_0_clk 0.00532f
C4935 VPWR hold90/a_438_182# 0.00128f
C4936 _697_/a_741_93# _309_ 0
C4937 _697_/a_681_505# baud_inst.counter\[24\] 0.00111f
C4938 _043_ _632_/a_843_236# 0
C4939 _405_/a_27_156# net29 0
C4940 _700_/a_741_93# baud_inst.counter\[29\] 0
C4941 _645_/a_1583_191# _644_/a_1840_334# 0
C4942 _427_/a_350_122# net24 0
C4943 hold79/a_56_118# net60 0
C4944 _673_/a_1489_191# VPWR 0.00175f
C4945 _661_/a_741_93# VPWR 0.01524f
C4946 net154 clknet_0_clk 0.29609f
C4947 hold138/a_438_182# _636_/a_741_93# 0.00404f
C4948 _155_ VPWR 0.1502f
C4949 _510_/a_248_122# _183_ 0
C4950 _640_/a_843_236# VPWR 0.01248f
C4951 VPWR _667_/a_2250_412# 0.0086f
C4952 clknet_4_13_0_clk hold51/a_438_182# 0
C4953 FILLER_17_81/a_32_246# _544_/a_46_156# 0.0073f
C4954 hold52/a_56_118# _254_ 0.00151f
C4955 _143_ clknet_4_4_0_clk 0.04239f
C4956 _058_ _247_ 0.01144f
C4957 _101_ _296_ 0
C4958 _691_/a_1785_429# net103 0
C4959 _115_ net134 0
C4960 tx_data[2] _388_/a_496_118# 0
C4961 _189_ clknet_0_clk 0.04956f
C4962 _691_/a_741_93# net101 0
C4963 _205_ hold180/a_326_118# 0
C4964 net66 _638_/a_324_432# 0
C4965 hold108/a_438_182# _096_ 0
C4966 _031_ _113_ 0.00541f
C4967 net36 _232_ 0.00153f
C4968 _206_ _148_ 0.00754f
C4969 net69 _267_ 0.45518f
C4970 _679_/a_298_337# net38 0
C4971 hold127/a_438_182# _649_/a_298_337# 0
C4972 _060_ _649_/a_612_127# 0.00148f
C4973 hold66/a_56_118# _043_ 0
C4974 _490_/a_45_160# _279_ 0.01921f
C4975 _183_ _182_ 0.10299f
C4976 _500_/a_257_140# _185_ 0
C4977 _283_ _352_/a_268_412# 0.00193f
C4978 _673_/a_843_236# _181_ 0
C4979 _657_/a_2250_412# tx_inst.data_reg\[1\] 0.0081f
C4980 _687_/a_550_127# _296_ 0
C4981 _307_ _548_/a_170_160# 0.00517f
C4982 rx_data[6] _273_ 0
C4983 baud_inst.counter\[23\] net45 0
C4984 hold181/a_438_182# _287_ 0.00772f
C4985 hold106/a_56_118# baud_inst.counter\[29\] 0
C4986 _392_/a_382_118# _144_ 0.02148f
C4987 _171_ _005_ 0.00333f
C4988 net93 hold93/a_438_182# 0
C4989 _145_ tx_data[7] 0
C4990 _217_ _653_/a_843_236# 0
C4991 clknet_4_5_0_clk net146 0
C4992 _059_ _266_ 0.00707f
C4993 baud_inst.counter\[22\] FILLER_22_43/a_40_246# 0.01824f
C4994 tx_inst.data_reg\[0\] _071_ 0.00246f
C4995 _266_ _668_/a_612_127# 0
C4996 _634_/a_1583_191# hold71/a_438_182# 0
C4997 net2 net25 0.29005f
C4998 net172 _664_/a_1583_191# 0.02233f
C4999 _401_/a_22_110# _221_ 0.0015f
C5000 _142_ _400_/a_155_160# 0
C5001 FILLER_25_177/a_40_246# _155_ 0
C5002 _227_ net51 0
C5003 FILLER_20_57/a_32_246# _695_/a_2250_412# 0
C5004 FILLER_7_9/a_32_246# VPWR 0.06755f
C5005 _186_ net29 0.15189f
C5006 _198_ _369_/a_146_122# 0
C5007 _159_ _266_ 0.05489f
C5008 net169 _007_ 0.03982f
C5009 net161 _522_/a_474_130# 0
C5010 FILLER_10_78/a_32_246# _182_ 0.005f
C5011 rx_data[7] clknet_4_13_0_clk 0.02052f
C5012 rx_inst.data_reg\[1\] hold131/a_56_118# 0.02258f
C5013 FILLER_22_118/a_32_246# net45 0
C5014 hold86/a_56_118# _672_/a_1583_191# 0
C5015 baud_inst.counter\[1\] _672_/a_324_432# 0.00135f
C5016 net58 _555_/a_380_412# 0
C5017 tx_inst.bit_index\[1\] _341_/a_382_118# 0.00961f
C5018 net184 _341_/a_1453_124# 0.01301f
C5019 _360_/a_1453_124# tx_inst.bit_index\[2\] 0
C5020 net154 _182_ 0.01006f
C5021 _483_/a_22_110# _671_/a_38_114# 0.0348f
C5022 net48 _156_ 1.19703f
C5023 clknet_4_8_0_clk _545_/a_146_122# 0.00179f
C5024 _266_ _648_/a_1785_429# 0
C5025 net30 _648_/a_612_127# 0
C5026 hold65/a_326_118# net69 0
C5027 hold100/a_56_118# VPWR 0.02611f
C5028 _676_/a_1840_334# baud_inst.counter\[4\] 0.04137f
C5029 _192_ tx_inst.state\[2\] 0
C5030 _510_/a_248_122# net115 0.00166f
C5031 hold116/a_438_182# net109 0
C5032 _679_/a_843_236# baud_inst.counter\[4\] 0
C5033 _679_/a_741_93# _282_ 0
C5034 hold116/a_56_118# _010_ 0
C5035 _292_ baud_inst.counter\[15\] 0
C5036 net29 _417_/a_120_432# 0.00122f
C5037 _155_ _127_ 0.00945f
C5038 net120 FILLER_22_22/a_32_246# 0
C5039 _445_/a_279_412# _257_ 0.00108f
C5040 clknet_0_clk _382_/a_285_118# 0.0011f
C5041 _002_ clknet_4_9_0_clk 0.01627f
C5042 _046_ _635_/a_298_337# 0.01335f
C5043 net51 hold62/a_438_182# 0.00921f
C5044 rx_inst.bit_index\[2\] net26 0
C5045 baud_inst.counter\[4\] _683_/a_1840_334# 0
C5046 _282_ _683_/a_1583_191# 0
C5047 net152 _683_/a_2250_412# 0
C5048 _189_ _182_ 0.01953f
C5049 rx_inst.data_reg\[4\] net19 0
C5050 _446_/a_146_122# _054_ 0
C5051 _637_/a_843_236# clknet_4_15_0_clk 0.04194f
C5052 _546_/a_435_412# net99 0
C5053 _227_ clknet_4_12_0_clk 0
C5054 net67 VPWR 0.23546f
C5055 tx_data[3] net8 0.03205f
C5056 net6 tx_data[5] 0.03188f
C5057 net128 hold91/a_56_118# 0.0031f
C5058 net49 _439_/a_354_412# 0
C5059 rx_inst.bit_index\[2\] net32 1.66964f
C5060 _430_/a_170_412# net49 0
C5061 clknet_0_clk _309_ 0
C5062 net109 net97 0.11172f
C5063 _292_ net108 0.22213f
C5064 hold121/a_326_118# _105_ 0.00193f
C5065 _635_/a_2250_412# VPWR 0.00192f
C5066 _642_/a_298_337# baud_inst.counter\[25\] 0
C5067 hold174/a_326_118# net174 0.00528f
C5068 net115 _182_ 0.01989f
C5069 clknet_4_3_0_clk clknet_0_clk 0.45207f
C5070 rx_data[0] net18 0.52454f
C5071 net92 _677_/a_38_114# 0
C5072 _283_ _677_/a_298_337# 0.00601f
C5073 clknet_4_0_0_clk _085_ 0.00163f
C5074 net60 _037_ 0
C5075 net26 _196_ 0
C5076 _094_ _039_ 0.0016f
C5077 hold153/a_326_118# _281_ 0
C5078 hold68/a_56_118# _700_/a_298_337# 0
C5079 _098_ _686_/a_1583_191# 0
C5080 rx_data[2] _637_/a_324_432# 0
C5081 net14 _637_/a_741_93# 0.00176f
C5082 _155_ _266_ 0.13975f
C5083 _055_ _255_ 0
C5084 net45 _694_/a_1840_334# 0.00192f
C5085 hold149/a_56_118# FILLER_24_19/a_40_246# 0.00786f
C5086 FILLER_23_186/a_40_246# clknet_0_clk 0
C5087 net114 net45 0.13068f
C5088 _478_/a_229_118# net172 0
C5089 net41 FILLER_1_201/a_40_246# 0
C5090 _686_/a_38_114# _669_/a_38_114# 0.03256f
C5091 _009_ _688_/a_2250_412# 0
C5092 _305_ clknet_4_10_0_clk 0.06892f
C5093 _042_ net43 0
C5094 _091_ _036_ 0.00336f
C5095 net110 net97 0.20159f
C5096 hold154/a_56_118# baud_inst.counter\[13\] 0
C5097 hold129/a_438_182# _182_ 0
C5098 _694_/a_2250_412# FILLER_22_43/a_40_246# 0
C5099 rx_data[4] hold73/a_326_118# 0.02331f
C5100 net16 hold73/a_438_182# 0.00355f
C5101 _705_/a_1583_191# _704_/a_2250_412# 0
C5102 _705_/a_1489_191# _704_/a_741_93# 0
C5103 _705_/a_1840_334# _704_/a_1840_334# 0
C5104 _705_/a_2250_412# _704_/a_1583_191# 0
C5105 _201_ _665_/a_298_337# 0
C5106 tx_busy net22 0.0073f
C5107 hold142/a_326_118# _310_ 0.002f
C5108 hold142/a_56_118# _025_ 0.0249f
C5109 _657_/a_550_127# VPWR 0
C5110 _192_ _197_ 0.22456f
C5111 clknet_4_13_0_clk _636_/a_1840_334# 0
C5112 clk _380_/a_285_412# 0.00104f
C5113 _290_ _289_ 0
C5114 net32 _243_ 0.00189f
C5115 clknet_4_1_0_clk _145_ 0.10752f
C5116 _661_/a_1583_191# tx_inst.data_reg\[1\] 0
C5117 rx_inst.state\[3\] _669_/a_2250_412# 0.00149f
C5118 net48 _050_ 0.02483f
C5119 _688_/a_1785_429# clknet_4_2_0_clk 0
C5120 clkbuf_4_9_0_clk/a_27_118# _686_/a_324_432# 0
C5121 VPWR _650_/a_741_93# 0.01857f
C5122 _046_ _632_/a_612_127# 0
C5123 _171_ _199_ 0
C5124 net135 _287_ 0.40843f
C5125 _705_/a_2250_412# net43 0
C5126 _081_ clknet_4_13_0_clk 0
C5127 net57 _667_/a_1840_334# 0
C5128 _427_/a_248_122# VPWR 0
C5129 tx_inst.data_reg\[7\] tx_inst.data_reg\[5\] 0.027f
C5130 _696_/a_38_114# _308_ 0
C5131 _232_ _444_/a_142_412# 0.01078f
C5132 _180_ _546_/a_192_429# 0.0538f
C5133 _082_ _669_/a_612_127# 0.00483f
C5134 _138_ _648_/a_741_93# 0.00472f
C5135 FILLER_15_173/a_40_246# _671_/a_741_93# 0.00125f
C5136 _659_/a_298_337# _382_/a_382_118# 0
C5137 _634_/a_38_114# _271_ 0.00981f
C5138 _634_/a_298_337# _124_ 0.00419f
C5139 hold148/a_326_118# _303_ 0.00624f
C5140 _146_ _212_ 0.00244f
C5141 net79 _491_/a_435_412# 0.00142f
C5142 hold54/a_56_118# tx_inst.state\[3\] 0.00322f
C5143 hold55/a_438_182# _478_/a_27_156# 0
C5144 clknet_4_3_0_clk _182_ 0.3712f
C5145 net34 net56 0.04078f
C5146 rx_inst.state\[2\] _250_ 0
C5147 _638_/a_324_432# hold70/a_326_118# 0
C5148 _638_/a_741_93# hold70/a_56_118# 0
C5149 _376_/a_170_160# _200_ 0.00392f
C5150 _670_/a_1583_191# VPWR 0.00479f
C5151 _132_ _696_/a_1583_191# 0
C5152 FILLER_10_222/a_32_246# VPWR 0.07229f
C5153 _031_ hold114/a_326_118# 0
C5154 _378_/a_559_412# net7 0.00129f
C5155 FILLER_8_19/a_40_246# _682_/a_38_114# 0
C5156 hold178/a_326_118# clknet_4_2_0_clk 0.02441f
C5157 clknet_4_10_0_clk _701_/a_741_93# 0.03046f
C5158 _043_ _635_/a_298_337# 0
C5159 hold96/a_438_182# _291_ 0
C5160 FILLER_15_17/a_40_246# net101 0.02251f
C5161 FILLER_24_156/a_32_246# _154_ 0
C5162 FILLER_11_125/a_32_246# net43 0
C5163 hold175/a_326_118# _450_/a_127_436# 0
C5164 baud_inst.counter\[3\] _672_/a_550_127# 0
C5165 _675_/a_1489_191# clknet_4_0_0_clk 0
C5166 _676_/a_741_93# _280_ 0.00124f
C5167 hold154/a_438_182# _089_ 0.00414f
C5168 _033_ net61 0
C5169 tx_inst.data_reg\[4\] _658_/a_2002_114# 0
C5170 hold159/a_438_182# _151_ 0
C5171 _070_ VPWR 0.14879f
C5172 hold122/a_326_118# clknet_4_6_0_clk 0.02688f
C5173 net48 hold78/a_438_182# 0.00774f
C5174 clkbuf_0_clk/a_116_82# _667_/a_741_93# 0
C5175 clk _667_/a_298_337# 0.03865f
C5176 _684_/a_324_432# net29 0
C5177 _058_ rx_inst.data_reg\[4\] 0
C5178 baud_inst.counter\[30\] net68 0
C5179 hold99/a_56_118# net100 0.01568f
C5180 net54 _706_/a_1840_334# 0.02039f
C5181 _280_ _683_/a_741_93# 0
C5182 clknet_0_clk _669_/a_612_127# 0
C5183 hold126/a_326_118# rx_inst.data_reg\[6\] 0.00269f
C5184 _555_/a_380_412# _027_ 0
C5185 _378_/a_285_118# _206_ 0.00269f
C5186 _378_/a_382_118# _151_ 0.01211f
C5187 _378_/a_559_412# net155 0
C5188 _283_ _679_/a_38_114# 0
C5189 net94 _679_/a_741_93# 0.0271f
C5190 net92 _679_/a_324_432# 0
C5191 _652_/a_741_93# _142_ 0.01266f
C5192 _676_/a_1583_191# FILLER_12_117/a_40_246# 0.00262f
C5193 _642_/a_1785_429# rx_inst.state\[2\] 0
C5194 _527_/a_192_429# baud_inst.counter\[16\] 0.00104f
C5195 baud_inst.counter\[31\] _116_ 0.04177f
C5196 _064_ _652_/a_324_432# 0.00118f
C5197 net42 _652_/a_741_93# 0.01434f
C5198 _698_/a_1489_191# FILLER_21_96/a_40_246# 0
C5199 hold179/a_438_182# net41 0
C5200 hold172/a_326_118# net172 0.00146f
C5201 net47 _124_ 0.64334f
C5202 clknet_4_5_0_clk _706_/a_612_127# 0.00259f
C5203 _286_ _683_/a_324_432# 0
C5204 _098_ _293_ 0.1198f
C5205 _169_ net25 0.00367f
C5206 tx_inst.data_reg\[3\] _339_/a_382_118# 0.00275f
C5207 baud_inst.counter\[12\] _515_/a_272_160# 0.00355f
C5208 baud_inst.counter\[30\] hold67/a_326_118# 0.00861f
C5209 net85 net30 0.00185f
C5210 clkbuf_4_11_0_clk/a_27_118# _703_/a_1583_191# 0
C5211 _639_/a_1840_334# net51 0
C5212 net81 _707_/a_1840_334# 0
C5213 _050_ _707_/a_2250_412# 0
C5214 _047_ _457_/a_120_432# 0
C5215 _697_/a_38_114# net46 0.00437f
C5216 _216_ _666_/a_1840_334# 0
C5217 _118_ _487_/a_248_122# 0
C5218 _698_/a_132_114# _051_ 0
C5219 _173_ _193_ 0
C5220 _644_/a_741_93# rx_inst.data_reg\[1\] 0
C5221 net36 _406_/a_154_118# 0
C5222 _090_ clkbuf_4_3_0_clk/a_27_118# 0.00208f
C5223 _677_/a_612_127# net152 0
C5224 net58 _702_/a_38_114# 0
C5225 _316_ _702_/a_298_337# 0
C5226 hold178/a_56_118# _683_/a_38_114# 0
C5227 VPWR _682_/a_2250_412# 0.00385f
C5228 clknet_4_6_0_clk _140_ 0
C5229 FILLER_19_178/a_40_246# _241_ 0
C5230 hold142/a_438_182# _698_/a_1583_191# 0
C5231 hold142/a_56_118# _698_/a_2250_412# 0
C5232 hold142/a_326_118# _698_/a_1840_334# 0
C5233 _546_/a_192_429# net140 0
C5234 _102_ _688_/a_38_114# 0.00157f
C5235 hold102/a_326_118# _018_ 0
C5236 net120 _692_/a_741_93# 0
C5237 _022_ _692_/a_38_114# 0
C5238 rx_inst.bit_index\[2\] hold175/a_438_182# 0
C5239 _186_ hold95/a_438_182# 0
C5240 net39 _508_/a_209_168# 0.01199f
C5241 net102 _690_/a_132_114# 0
C5242 baud_inst.counter\[28\] _701_/a_843_236# 0.03191f
C5243 _128_ net65 0.04815f
C5244 hold147/a_326_118# VPWR 0.03929f
C5245 _554_/a_350_122# net46 0
C5246 net2 _668_/a_324_432# 0.00139f
C5247 _043_ _632_/a_612_127# 0.00483f
C5248 _645_/a_843_236# net132 0
C5249 _244_ net24 0.25964f
C5250 _661_/a_1785_429# VPWR 0
C5251 rx_inst.data_reg\[4\] _636_/a_1583_191# 0
C5252 hold56/a_438_182# net56 0.00325f
C5253 net123 _676_/a_324_432# 0
C5254 _640_/a_612_127# VPWR 0.00331f
C5255 FILLER_7_82/a_32_246# baud_inst.counter\[7\] 0.02427f
C5256 net48 hold138/a_438_182# 0
C5257 FILLER_5_207/a_32_246# net172 0.00412f
C5258 _650_/a_843_236# net30 0.01882f
C5259 _650_/a_741_93# _266_ 0.01043f
C5260 _030_ _181_ 0.0241f
C5261 _676_/a_741_93# _191_ 0.00548f
C5262 _411_/a_358_436# net180 0.06534f
C5263 fanout40/a_40_152# net160 0
C5264 _185_ _280_ 0.00115f
C5265 fanout45/a_40_152# FILLER_25_7/a_40_246# 0.00203f
C5266 _674_/a_324_432# _490_/a_45_160# 0
C5267 _669_/a_298_337# clknet_4_9_0_clk 0
C5268 FILLER_26_88/a_40_246# net58 0.03326f
C5269 _060_ net127 0.09349f
C5270 hold171/a_438_182# clknet_4_4_0_clk 0
C5271 _062_ _400_/a_192_429# 0
C5272 net122 _405_/a_27_156# 0.01228f
C5273 hold177/a_56_118# VPWR 0.01454f
C5274 _307_ _313_ 0.00297f
C5275 _170_ _161_ -0
C5276 _431_/a_379_118# net25 0.00479f
C5277 hold133/a_326_118# _702_/a_38_114# 0
C5278 hold165/a_56_118# net165 0
C5279 _651_/a_2250_412# _007_ 0.00171f
C5280 hold65/a_438_182# net65 0.00124f
C5281 clknet_4_14_0_clk _421_/a_252_412# 0
C5282 clkbuf_4_0_0_clk/a_27_118# net135 0.00231f
C5283 _665_/a_298_337# tx_inst.state\[3\] 0
C5284 net82 _634_/a_298_337# 0
C5285 _278_ FILLER_11_134/a_32_246# 0
C5286 clkbuf_4_9_0_clk/a_27_118# clknet_4_9_0_clk 0.08659f
C5287 hold159/a_438_182# FILLER_4_108/a_40_246# 0.00217f
C5288 net168 _664_/a_1489_191# 0.01379f
C5289 net172 _664_/a_2002_114# 0.00118f
C5290 net156 net158 0.01828f
C5291 _385_/a_46_156# _382_/a_382_118# 0
C5292 _064_ _221_ 0
C5293 _680_/a_298_337# net136 0.01142f
C5294 net23 _704_/a_324_432# 0.00167f
C5295 hold116/a_326_118# _289_ 0.00249f
C5296 net75 fanout44/a_40_152# 0
C5297 tx_inst.data_reg\[6\] net41 0.05556f
C5298 _113_ _313_ 0.04589f
C5299 _511_/a_252_412# net29 0
C5300 net184 _341_/a_1377_160# 0.0428f
C5301 _361_/a_146_122# net173 0
C5302 _360_/a_1377_160# tx_inst.bit_index\[2\] 0
C5303 net28 _671_/a_843_236# 0.0016f
C5304 _277_ _671_/a_741_93# 0.01394f
C5305 _004_ _671_/a_324_432# 0.00448f
C5306 net2 _667_/a_298_337# 0
C5307 net122 net183 0
C5308 hold114/a_326_118# net46 0.00429f
C5309 net108 _289_ 0
C5310 output13/a_40_152# clknet_4_14_0_clk 0
C5311 _116_ _703_/a_681_505# 0.00126f
C5312 net29 _140_ 0.06403f
C5313 _345_/a_252_412# net75 0
C5314 _644_/a_1583_191# _044_ 0
C5315 clknet_0_clk _149_ 0
C5316 _303_ FILLER_22_32/a_40_246# 0
C5317 rx_inst.bit_index\[1\] _255_ 0
C5318 _017_ hold158/a_326_118# 0
C5319 _258_ _054_ 0.01239f
C5320 _514_/a_155_412# hold129/a_56_118# 0.03612f
C5321 _637_/a_612_127# clknet_4_15_0_clk 0.00379f
C5322 net82 net47 0.10587f
C5323 _026_ net99 0.03044f
C5324 hold172/a_326_118# _705_/a_843_236# 0
C5325 hold172/a_438_182# _705_/a_741_93# 0
C5326 net143 _156_ 0.00115f
C5327 _030_ _088_ 0.00301f
C5328 _681_/a_741_93# baud_inst.counter\[9\] 0
C5329 net54 net172 0.00213f
C5330 _180_ net130 0.08524f
C5331 net44 net87 0.07347f
C5332 net49 _253_ 0.03682f
C5333 net112 _446_/a_248_122# 0
C5334 clkbuf_4_10_0_clk/a_27_118# _548_/a_76_160# 0
C5335 net146 _199_ 0.00413f
C5336 output23/a_40_152# _707_/a_324_432# 0
C5337 hold162/a_326_118# net141 0.01625f
C5338 _170_ _429_/a_244_140# 0
C5339 hold162/a_56_118# _310_ 0.01809f
C5340 clknet_4_14_0_clk net24 0.77131f
C5341 _481_/a_22_110# VPWR 0.00357f
C5342 _283_ _677_/a_1583_191# 0
C5343 net122 _372_/a_22_110# 0.00526f
C5344 hold118/a_56_118# _639_/a_1583_191# 0
C5345 _171_ _365_/a_257_140# 0
C5346 net26 _365_/a_155_412# 0
C5347 hold103/a_326_118# _301_ 0.04847f
C5348 hold52/a_326_118# net25 0
C5349 _392_/a_285_412# VPWR 0.00423f
C5350 _234_ _671_/a_298_337# 0
C5351 hold175/a_326_118# net175 0.05355f
C5352 _035_ _683_/a_2250_412# 0
C5353 _031_ _700_/a_324_432# 0
C5354 net168 _364_/a_155_412# 0
C5355 net14 _637_/a_1785_429# 0
C5356 hold97/a_438_182# _288_ 0.05134f
C5357 fanout32/a_40_152# VPWR 0.0062f
C5358 net49 net29 0.11149f
C5359 FILLER_15_173/a_40_246# _250_ 0
C5360 _431_/a_81_118# _246_ 0.02859f
C5361 _653_/a_1583_191# _220_ 0
C5362 _292_ clknet_4_9_0_clk 0
C5363 clknet_4_3_0_clk FILLER_10_110/a_40_246# 0
C5364 _080_ _667_/a_38_114# 0.02935f
C5365 baud_inst.counter\[5\] clknet_0_clk 0.03438f
C5366 net42 _653_/a_132_114# 0
C5367 net22 _704_/a_741_93# 0.00328f
C5368 _059_ _138_ 0.09554f
C5369 _386_/a_285_412# net137 0.0021f
C5370 tx_inst.bit_index\[2\] _653_/a_2250_412# 0.00168f
C5371 _180_ clknet_4_8_0_clk 0.03691f
C5372 clk net170 0.00104f
C5373 _649_/a_38_114# rx_inst.data_reg\[6\] 0
C5374 _303_ _692_/a_1489_191# 0
C5375 _093_ hold117/a_56_118# 0.00104f
C5376 hold97/a_56_118# _682_/a_1583_191# 0
C5377 VPWR _015_ 0.04171f
C5378 _138_ _159_ 0
C5379 _059_ _232_ 0.16819f
C5380 hold119/a_56_118# _140_ 0.02796f
C5381 _136_ _137_ 0.16519f
C5382 _109_ _696_/a_324_432# 0.04566f
C5383 _174_ FILLER_3_177/a_32_246# 0.01945f
C5384 net173 FILLER_5_164/a_40_246# 0
C5385 net34 _196_ 0.20309f
C5386 hold117/a_326_118# _183_ 0
C5387 _640_/a_324_432# _111_ 0
C5388 _640_/a_741_93# net45 0.00216f
C5389 fanout42/a_40_152# _652_/a_1583_191# 0
C5390 _232_ _159_ 0.0095f
C5391 _255_ FILLER_22_152/a_32_246# 0
C5392 baud_inst.counter\[30\] net113 0
C5393 _067_ FILLER_3_141/a_40_246# 0.00355f
C5394 _634_/a_1583_191# _124_ 0
C5395 hold167/a_438_182# net123 0
C5396 hold155/a_326_118# _209_ 0
C5397 _263_ _161_ 0
C5398 rx_data[5] net18 0
C5399 _662_/a_1489_191# clk 0.00182f
C5400 rx_inst.bit_index\[1\] hold52/a_56_118# 0
C5401 _079_ net62 0.01971f
C5402 _644_/a_1840_334# _272_ 0
C5403 FILLER_0_115/a_40_246# _384_/a_59_156# 0.00885f
C5404 _198_ clkbuf_4_5_0_clk/a_27_118# 0
C5405 fanout38/a_40_152# FILLER_8_21/a_32_246# 0.00114f
C5406 _097_ _684_/a_38_114# 0.01972f
C5407 hold130/a_56_118# _190_ 0.02626f
C5408 VPWR _456_/a_257_140# 0
C5409 _170_ clkbuf_4_14_0_clk/a_27_118# 0.00835f
C5410 _346_/a_252_412# baud_inst.counter\[29\] 0
C5411 hold88/a_56_118# clkbuf_4_8_0_clk/a_27_118# 0.00458f
C5412 _048_ _633_/a_1583_191# 0
C5413 _660_/a_843_236# net55 0.00139f
C5414 _358_/a_72_436# _180_ 0.05724f
C5415 _530_/a_155_412# _690_/a_298_337# 0
C5416 hold132/a_56_118# net24 0
C5417 net1 net46 0.003f
C5418 hold175/a_326_118# _161_ 0.00167f
C5419 baud_inst.counter\[3\] clknet_4_0_0_clk 0.03026f
C5420 _183_ net152 0.18672f
C5421 hold163/a_326_118# VPWR 0.03115f
C5422 _237_ _161_ 0
C5423 net33 net21 0.20111f
C5424 clknet_4_3_0_clk net43 0.00772f
C5425 _009_ _508_/a_474_130# 0
C5426 _180_ _686_/a_1840_334# 0.00279f
C5427 net66 _643_/a_2250_412# 0.01086f
C5428 baud_inst.counter\[12\] VPWR 0.30813f
C5429 _684_/a_2250_412# net29 0.00215f
C5430 _526_/a_350_122# baud_inst.counter\[16\] 0
C5431 _696_/a_38_114# VPWR 0
C5432 net69 net71 0.00117f
C5433 net141 _310_ 0.34403f
C5434 _206_ _151_ 0
C5435 net179 _392_/a_382_118# 0.02513f
C5436 net94 _679_/a_1785_429# 0.00153f
C5437 net92 _679_/a_2250_412# 0
C5438 _283_ _679_/a_1840_334# 0.04606f
C5439 _285_ _679_/a_1583_191# 0.03892f
C5440 _652_/a_1785_429# _142_ 0.00153f
C5441 baud_inst.counter\[5\] _182_ 0
C5442 _132_ _228_ 0.004f
C5443 _053_ rx_inst.state\[2\] 0.00141f
C5444 hold136/a_326_118# VPWR 0.00896f
C5445 _155_ _138_ 0.25381f
C5446 _064_ _652_/a_2250_412# 0
C5447 net42 _652_/a_1785_429# 0
C5448 _409_/a_73_118# fanout28/a_40_152# 0
C5449 FILLER_19_77/a_32_246# net140 0
C5450 hold98/a_326_118# VPWR 0.01197f
C5451 fanout26/a_40_152# net62 0
C5452 hold140/a_326_118# clknet_4_11_0_clk 0
C5453 _661_/a_298_337# _661_/a_324_432# -0
C5454 hold114/a_326_118# _313_ 0.04798f
C5455 _706_/a_38_114# VPWR 0.00589f
C5456 _155_ _232_ 0.01993f
C5457 _645_/a_38_114# _253_ 0
C5458 FILLER_10_78/a_32_246# net152 0
C5459 hold122/a_438_182# _667_/a_843_236# 0
C5460 hold128/a_56_118# net29 0
C5461 _041_ _667_/a_38_114# 0
C5462 hold118/a_326_118# rx_inst.data_reg\[7\] 0.01536f
C5463 clknet_4_8_0_clk net140 0.14357f
C5464 VPWR net88 0.11003f
C5465 fanout43/a_40_152# fanout28/a_40_152# 0
C5466 tx_inst.bit_index\[1\] _219_ 0
C5467 net184 _195_ 0.0094f
C5468 _684_/a_843_236# net40 0.00744f
C5469 hold130/a_326_118# hold129/a_438_182# 0.00115f
C5470 hold130/a_438_182# hold129/a_326_118# 0.00115f
C5471 _294_ hold91/a_438_182# 0
C5472 _644_/a_1785_429# rx_inst.data_reg\[1\] 0
C5473 _660_/a_38_114# tx_inst.data_reg\[2\] 0.02282f
C5474 net154 net152 0
C5475 net122 _652_/a_1583_191# 0
C5476 net26 _458_/a_165_412# 0.00753f
C5477 _292_ _686_/a_2250_412# 0
C5478 net58 _702_/a_1840_334# 0.00232f
C5479 hold181/a_438_182# net181 0.04467f
C5480 net49 _444_/a_550_140# 0
C5481 _178_ clkbuf_4_11_0_clk/a_27_118# 0.00571f
C5482 baud_inst.counter\[7\] FILLER_6_98/a_40_246# 0
C5483 net94 hold96/a_326_118# 0.00397f
C5484 net92 hold96/a_56_118# 0.00675f
C5485 _169_ _667_/a_298_337# 0.00262f
C5486 _022_ _692_/a_1840_334# 0
C5487 tx_data[5] net8 0.00227f
C5488 _675_/a_38_114# FILLER_3_21/a_40_246# 0
C5489 _075_ _217_ 0
C5490 net51 net118 0
C5491 hold102/a_438_182# _103_ 0.00184f
C5492 hold160/a_326_118# baud_inst.counter\[17\] 0.01572f
C5493 baud_inst.counter\[28\] _701_/a_612_127# 0.00771f
C5494 _093_ hold115/a_326_118# 0
C5495 net2 _668_/a_2250_412# 0
C5496 net48 _633_/a_324_432# 0.04627f
C5497 _254_ _439_/a_252_412# 0.0016f
C5498 _256_ _439_/a_150_412# 0.00114f
C5499 net36 _445_/a_279_412# 0.00105f
C5500 _110_ _309_ 0
C5501 _537_/a_192_429# VPWR 0.00957f
C5502 _072_ VPWR 0.15761f
C5503 _645_/a_612_127# net132 0
C5504 net111 hold143/a_438_182# 0
C5505 hold115/a_438_182# _183_ 0
C5506 _707_/a_2250_412# hold80/a_326_118# 0.00103f
C5507 _227_ _449_/a_27_156# 0
C5508 _449_/a_229_118# net32 0
C5509 net123 _676_/a_2250_412# 0
C5510 _453_/a_170_412# _262_ 0
C5511 net152 net115 0
C5512 _117_ _663_/a_1583_191# 0.00381f
C5513 _464_/a_22_110# _264_ 0.00381f
C5514 net49 _694_/a_550_127# 0
C5515 net182 hold128/a_56_118# 0.00409f
C5516 _193_ FILLER_4_172/a_32_246# 0.02112f
C5517 net39 VPWR 1.16292f
C5518 clknet_0_clk _685_/a_38_114# 0.00426f
C5519 _650_/a_612_127# net30 0.01013f
C5520 _650_/a_1785_429# _266_ 0.00185f
C5521 _691_/a_843_236# hold163/a_438_182# 0
C5522 _676_/a_1785_429# _191_ 0
C5523 _230_ net180 0.10225f
C5524 FILLER_12_89/a_40_246# VPWR 0.13099f
C5525 _651_/a_298_337# clknet_4_6_0_clk 0.00872f
C5526 hold141/a_326_118# net46 0.01989f
C5527 net79 _066_ 0
C5528 hold177/a_438_182# clkbuf_4_8_0_clk/a_27_118# 0
C5529 hold111/a_438_182# clknet_0_clk 0.00203f
C5530 _674_/a_843_236# _279_ 0.00157f
C5531 hold157/a_326_118# net157 0.003f
C5532 _669_/a_1583_191# clknet_4_9_0_clk 0.00432f
C5533 _640_/a_2250_412# _236_ 0
C5534 _098_ clkload0/Y 0
C5535 net44 _690_/a_741_93# 0
C5536 net57 net27 0.00156f
C5537 _639_/a_741_93# VPWR 0.01459f
C5538 _425_/a_268_412# VPWR 0
C5539 _705_/a_298_337# _199_ 0
C5540 net37 _224_ 0.02955f
C5541 clknet_4_1_0_clk net60 0
C5542 hold183/a_438_182# _141_ 0
C5543 hold75/a_326_118# clknet_4_10_0_clk 0.06506f
C5544 _195_ _651_/a_324_432# 0
C5545 _121_ clknet_0_clk 0.00189f
C5546 net166 fanout31/a_40_152# 0
C5547 net6 _385_/a_46_156# 0.01843f
C5548 _680_/a_2002_114# net136 0
C5549 clknet_4_6_0_clk _166_ 0.03074f
C5550 VPWR _529_/a_45_160# 0.01983f
C5551 _446_/a_146_122# _257_ 0
C5552 _170_ fanout30/a_40_152# 0
C5553 _665_/a_1583_191# tx_inst.state\[3\] 0.01459f
C5554 _090_ hold93/a_56_118# 0
C5555 hold120/a_326_118# _108_ 0
C5556 _640_/a_298_337# net49 0
C5557 net168 tx_inst.state\[2\] 0.12587f
C5558 _393_/a_170_412# VPWR 0
C5559 tx_inst.data_reg\[6\] _392_/a_496_118# 0
C5560 _693_/a_38_114# _106_ 0.01808f
C5561 _211_ _382_/a_285_412# 0.00639f
C5562 _652_/a_298_337# FILLER_11_123/a_40_246# 0
C5563 net44 _697_/a_843_236# 0.00816f
C5564 _680_/a_1583_191# net136 0
C5565 tx_done _704_/a_1840_334# 0.00496f
C5566 net23 _704_/a_2250_412# 0
C5567 _206_ FILLER_4_108/a_40_246# 0
C5568 _195_ net169 0
C5569 net156 _688_/a_843_236# 0.02771f
C5570 hold156/a_326_118# _688_/a_2250_412# 0.00119f
C5571 net179 _706_/a_298_337# 0.00356f
C5572 _060_ _648_/a_843_236# 0
C5573 hold86/a_438_182# clknet_4_0_0_clk 0
C5574 hold104/a_56_118# VPWR 0.01553f
C5575 tx_inst.bit_index\[1\] tx_inst.bit_index\[2\] 0.14442f
C5576 net122 hold122/a_326_118# 0.00864f
C5577 net2 _667_/a_1583_191# 0
C5578 rx_inst.state\[2\] _451_/a_155_412# 0.00194f
C5579 _532_/a_155_412# fanout44/a_40_152# 0
C5580 _177_ _116_ 0.01228f
C5581 FILLER_25_9/a_32_246# _106_ 0
C5582 _349_/a_350_122# _182_ -0
C5583 hold115/a_438_182# net115 0.01248f
C5584 _516_/a_165_412# VPWR 0
C5585 _116_ _703_/a_550_127# 0
C5586 hold174/a_438_182# _217_ 0
C5587 clknet_4_3_0_clk net152 0.06861f
C5588 _117_ net2 0.02286f
C5589 _170_ _448_/a_142_412# 0.00728f
C5590 net38 _381_/a_46_156# 0
C5591 _484_/a_154_118# rx_inst.state\[3\] 0
C5592 net42 _663_/a_550_127# 0
C5593 _693_/a_132_114# VPWR 0
C5594 hold165/a_438_182# _656_/a_741_93# 0
C5595 hold165/a_326_118# _656_/a_843_236# 0
C5596 net34 tx_inst.data_reg\[0\] 0
C5597 _013_ net46 0
C5598 _237_ clkbuf_4_14_0_clk/a_27_118# 0
C5599 net49 FILLER_24_156/a_32_246# 0
C5600 net108 net135 0.0022f
C5601 _293_ hold129/a_56_118# 0.03392f
C5602 net72 clknet_4_15_0_clk 0.0334f
C5603 _681_/a_550_127# net117 0
C5604 _697_/a_741_93# clknet_0_clk 0.01612f
C5605 rx_data[2] hold82/a_326_118# 0
C5606 net14 hold82/a_438_182# 0.02266f
C5607 _360_/a_805_385# net41 0
C5608 _677_/a_550_127# _280_ 0
C5609 hold157/a_326_118# _298_ 0.00515f
C5610 hold89/a_56_118# _100_ 0.00788f
C5611 rx_inst.bit_index\[2\] hold180/a_438_182# 0
C5612 _154_ rx_inst.data_reg\[5\] 0
C5613 FILLER_22_118/a_32_246# _051_ 0
C5614 net135 net181 0.30308f
C5615 baud_inst.counter\[15\] _099_ 0
C5616 baud_inst.counter\[14\] net46 0.58155f
C5617 clkbuf_4_10_0_clk/a_27_118# _312_ 0.00246f
C5618 _187_ _100_ 0
C5619 FILLER_26_35/a_32_246# _314_ 0.01655f
C5620 rx_inst.bit_index\[2\] FILLER_21_165/a_40_246# 0
C5621 net55 _120_ 0.17039f
C5622 _012_ _515_/a_272_160# 0
C5623 hold139/a_438_182# _647_/a_298_337# 0
C5624 _642_/a_1583_191# _669_/a_2250_412# 0
C5625 _674_/a_1583_191# _033_ 0
C5626 baud_inst.counter\[8\] hold116/a_438_182# 0.01273f
C5627 clkbuf_0_clk/a_116_82# _670_/a_1840_334# 0.00223f
C5628 _352_/a_46_156# VPWR 0.0279f
C5629 net37 _235_ 0.30017f
C5630 _672_/a_1489_191# VPWR 0
C5631 _094_ net136 0.00174f
C5632 net168 _197_ 0.00656f
C5633 _704_/a_298_337# _121_ 0
C5634 net14 _048_ 0.0011f
C5635 net120 _021_ 0.07879f
C5636 _022_ net148 0.11386f
C5637 output20/a_40_152# _704_/a_2250_412# 0.00206f
C5638 hold151/a_56_118# _440_/a_142_412# 0
C5639 _496_/a_170_412# _182_ 0.00175f
C5640 net39 fanout39/a_40_152# 0.02256f
C5641 _058_ FILLER_17_199/a_40_246# 0
C5642 _646_/a_1583_191# _474_/a_22_110# 0
C5643 clknet_4_14_0_clk net30 0.0059f
C5644 _232_ _427_/a_248_122# 0
C5645 baud_inst.counter\[8\] net97 0.00265f
C5646 _471_/a_22_110# net77 0.02067f
C5647 _139_ _649_/a_132_114# 0
C5648 _653_/a_1489_191# _142_ 0.00123f
C5649 _637_/a_843_236# hold82/a_326_118# 0
C5650 net37 FILLER_12_128/a_40_246# 0.00203f
C5651 _555_/a_380_412# net49 0
C5652 _178_ _701_/a_38_114# 0
C5653 baud_inst.counter\[8\] net86 0.04023f
C5654 hold171/a_326_118# tx_inst.data_reg\[4\] 0.00322f
C5655 net92 _506_/a_257_140# 0
C5656 _659_/a_741_93# clknet_4_4_0_clk 0.02244f
C5657 _424_/a_142_412# _238_ 0.00172f
C5658 _383_/a_46_156# _381_/a_268_412# 0
C5659 net46 _685_/a_1489_191# 0
C5660 _691_/a_741_93# hold104/a_438_182# 0
C5661 _649_/a_1840_334# rx_inst.data_reg\[6\] 0
C5662 _672_/a_681_505# net60 0
C5663 _672_/a_843_236# _181_ 0.06174f
C5664 _639_/a_741_93# _266_ 0
C5665 fanout30/a_40_152# hold139/a_438_182# 0
C5666 _639_/a_843_236# net30 0.00193f
C5667 hold148/a_56_118# net147 0.04262f
C5668 VPWR _061_ 0.07049f
C5669 baud_inst.counter\[27\] FILLER_22_86/a_32_246# 0.02812f
C5670 hold148/a_56_118# net46 0
C5671 net122 net49 0.00207f
C5672 _082_ clknet_0_clk 0.00325f
C5673 _313_ _700_/a_324_432# 0.00572f
C5674 _637_/a_741_93# _048_ 0.00147f
C5675 _637_/a_324_432# net72 0.01437f
C5676 net121 baud_inst.counter\[21\] 0
C5677 net48 clkbuf_4_15_0_clk/a_27_118# 0.00251f
C5678 _695_/a_1840_334# clknet_4_10_0_clk 0.00269f
C5679 net92 _010_ 0
C5680 hold177/a_56_118# _163_ 0
C5681 _640_/a_1785_429# net45 0
C5682 FILLER_8_63/a_40_246# _683_/a_843_236# 0
C5683 hold57/a_56_118# fanout34/a_40_152# 0.00117f
C5684 FILLER_13_137/a_32_246# clkbuf_0_clk/a_116_82# 0
C5685 _046_ hold84/a_438_182# 0
C5686 baud_inst.counter\[23\] _699_/a_298_337# 0
C5687 baud_inst.counter\[21\] _699_/a_324_432# 0
C5688 baud_inst.counter\[5\] FILLER_10_110/a_40_246# 0.00866f
C5689 _691_/a_298_337# net163 0.01632f
C5690 _659_/a_132_114# net137 0
C5691 tx net11 0.08261f
C5692 net27 fanout27/a_40_152# 0.02954f
C5693 net163 baud_inst.counter\[19\] 0
C5694 _268_ net65 0
C5695 hold118/a_56_118# FILLER_16_221/a_32_246# 0
C5696 hold131/a_438_182# _159_ 0
C5697 FILLER_17_201/a_32_246# _156_ 0.02691f
C5698 clknet_0_clk _452_/a_155_412# 0.00118f
C5699 _040_ clk 0.00325f
C5700 clknet_4_4_0_clk _664_/a_38_114# 0.00927f
C5701 hold77/a_56_118# _463_/a_22_110# 0
C5702 fanout49/a_40_152# net1 0.03103f
C5703 clknet_4_7_0_clk _668_/a_843_236# 0
C5704 _126_ _650_/a_1583_191# 0
C5705 _474_/a_120_432# _273_ 0
C5706 _649_/a_843_236# _648_/a_741_93# 0
C5707 _649_/a_741_93# _648_/a_843_236# 0
C5708 baud_inst.counter\[30\] baud_inst.counter\[29\] 0.48436f
C5709 _640_/a_1840_334# _224_ 0
C5710 _377_/a_46_156# net38 0.00462f
C5711 _358_/a_411_436# _190_ 0.0011f
C5712 hold166/a_56_118# rx_inst.state\[3\] 0.05435f
C5713 net12 hold71/a_56_118# 0.00419f
C5714 net48 FILLER_21_192/a_40_246# 0
C5715 FILLER_12_82/a_32_246# net40 0
C5716 _018_ _690_/a_298_337# 0.00287f
C5717 _164_ _690_/a_324_432# 0.00312f
C5718 _302_ _690_/a_741_93# 0
C5719 _095_ _508_/a_380_412# 0
C5720 net31 _250_ 0.00323f
C5721 VPWR hold50/a_438_182# 0.00416f
C5722 _300_ baud_inst.counter\[16\] 0.03103f
C5723 _696_/a_1840_334# VPWR 0.00474f
C5724 _680_/a_1489_191# clknet_4_0_0_clk 0.00507f
C5725 _280_ _096_ 0
C5726 _017_ baud_inst.counter\[17\] 0.08151f
C5727 _688_/a_1583_191# _096_ 0
C5728 _517_/a_474_130# clknet_0_clk 0
C5729 _063_ _142_ 0.02999f
C5730 VPWR _433_/a_142_412# 0.00188f
C5731 _691_/a_324_432# _104_ 0.02672f
C5732 net69 _273_ 0.02432f
C5733 _076_ _664_/a_741_93# 0
C5734 net42 _063_ 0.20241f
C5735 net74 hold84/a_56_118# 0.00103f
C5736 net175 hold180/a_326_118# 0
C5737 net92 baud_inst.counter\[11\] 0
C5738 net2 _650_/a_38_114# 0
C5739 net44 _692_/a_38_114# 0
C5740 input11/a_40_152# net43 0
C5741 _079_ rx_inst.state\[3\] 0.00167f
C5742 output19/a_40_152# _240_ 0
C5743 VPWR _547_/a_277_118# 0
C5744 _546_/a_155_160# net46 0
C5745 _661_/a_298_337# clknet_4_1_0_clk 0
C5746 _706_/a_1840_334# VPWR 0.00903f
C5747 _077_ clknet_0_clk 0
C5748 hold122/a_56_118# _667_/a_1489_191# 0
C5749 _041_ _667_/a_1840_334# 0.04663f
C5750 FILLER_8_189/a_40_246# VPWR 0.13362f
C5751 net100 net45 0.1926f
C5752 clknet_4_5_0_clk net33 0
C5753 _684_/a_612_127# net40 0
C5754 _687_/a_38_114# FILLER_15_42/a_40_246# 0
C5755 _055_ rx_inst.data_reg\[1\] 0
C5756 hold152/a_438_182# clknet_4_3_0_clk 0.00196f
C5757 hold131/a_438_182# _155_ 0
C5758 _032_ _702_/a_1489_191# 0
C5759 _113_ _700_/a_132_114# 0
C5760 _201_ _203_ 0.84735f
C5761 net121 _694_/a_132_114# 0
C5762 hold166/a_438_182# clknet_0_clk 0
C5763 _169_ _667_/a_1583_191# 0.0091f
C5764 _662_/a_741_93# _206_ 0
C5765 clknet_0_clk _386_/a_59_156# 0.01835f
C5766 baud_inst.counter\[28\] net107 0.02348f
C5767 _099_ _686_/a_324_432# 0.02566f
C5768 net46 _686_/a_741_93# 0.0155f
C5769 _254_ _251_ 0.01527f
C5770 FILLER_24_229/a_32_246# VPWR 0.07824f
C5771 _305_ VPWR 0.18245f
C5772 _699_/a_298_337# net114 0.05166f
C5773 _534_/a_46_156# _304_ 0.08791f
C5774 rx_inst.state\[3\] fanout26/a_40_152# 0.01446f
C5775 _431_/a_81_118# FILLER_18_160/a_32_246# 0.00792f
C5776 net30 FILLER_19_228/a_40_246# 0.03122f
C5777 _170_ _154_ 0.0624f
C5778 _638_/a_298_337# _264_ 0.00485f
C5779 hold160/a_56_118# _688_/a_1583_191# 0.00336f
C5780 _376_/a_76_160# FILLER_6_205/a_40_246# 0
C5781 net154 _035_ 0.98087f
C5782 _428_/a_150_412# _244_ 0.00275f
C5783 clknet_0_clk _182_ 0.18416f
C5784 net30 rx_inst.state\[4\] 0
C5785 hold65/a_56_118# clknet_4_15_0_clk 0.03646f
C5786 hold127/a_326_118# _139_ 0
C5787 _662_/a_324_432# _074_ 0.01326f
C5788 clk FILLER_10_145/a_40_246# 0.00722f
C5789 hold161/a_56_118# net158 0.00278f
C5790 rx_data[5] hold71/a_326_118# 0
C5791 _116_ VPWR 0.21952f
C5792 _660_/a_612_127# _076_ 0
C5793 _671_/a_741_93# net62 0.02653f
C5794 clknet_0_clk _685_/a_1840_334# 0.01355f
C5795 _671_/a_324_432# _168_ 0.05271f
C5796 net119 net30 0.04074f
C5797 _061_ _266_ 0.03044f
C5798 _691_/a_1840_334# baud_inst.counter\[20\] 0
C5799 clknet_0_clk _666_/a_1489_191# 0.00209f
C5800 _651_/a_1583_191# clknet_4_6_0_clk 0.00979f
C5801 hold54/a_438_182# net11 0
C5802 _267_ _637_/a_38_114# 0
C5803 _242_ FILLER_23_143/a_32_246# 0.01941f
C5804 _061_ _167_ 0
C5805 hold67/a_438_182# VPWR 0.00643f
C5806 net29 _681_/a_2250_412# 0
C5807 _676_/a_843_236# VPWR 0.00263f
C5808 _669_/a_2002_114# clknet_4_9_0_clk 0
C5809 FILLER_12_46/a_32_246# _288_ 0
C5810 _062_ hold122/a_438_182# 0
C5811 hold101/a_326_118# hold157/a_326_118# 0.00127f
C5812 hold101/a_438_182# hold157/a_56_118# 0
C5813 _679_/a_298_337# VPWR 0.00303f
C5814 _044_ net77 0
C5815 _118_ _200_ 0.00807f
C5816 net119 _647_/a_324_432# 0
C5817 _061_ _647_/a_741_93# 0
C5818 net133 _115_ 0.20414f
C5819 _644_/a_38_114# _056_ 0
C5820 net15 _635_/a_1583_191# 0.00209f
C5821 hold175/a_438_182# _418_/a_46_156# 0
C5822 _379_/a_46_156# net9 0.02245f
C5823 _217_ _651_/a_1840_334# 0
C5824 VPWR _683_/a_843_236# 0.00152f
C5825 _170_ _405_/a_27_156# 0
C5826 _419_/a_154_118# _236_ 0
C5827 _216_ _396_/a_155_412# 0
C5828 baud_inst.counter\[14\] _685_/a_741_93# 0.00169f
C5829 _258_ _257_ 0.02754f
C5830 net4 net7 0.11848f
C5831 _665_/a_2002_114# tx_inst.state\[3\] 0
C5832 net49 _702_/a_38_114# 0
C5833 clk _392_/a_59_156# 0
C5834 clknet_4_3_0_clk FILLER_8_116/a_40_246# 0
C5835 _547_/a_81_118# net162 0
C5836 net34 hold57/a_326_118# 0
C5837 VPWR _701_/a_741_93# 0.00984f
C5838 _284_ _676_/a_324_432# 0
C5839 baud_inst.counter\[18\] _528_/a_277_118# 0.00218f
C5840 _640_/a_1583_191# net49 0
C5841 _672_/a_324_432# _087_ 0
C5842 _510_/a_248_122# _182_ 0
C5843 _659_/a_1785_429# _069_ 0
C5844 _693_/a_1840_334# _106_ 0
C5845 _211_ net137 0.06504f
C5846 hold154/a_56_118# net29 0
C5847 hold161/a_438_182# _103_ 0
C5848 net44 _697_/a_612_127# 0
C5849 _173_ _218_ 0
C5850 _194_ _217_ 0
C5851 _645_/a_298_337# _056_ 0.01124f
C5852 net49 fanout47/a_40_152# 0
C5853 net156 _688_/a_612_127# 0.01178f
C5854 net179 _706_/a_1583_191# 0
C5855 baud_inst.counter\[12\] _163_ 0.00148f
C5856 hold127/a_326_118# _648_/a_38_114# 0
C5857 _060_ _648_/a_612_127# 0
C5858 _519_/a_81_118# _684_/a_843_236# 0
C5859 _264_ _647_/a_843_236# 0
C5860 _070_ clkbuf_4_1_0_clk/a_27_118# 0
C5861 _286_ _183_ 0.03437f
C5862 _640_/a_2250_412# net2 0
C5863 net30 _433_/a_244_412# 0
C5864 _661_/a_843_236# net171 0
C5865 _661_/a_324_432# _148_ 0.01545f
C5866 clk _068_ 0
C5867 _012_ VPWR 0.02642f
C5868 hold87/a_438_182# clknet_4_8_0_clk 0.00365f
C5869 _678_/a_1583_191# hold92/a_56_118# 0
C5870 _170_ _160_ 0.05917f
C5871 hold146/a_56_118# clknet_0_clk 0.00328f
C5872 net42 clknet_4_7_0_clk 0.01709f
C5873 _180_ _687_/a_2250_412# 0
C5874 net167 net91 0.18802f
C5875 _167_ _433_/a_142_412# 0.00798f
C5876 _693_/a_1489_191# VPWR 0.00463f
C5877 hold140/a_56_118# _641_/a_298_337# 0
C5878 _377_/a_46_156# _655_/a_741_93# 0
C5879 _646_/a_2250_412# clknet_4_13_0_clk 0
C5880 _644_/a_681_505# _159_ 0
C5881 _644_/a_38_114# _134_ 0
C5882 _020_ VPWR 0.30662f
C5883 FILLER_26_88/a_40_246# net49 0.00159f
C5884 net120 hold149/a_56_118# 0
C5885 _685_/a_741_93# _685_/a_1489_191# 0
C5886 _163_ net88 0
C5887 _223_ _436_/a_244_140# 0
C5888 _697_/a_1785_429# clknet_0_clk 0
C5889 hold145/a_438_182# net145 0.01393f
C5890 tx_busy _704_/a_843_236# 0.02507f
C5891 FILLER_16_154/a_32_246# clknet_0_clk 0
C5892 _430_/a_170_412# net25 0.00131f
C5893 _134_ FILLER_23_158/a_40_246# 0
C5894 net182 hold154/a_56_118# 0
C5895 _663_/a_38_114# net26 0.00741f
C5896 hold140/a_438_182# hold99/a_326_118# 0
C5897 hold140/a_326_118# hold99/a_438_182# 0.00209f
C5898 net23 _707_/a_1489_191# 0
C5899 _089_ _142_ 0
C5900 net26 _372_/a_120_432# 0.00123f
C5901 net79 FILLER_2_79/a_40_246# 0
C5902 _513_/a_341_118# clknet_4_2_0_clk 0.00168f
C5903 clknet_4_3_0_clk _035_ 0
C5904 hold118/a_438_182# clknet_4_13_0_clk 0.00937f
C5905 hold181/a_326_118# net38 0.06066f
C5906 net42 _089_ 0
C5907 _132_ _669_/a_681_505# 0
C5908 clknet_4_12_0_clk _669_/a_843_236# 0
C5909 rx_inst.data_reg\[2\] _044_ 0.14997f
C5910 hold63/a_56_118# net43 0
C5911 _645_/a_843_236# _159_ 0.02376f
C5912 hold78/a_438_182# FILLER_29_179/a_40_246# 0.00941f
C5913 clknet_4_14_0_clk _428_/a_150_412# 0.00159f
C5914 _641_/a_1583_191# _263_ 0.00119f
C5915 VPWR net172 0.2918f
C5916 _424_/a_244_140# _139_ 0
C5917 baud_inst.counter\[5\] net152 0.10746f
C5918 net12 rx_data[0] 0.52827f
C5919 FILLER_24_229/a_32_246# _266_ 0
C5920 FILLER_24_19/a_40_246# _106_ 0
C5921 _170_ hold144/a_326_118# 0.00329f
C5922 baud_inst.counter\[0\] VPWR 0.1647f
C5923 tx_inst.bit_index\[1\] _657_/a_2250_412# 0
C5924 _651_/a_1583_191# net29 0
C5925 _704_/a_1583_191# _121_ 0
C5926 _302_ _692_/a_38_114# 0.01591f
C5927 _135_ _440_/a_244_140# 0.00105f
C5928 hold151/a_56_118# _158_ 0.00725f
C5929 net55 _654_/a_132_114# 0
C5930 _651_/a_741_93# _142_ 0
C5931 _533_/a_146_122# net164 0
C5932 baud_inst.counter\[8\] hold115/a_56_118# 0.00672f
C5933 net42 _651_/a_741_93# 0
C5934 _121_ net43 0.12967f
C5935 _292_ hold91/a_56_118# 0
C5936 _231_ _486_/a_494_160# 0
C5937 FILLER_13_100/a_40_246# VPWR 0.12348f
C5938 _662_/a_38_114# _203_ 0
C5939 net39 _163_ 0.00922f
C5940 _045_ clknet_4_15_0_clk 0.00519f
C5941 clknet_4_12_0_clk _057_ 0.0588f
C5942 net6 _655_/a_38_114# 0
C5943 _662_/a_2250_412# FILLER_2_237/a_40_246# 0.01012f
C5944 _444_/a_244_412# _256_ 0
C5945 _659_/a_1785_429# clknet_4_4_0_clk 0.00121f
C5946 _286_ net115 0.01412f
C5947 _692_/a_843_236# FILLER_22_22/a_32_246# 0
C5948 _142_ _007_ 0
C5949 _206_ _657_/a_298_337# 0
C5950 _691_/a_612_127# hold104/a_326_118# 0
C5951 _099_ clknet_4_9_0_clk 0.0265f
C5952 _691_/a_132_114# net104 0
C5953 _672_/a_612_127# _181_ 0
C5954 _672_/a_550_127# net60 0
C5955 net42 _007_ 0
C5956 _277_ _204_ 0.00302f
C5957 hold78/a_56_118# net13 0
C5958 _288_ _681_/a_324_432# 0
C5959 _650_/a_132_114# _140_ 0
C5960 _637_/a_1583_191# net17 0.00168f
C5961 _101_ _096_ 0
C5962 baud_inst.counter\[16\] net160 3.24693f
C5963 _019_ clknet_4_1_0_clk 0.00922f
C5964 _707_/a_843_236# _121_ 0.00176f
C5965 _045_ _158_ 0.08295f
C5966 rx_done _707_/a_2250_412# 0.01359f
C5967 FILLER_16_166/a_32_246# VPWR 0.08319f
C5968 _238_ net127 0
C5969 hold55/a_326_118# VPWR 0.00589f
C5970 baud_inst.counter\[24\] _687_/a_1840_334# 0
C5971 _641_/a_324_432# hold176/a_56_118# 0
C5972 _656_/a_741_93# tx_inst.data_reg\[0\] 0
C5973 _041_ FILLER_14_164/a_32_246# 0
C5974 net2 fanout37/a_40_152# 0.03432f
C5975 _691_/a_681_505# _020_ 0
C5976 _691_/a_1583_191# net163 0.00722f
C5977 _040_ hold54/a_438_182# 0.02044f
C5978 _646_/a_1583_191# net111 0
C5979 _153_ _459_/a_27_156# 0
C5980 net55 _391_/a_46_156# 0.00922f
C5981 _658_/a_2250_412# FILLER_3_150/a_40_246# 0
C5982 clknet_4_4_0_clk _664_/a_1840_334# 0
C5983 _122_ _273_ 0.00764f
C5984 _643_/a_298_337# _264_ 0.00191f
C5985 hold130/a_438_182# _685_/a_298_337# 0
C5986 _649_/a_1583_191# _648_/a_1583_191# 0
C5987 hold105/a_438_182# VPWR 0.00469f
C5988 net176 net100 0
C5989 net94 hold135/a_326_118# 0
C5990 _191_ _190_ 0.00117f
C5991 _645_/a_38_114# fanout47/a_40_152# 0.00414f
C5992 _640_/a_741_93# _051_ 0.00181f
C5993 clknet_4_5_0_clk FILLER_6_205/a_40_246# 0.0064f
C5994 _089_ _670_/a_298_337# 0
C5995 baud_inst.counter\[26\] net99 0.49961f
C5996 _686_/a_324_432# _685_/a_843_236# 0
C5997 _686_/a_741_93# _685_/a_741_93# 0.00142f
C5998 _690_/a_38_114# _103_ 0.0324f
C5999 baud_inst.counter\[7\] _280_ 0.00614f
C6000 _045_ _637_/a_324_432# 0
C6001 _677_/a_38_114# _036_ 0
C6002 baud_inst.counter\[13\] hold90/a_56_118# 0
C6003 _284_ _677_/a_843_236# 0
C6004 VPWR _156_ 0.18181f
C6005 _286_ clknet_4_3_0_clk 0
C6006 net109 _508_/a_209_168# 0.01959f
C6007 _017_ _688_/a_132_114# 0
C6008 _646_/a_132_114# _057_ 0
C6009 net26 _480_/a_120_432# 0.00884f
C6010 _171_ _480_/a_22_110# 0.00633f
C6011 net2 _650_/a_1840_334# 0
C6012 _186_ clknet_4_2_0_clk 0.00678f
C6013 hold101/a_56_118# net40 0.06597f
C6014 hold124/a_326_118# hold124/a_438_182# 0
C6015 fanout36/a_40_152# _237_ 0
C6016 net172 FILLER_7_234/a_32_246# 0
C6017 _515_/a_76_160# _180_ 0
C6018 _168_ _157_ 0
C6019 net111 net64 0.7989f
C6020 _351_/a_268_412# _162_ 0.00175f
C6021 _155_ _649_/a_843_236# 0
C6022 _230_ net37 0.66922f
C6023 _253_ _437_/a_154_118# 0.00382f
C6024 _315_ hold106/a_56_118# 0.02454f
C6025 rx_inst.state\[2\] VPWR 0.66319f
C6026 hold168/a_326_118# _192_ 0
C6027 _398_/a_115_308# tx_inst.data_reg\[5\] 0
C6028 net177 hold177/a_56_118# 0.00175f
C6029 _049_ _264_ 0.01854f
C6030 net100 FILLER_21_96/a_40_246# 0.02489f
C6031 net60 FILLER_0_40/a_40_246# 0
C6032 _309_ _540_/a_139_160# 0
C6033 tx_inst.bit_index\[0\] VPWR 0.09479f
C6034 _705_/a_843_236# VPWR 0.00222f
C6035 _169_ _667_/a_2002_114# 0
C6036 hold126/a_326_118# rx_inst.data_reg\[5\] 0
C6037 hold111/a_438_182# clkbuf_4_13_0_clk/a_27_118# 0
C6038 _697_/a_741_93# _110_ 0.01282f
C6039 _697_/a_324_432# net142 0.01054f
C6040 net46 _686_/a_1785_429# 0
C6041 _642_/a_38_114# _697_/a_1583_191# 0
C6042 _341_/a_382_118# tx_inst.bit_index\[2\] 0
C6043 _638_/a_1583_191# _264_ 0
C6044 baud_inst.counter\[8\] net38 0.11396f
C6045 _642_/a_324_432# _131_ 0
C6046 hold113/a_438_182# baud_inst.counter\[25\] 0
C6047 _299_ _522_/a_209_168# 0.0486f
C6048 rx_data[0] _632_/a_1583_191# 0.00142f
C6049 hold116/a_56_118# net108 0
C6050 baud_inst.counter\[27\] _180_ 0.65199f
C6051 hold152/a_438_182# baud_inst.counter\[5\] 0.04202f
C6052 net123 clknet_4_3_0_clk 0
C6053 hold142/a_326_118# hold100/a_326_118# 0.00159f
C6054 _078_ _666_/a_298_337# 0.0345f
C6055 _671_/a_2250_412# _168_ 0
C6056 _532_/a_257_140# VPWR 0
C6057 _184_ _683_/a_741_93# 0
C6058 hold183/a_326_118# VPWR 0.00751f
C6059 _508_/a_177_436# _096_ 0.0017f
C6060 _651_/a_2002_114# clknet_4_6_0_clk 0
C6061 _659_/a_843_236# clknet_0_clk 0
C6062 net33 _199_ 0
C6063 hold118/a_56_118# _047_ 0
C6064 _267_ _637_/a_1840_334# 0
C6065 _128_ _637_/a_1583_191# 0
C6066 _695_/a_38_114# VPWR 0.00509f
C6067 _669_/a_38_114# net91 0.00233f
C6068 _030_ _279_ 0.00547f
C6069 _676_/a_612_127# VPWR 0
C6070 hold85/a_326_118# _270_ 0.00692f
C6071 _270_ _635_/a_681_505# 0
C6072 hold85/a_56_118# _125_ 0.01894f
C6073 _496_/a_170_412# net152 0
C6074 net43 clknet_0_clk 0.26299f
C6075 net44 _103_ 0.07372f
C6076 net26 _224_ 0.81957f
C6077 _679_/a_1583_191# VPWR 0.01272f
C6078 _050_ VPWR 0.15336f
C6079 net15 _635_/a_2002_114# 0
C6080 _073_ _665_/a_843_236# 0.00201f
C6081 _040_ _665_/a_324_432# 0.00305f
C6082 net32 _224_ 0.6788f
C6083 hold165/a_438_182# net55 0
C6084 _658_/a_38_114# tx_inst.data_reg\[1\] 0
C6085 hold184/a_438_182# net183 0
C6086 net49 _702_/a_1840_334# 0
C6087 _265_ _668_/a_1583_191# 0
C6088 rx_inst.data_reg\[1\] _472_/a_120_432# 0
C6089 _073_ _166_ 0.00216f
C6090 _300_ _016_ 0
C6091 _272_ _648_/a_298_337# 0
C6092 net77 _648_/a_38_114# 0.00169f
C6093 _242_ _236_ 1.72933f
C6094 _640_/a_2002_114# net49 0
C6095 clkbuf_4_11_0_clk/a_27_118# _111_ 0.00302f
C6096 net44 net142 0.00322f
C6097 _006_ _665_/a_324_432# 0.00249f
C6098 _397_/a_165_412# _219_ 0.00409f
C6099 _275_ _665_/a_741_93# 0.00669f
C6100 _077_ net43 0.0346f
C6101 net44 _642_/a_132_114# 0
C6102 _645_/a_1583_191# _056_ 0
C6103 net156 net161 0.03356f
C6104 _284_ _683_/a_2250_412# 0
C6105 net31 _204_ 0
C6106 hold154/a_56_118# _493_/a_45_160# 0.00124f
C6107 hold166/a_56_118# _205_ 0
C6108 net128 _684_/a_843_236# 0
C6109 _295_ _684_/a_324_432# 0.00165f
C6110 _224_ hold62/a_326_118# 0
C6111 hold88/a_438_182# _684_/a_1840_334# 0
C6112 hold143/a_56_118# _240_ 0
C6113 hold114/a_56_118# clknet_4_8_0_clk 0.00136f
C6114 FILLER_1_30/a_32_246# _675_/a_324_432# 0
C6115 _266_ _156_ 0.17832f
C6116 net107 FILLER_25_36/a_32_246# 0.02803f
C6117 tx_inst.data_reg\[7\] _384_/a_59_156# 0
C6118 _661_/a_2250_412# _148_ 0.00422f
C6119 clknet_4_5_0_clk _369_/a_248_122# 0
C6120 clknet_4_1_0_clk _148_ 0.54212f
C6121 FILLER_8_116/a_40_246# baud_inst.counter\[5\] 0
C6122 _538_/a_277_118# _306_ 0
C6123 _538_/a_379_118# baud_inst.counter\[22\] 0
C6124 hold78/a_438_182# VPWR 0.01987f
C6125 hold148/a_56_118# _692_/a_324_432# 0
C6126 _109_ net99 0
C6127 _517_/a_209_168# clknet_4_8_0_clk 0
C6128 net44 _686_/a_132_114# 0
C6129 net133 _701_/a_1840_334# 0
C6130 hold154/a_438_182# net40 0
C6131 rx FILLER_13_228/a_40_246# 0
C6132 _167_ _156_ 0.0013f
C6133 hold165/a_438_182# _067_ 0
C6134 _207_ _655_/a_843_236# 0
C6135 hold165/a_56_118# clknet_4_4_0_clk 0.00294f
C6136 net43 _386_/a_59_156# 0.00326f
C6137 _644_/a_550_127# _159_ 0
C6138 hold59/a_56_118# _702_/a_741_93# 0.00291f
C6139 hold59/a_326_118# _702_/a_324_432# 0
C6140 baud_inst.counter\[27\] _695_/a_1785_429# 0
C6141 baud_inst.counter\[26\] _695_/a_2250_412# 0
C6142 hold120/a_326_118# _302_ 0.0047f
C6143 _184_ _185_ 0.05452f
C6144 baud_inst.counter\[27\] net140 0
C6145 _180_ net91 0.0095f
C6146 _685_/a_843_236# clknet_4_9_0_clk 0.03631f
C6147 _110_ clknet_0_clk 0.04454f
C6148 _156_ _647_/a_741_93# 0.00113f
C6149 tx_busy _704_/a_612_127# 0
C6150 rx _639_/a_324_432# 0
C6151 net2 _639_/a_38_114# 0.0158f
C6152 _642_/a_681_505# clknet_0_clk 0
C6153 _079_ _205_ 0.04129f
C6154 FILLER_18_148/a_40_246# hold180/a_326_118# 0
C6155 _376_/a_76_160# _375_/a_170_412# 0
C6156 _548_/a_76_160# _540_/a_45_160# 0
C6157 _062_ _651_/a_38_114# 0.01479f
C6158 _671_/a_681_505# clknet_0_clk 0
C6159 rx_inst.state\[2\] _167_ 0
C6160 _704_/a_298_337# net43 0
C6161 _684_/a_324_432# clknet_4_2_0_clk 0.00179f
C6162 _132_ _669_/a_550_127# 0
C6163 net43 _666_/a_1489_191# 0
C6164 FILLER_15_67/a_40_246# _294_ 0.02703f
C6165 net26 _235_ 0.00452f
C6166 _645_/a_612_127# _159_ 0.00343f
C6167 _645_/a_1583_191# _134_ 0
C6168 _226_ VPWR 0.23092f
C6169 hold159/a_326_118# net41 0.00288f
C6170 clknet_0_clk _686_/a_681_505# 0
C6171 net15 hold84/a_438_182# 0.01186f
C6172 rx_data[3] hold84/a_326_118# 0
C6173 net2 clkbuf_4_6_0_clk/a_27_118# 0
C6174 _170_ _140_ 0.0049f
C6175 net29 net25 0
C6176 net32 _235_ 0.04438f
C6177 _091_ _206_ 0
C6178 rx_inst.state\[2\] _225_ 0.18785f
C6179 net55 _654_/a_1489_191# 0.00422f
C6180 _651_/a_612_127# _220_ 0
C6181 _230_ _640_/a_1840_334# 0
C6182 net49 _693_/a_324_432# 0.02792f
C6183 _304_ net164 0.0013f
C6184 net147 clknet_4_10_0_clk 0.01662f
C6185 clk _388_/a_382_118# 0
C6186 _360_/a_1453_124# net34 0
C6187 net71 FILLER_26_229/a_32_246# 0.0135f
C6188 clknet_4_10_0_clk net46 0.3136f
C6189 _707_/a_324_432# _704_/a_324_432# 0.00323f
C6190 fanout26/a_40_152# _205_ 0
C6191 hold131/a_326_118# _244_ 0.00258f
C6192 _551_/a_170_160# _314_ 0
C6193 _035_ baud_inst.counter\[5\] 0.01764f
C6194 fanout30/a_40_152# _247_ 0
C6195 net6 _655_/a_1840_334# 0.01636f
C6196 tx_busy _707_/a_1840_334# 0.00483f
C6197 net125 _264_ 0
C6198 net39 clkbuf_4_1_0_clk/a_27_118# 0
C6199 net178 _189_ 0.0119f
C6200 net177 baud_inst.counter\[12\] 0.48361f
C6201 net11 _665_/a_2250_412# 0
C6202 baud_inst.counter\[14\] _686_/a_298_337# 0
C6203 net44 hold164/a_326_118# 0
C6204 hold138/a_438_182# VPWR 0.0041f
C6205 _658_/a_843_236# VPWR 0.00654f
C6206 clknet_4_0_0_clk net60 0.09937f
C6207 net92 _287_ 0.06861f
C6208 _050_ _266_ 0
C6209 _235_ hold62/a_326_118# 0
C6210 net81 net30 0.05749f
C6211 _690_/a_843_236# baud_inst.counter\[17\] 0.00487f
C6212 net116 _681_/a_1840_334# 0.00207f
C6213 _039_ _681_/a_1583_191# 0
C6214 _288_ _681_/a_2250_412# 0
C6215 hold69/a_438_182# _049_ 0
C6216 _634_/a_132_114# rx_inst.data_reg\[5\] 0
C6217 hold75/a_326_118# VPWR 0.00891f
C6218 tx_inst.bit_index\[2\] _397_/a_165_412# 0.00201f
C6219 _707_/a_612_127# _121_ 0.00146f
C6220 _231_ fanout43/a_40_152# 0
C6221 clknet_0_clk clkbuf_4_13_0_clk/a_27_118# 0.02398f
C6222 _170_ net49 0.40214f
C6223 _678_/a_38_114# FILLER_5_84/a_40_246# 0
C6224 _011_ _683_/a_324_432# 0
C6225 _163_ _683_/a_843_236# 0
C6226 _633_/a_324_432# FILLER_29_179/a_40_246# 0
C6227 baud_inst.counter\[22\] _694_/a_741_93# 0.03145f
C6228 hold53/a_326_118# _130_ 0.00515f
C6229 _656_/a_1785_429# tx_inst.data_reg\[0\] 0
C6230 net152 clknet_0_clk 0.02725f
C6231 clknet_4_7_0_clk FILLER_10_222/a_32_246# 0.00142f
C6232 _691_/a_550_127# _020_ 0
C6233 hold92/a_326_118# net40 0.00177f
C6234 tx_inst.data_reg\[5\] net137 0
C6235 net177 net88 0.01557f
C6236 hold69/a_56_118# _638_/a_2250_412# 0
C6237 hold69/a_438_182# _638_/a_1583_191# 0
C6238 hold69/a_326_118# _638_/a_1840_334# 0
C6239 hold130/a_326_118# _182_ 0
C6240 FILLER_19_118/a_32_246# _261_ 0
C6241 _535_/a_248_122# net49 0
C6242 hold66/a_56_118# _632_/a_324_432# 0
C6243 hold81/a_326_118# net19 0
C6244 net74 rx_inst.data_reg\[7\] 0
C6245 _227_ net2 0.07126f
C6246 FILLER_15_173/a_40_246# VPWR 0.14396f
C6247 _643_/a_1583_191# _264_ 0.02098f
C6248 tx_inst.data_reg\[6\] _656_/a_324_432# 0.01437f
C6249 _707_/a_324_432# net19 0.00156f
C6250 _677_/a_1489_191# VPWR -0
C6251 net36 _246_ 0.03082f
C6252 tx_data[1] net4 0.06824f
C6253 net27 _665_/a_38_114# 0
C6254 _302_ _103_ 0.06936f
C6255 _498_/a_165_412# clknet_0_clk 0
C6256 baud_inst.counter\[31\] net46 0.07791f
C6257 net87 _687_/a_681_505# 0
C6258 net27 _477_/a_22_110# 0.00432f
C6259 hold139/a_326_118# _241_ 0
C6260 net71 _637_/a_38_114# 0.00116f
C6261 net45 _701_/a_324_432# 0.04638f
C6262 _012_ _163_ 0
C6263 net28 _459_/a_27_156# 0.01923f
C6264 _486_/a_115_308# _002_ 0.00768f
C6265 net13 _633_/a_298_337# 0
C6266 output13/a_40_152# _633_/a_741_93# 0
C6267 net2 hold62/a_438_182# 0.00944f
C6268 VPWR _434_/a_252_412# -0
C6269 _346_/a_150_412# _027_ 0
C6270 hold102/a_56_118# net161 0
C6271 _646_/a_1489_191# _057_ 0
C6272 _707_/a_741_93# hold51/a_56_118# 0
C6273 net54 tx_inst.data_reg\[2\] 0.01757f
C6274 net44 _687_/a_298_337# 0.00271f
C6275 clknet_4_6_0_clk _668_/a_324_432# 0.02948f
C6276 _411_/a_358_436# net26 0.02671f
C6277 _053_ net46 0
C6278 hold149/a_438_182# net46 0.02943f
C6279 hold146/a_438_182# tx_inst.state\[4\] 0
C6280 _141_ FILLER_9_169/a_32_246# 0
C6281 net184 _379_/a_46_156# 0
C6282 _227_ _411_/a_115_308# 0.05228f
C6283 net151 FILLER_26_141/a_40_246# 0.00162f
C6284 _680_/a_132_114# _093_ 0
C6285 net109 VPWR 0.19234f
C6286 _641_/a_298_337# baud_inst.counter\[25\] 0.01274f
C6287 _656_/a_132_114# VPWR 0
C6288 net152 _182_ 0.02962f
C6289 hold74/a_438_182# _156_ 0
C6290 hold164/a_56_118# _692_/a_298_337# 0
C6291 hold131/a_326_118# clknet_4_14_0_clk 0.00296f
C6292 net69 _154_ 0
C6293 hold66/a_56_118# _467_/a_22_110# 0
C6294 _672_/a_298_337# _033_ 0.03261f
C6295 hold169/a_326_118# net26 0
C6296 hold158/a_56_118# net158 0.01874f
C6297 baud_inst.counter\[28\] _554_/a_146_122# 0
C6298 _680_/a_1583_191# _183_ 0
C6299 net148 _302_ 0.00544f
C6300 rx_inst.state\[2\] _486_/a_358_436# 0
C6301 _638_/a_2002_114# _264_ 0
C6302 net100 _051_ 0.00331f
C6303 _226_ _225_ 0.19677f
C6304 hold141/a_56_118# FILLER_19_77/a_32_246# 0
C6305 hold143/a_326_118# clknet_0_clk 0.0491f
C6306 _642_/a_1785_429# _262_ 0
C6307 _661_/a_843_236# net155 0
C6308 _661_/a_324_432# _151_ 0.00555f
C6309 _016_ net160 0
C6310 net157 _015_ 0.02206f
C6311 _299_ _296_ 1.11772f
C6312 _644_/a_324_432# _170_ 0.00118f
C6313 _498_/a_165_412# _182_ 0
C6314 hold103/a_56_118# net163 0
C6315 hold121/a_438_182# hold147/a_438_182# 0
C6316 _079_ _374_/a_142_412# 0.02489f
C6317 rx_data[7] hold81/a_56_118# 0.00297f
C6318 rx_data[1] net150 0
C6319 _060_ _244_ 0
C6320 net110 VPWR 0.01148f
C6321 fanout35/a_40_152# _223_ 0
C6322 _186_ _683_/a_1583_191# 0.03982f
C6323 hold87/a_438_182# _687_/a_2250_412# 0.00887f
C6324 _314_ hold106/a_326_118# 0.00619f
C6325 net32 FILLER_23_158/a_40_246# 0.01737f
C6326 clknet_4_10_0_clk _313_ 0.09922f
C6327 _455_/a_257_140# net24 0.00269f
C6328 net48 _636_/a_298_337# 0
C6329 _674_/a_324_432# _030_ 0.01785f
C6330 FILLER_6_189/a_40_246# _664_/a_324_432# 0
C6331 _083_ baud_inst.counter\[13\] 0.38783f
C6332 _695_/a_1840_334# VPWR 0.00554f
C6333 _034_ VPWR 0.04123f
C6334 _270_ _635_/a_550_127# 0
C6335 FILLER_14_70/a_40_246# _186_ 0
C6336 net124 _470_/a_120_432# 0
C6337 hold64/a_326_118# net66 0
C6338 _160_ _474_/a_120_432# 0.00195f
C6339 _073_ _665_/a_612_127# 0
C6340 _040_ _665_/a_2250_412# 0.00544f
C6341 _264_ hold73/a_438_182# 0.05457f
C6342 rx_inst.bit_index\[2\] _158_ 0
C6343 _537_/a_341_118# net49 0
C6344 FILLER_19_149/a_40_246# VPWR 0.14342f
C6345 _293_ _685_/a_132_114# 0
C6346 _058_ _436_/a_244_412# 0
C6347 hold141/a_438_182# net142 0
C6348 net55 _390_/a_59_156# 0.04574f
C6349 net123 baud_inst.counter\[5\] 0
C6350 _663_/a_1840_334# net50 0
C6351 _663_/a_2250_412# net146 0
C6352 _129_ _668_/a_1489_191# 0
C6353 rx_inst.data_reg\[1\] _123_ 0.00158f
C6354 _679_/a_2250_412# _036_ 0
C6355 hold164/a_326_118# _302_ 0.00135f
C6356 net40 net117 0.0202f
C6357 _677_/a_2250_412# _652_/a_298_337# 0
C6358 FILLER_15_173/a_40_246# _167_ 0
C6359 net31 _435_/a_268_436# 0
C6360 hold175/a_326_118# net49 0
C6361 hold74/a_56_118# clknet_4_13_0_clk 0
C6362 hold74/a_438_182# _050_ 0
C6363 net49 _237_ 0.0024f
C6364 FILLER_12_46/a_32_246# clknet_4_2_0_clk 0
C6365 clknet_0_clk _249_ 0.03186f
C6366 hold86/a_56_118# hold181/a_438_182# 0
C6367 _680_/a_1583_191# net115 0.00305f
C6368 VPWR hold80/a_326_118# 0.00463f
C6369 hold154/a_326_118# _281_ 0.01658f
C6370 FILLER_24_229/a_32_246# _638_/a_1489_191# 0
C6371 net179 fanout33/a_40_152# 0
C6372 _298_ _015_ 0.00173f
C6373 _680_/a_741_93# _504_/a_209_168# 0
C6374 baud_inst.counter\[22\] _306_ 0.12693f
C6375 FILLER_27_194/a_40_246# _471_/a_22_110# 0
C6376 net45 hold105/a_326_118# 0.00115f
C6377 hold100/a_56_118# _310_ 0.00172f
C6378 net44 _686_/a_1489_191# 0
C6379 net55 _655_/a_1489_191# 0.01521f
C6380 _678_/a_298_337# net93 0
C6381 _277_ VPWR 0.07916f
C6382 baud_inst.counter\[31\] _313_ 0.08394f
C6383 VPWR _381_/a_46_156# 0.00857f
C6384 _174_ clk 0
C6385 hold109/a_56_118# net40 0
C6386 _243_ _158_ 0
C6387 net128 hold128/a_438_182# 0.0081f
C6388 hold160/a_326_118# VPWR 0.0104f
C6389 _170_ _649_/a_38_114# 0
C6390 hold182/a_438_182# net29 0
C6391 _685_/a_612_127# clknet_4_9_0_clk 0
C6392 _204_ net62 0
C6393 clknet_4_8_0_clk baud_inst.counter\[15\] 0.17062f
C6394 _423_/a_165_412# hold180/a_56_118# 0
C6395 _170_ net131 0
C6396 net2 _242_ 0.07255f
C6397 net2 _639_/a_1840_334# 0.00505f
C6398 _227_ _169_ 0
C6399 _642_/a_550_127# clknet_0_clk 0
C6400 tx FILLER_8_238/a_32_246# 0.0013f
C6401 hold89/a_56_118# _296_ 0.01596f
C6402 _225_ _434_/a_252_412# 0.00742f
C6403 _390_/a_285_412# net6 0.00594f
C6404 clknet_4_13_0_clk _638_/a_843_236# 0
C6405 _663_/a_741_93# _200_ 0
C6406 _062_ _651_/a_1840_334# 0
C6407 _689_/a_550_127# net158 0
C6408 _671_/a_550_127# clknet_0_clk 0
C6409 _187_ _296_ 0.05148f
C6410 net48 net19 0.01208f
C6411 _075_ FILLER_8_191/a_32_246# 0
C6412 _684_/a_2250_412# clknet_4_2_0_clk 0
C6413 _280_ _685_/a_324_432# 0
C6414 baud_inst.counter\[24\] _541_/a_177_436# 0.0013f
C6415 net140 _541_/a_380_412# 0
C6416 _193_ _176_ 0
C6417 _689_/a_1583_191# _688_/a_324_432# 0
C6418 net45 net113 0.00346f
C6419 _659_/a_843_236# net43 0
C6420 clknet_0_clk _686_/a_550_127# 0
C6421 _060_ clknet_4_14_0_clk 0.00132f
C6422 _353_/a_146_122# _183_ 0
C6423 clkbuf_0_clk/a_116_82# _002_ 0.00377f
C6424 net55 tx_inst.data_reg\[0\] 0.29654f
C6425 _482_/a_154_118# VPWR 0
C6426 _692_/a_843_236# clknet_4_8_0_clk 0
C6427 net49 _693_/a_2250_412# 0.00105f
C6428 clkbuf_4_6_0_clk/a_27_118# _084_ 0.03428f
C6429 _169_ hold62/a_438_182# 0.02985f
C6430 _046_ hold138/a_56_118# 0
C6431 _360_/a_886_118# _175_ 0
C6432 _360_/a_1377_160# net34 0
C6433 _369_/a_248_122# _199_ 0
C6434 baud_inst.counter\[13\] _670_/a_550_127# 0
C6435 FILLER_8_116/a_40_246# clknet_0_clk 0
C6436 hold146/a_438_182# FILLER_7_210/a_40_246# 0
C6437 _189_ _297_ 0
C6438 VPWR _633_/a_324_432# 0.01593f
C6439 hold132/a_438_182# net49 0.00185f
C6440 hold182/a_438_182# net182 0.02873f
C6441 net39 _063_ 0
C6442 _707_/a_1583_191# _704_/a_843_236# 0
C6443 _707_/a_843_236# _704_/a_1583_191# 0
C6444 FILLER_18_65/a_40_246# _687_/a_1583_191# 0.00247f
C6445 _641_/a_38_114# net140 0
C6446 _673_/a_741_93# net95 0.00307f
C6447 _673_/a_843_236# net29 0
C6448 hold63/a_56_118# net51 0.00657f
C6449 hold150/a_326_118# net150 0.03717f
C6450 net103 _100_ 0.19766f
C6451 hold142/a_56_118# _696_/a_741_93# 0
C6452 hold157/a_326_118# hold157/a_438_182# -0
C6453 _638_/a_843_236# net65 0
C6454 _638_/a_741_93# _122_ 0
C6455 _195_ _142_ 0
C6456 _217_ _220_ 0.00787f
C6457 _018_ baud_inst.counter\[17\] 0.00338f
C6458 baud_inst.counter\[14\] _686_/a_1583_191# 0.01624f
C6459 _390_/a_59_156# _389_/a_46_156# 0
C6460 _658_/a_612_127# VPWR 0
C6461 net42 _195_ 0
C6462 _707_/a_843_236# net43 0
C6463 _690_/a_612_127# baud_inst.counter\[17\] 0.00353f
C6464 _644_/a_843_236# clknet_4_14_0_clk 0.03781f
C6465 _039_ _681_/a_2002_114# 0
C6466 _143_ _339_/a_1453_124# 0.00129f
C6467 baud_inst.counter\[12\] _188_ 0.00156f
C6468 hold52/a_56_118# _425_/a_46_156# 0.00167f
C6469 tx_inst.data_reg\[1\] _382_/a_559_412# 0
C6470 _171_ _665_/a_843_236# 0
C6471 tx_inst.bit_index\[2\] _219_ 0.77122f
C6472 hold87/a_438_182# _515_/a_76_160# 0
C6473 net51 _121_ 0.15529f
C6474 FILLER_16_176/a_40_246# net28 0
C6475 _059_ net127 0
C6476 _180_ FILLER_23_83/a_32_246# 0.00335f
C6477 _118_ net22 0.00759f
C6478 output23/a_40_152# VPWR 0.00588f
C6479 net31 _438_/a_248_122# 0
C6480 baud_inst.counter\[22\] _694_/a_1785_429# 0.00112f
C6481 hold98/a_438_182# _681_/a_843_236# 0
C6482 _171_ _166_ 0
C6483 _067_ tx_inst.data_reg\[0\] 0
C6484 clknet_4_4_0_clk _144_ 0
C6485 _045_ hold82/a_326_118# 0
C6486 net69 _638_/a_1785_429# 0
C6487 net27 _651_/a_843_236# 0.01225f
C6488 hold178/a_438_182# _509_/a_155_412# 0
C6489 net49 _104_ 0.00775f
C6490 _645_/a_741_93# clknet_4_14_0_clk 0.02272f
C6491 VPWR _455_/a_155_412# 0.01304f
C6492 _316_ _180_ 0.00561f
C6493 net66 _632_/a_741_93# 0.00274f
C6494 hold86/a_56_118# net135 0
C6495 net100 _698_/a_324_432# 0.01578f
C6496 hold100/a_326_118# _698_/a_1583_191# 0.00358f
C6497 _008_ _674_/a_324_432# 0
C6498 _643_/a_2002_114# _264_ 0
C6499 tx_inst.data_reg\[6\] _656_/a_2250_412# 0.00477f
C6500 _188_ net88 0
C6501 _180_ clkbuf_4_8_0_clk/a_27_118# 0
C6502 FILLER_19_75/a_40_246# net162 0.0319f
C6503 _225_ FILLER_19_149/a_40_246# 0.00306f
C6504 _682_/a_741_93# net117 0
C6505 hold97/a_438_182# hold110/a_438_182# 0.00882f
C6506 hold64/a_56_118# _635_/a_1583_191# 0.00308f
C6507 baud_inst.counter\[1\] hold60/a_326_118# 0.00635f
C6508 _655_/a_1583_191# _213_ 0
C6509 _091_ _678_/a_843_236# 0.00337f
C6510 output21/a_40_152# _200_ 0
C6511 _191_ _685_/a_324_432# 0
C6512 net48 _457_/a_22_110# 0.00242f
C6513 _241_ _433_/a_244_140# 0
C6514 hold85/a_56_118# net16 0
C6515 FILLER_8_116/a_40_246# _386_/a_59_156# 0
C6516 rx_data[7] _636_/a_2250_412# 0
C6517 _035_ clknet_0_clk 0.05241f
C6518 _644_/a_38_114# FILLER_25_150/a_32_246# 0
C6519 _377_/a_46_156# VPWR 0.00527f
C6520 _343_/a_155_412# net34 0
C6521 _690_/a_1489_191# clknet_4_8_0_clk 0
C6522 _686_/a_38_114# clknet_4_9_0_clk 0.00784f
C6523 hold77/a_56_118# net30 0.08622f
C6524 _112_ _699_/a_324_432# 0.04096f
C6525 _192_ net169 0
C6526 net87 _687_/a_550_127# 0
C6527 net152 FILLER_10_110/a_40_246# 0.04937f
C6528 net71 _637_/a_1840_334# 0
C6529 net45 _701_/a_2250_412# 0.00354f
C6530 _284_ FILLER_10_78/a_32_246# 0
C6531 _277_ _266_ 0
C6532 _531_/a_209_168# _299_ 0
C6533 net8 _210_ 0
C6534 net13 _633_/a_1583_191# 0.01506f
C6535 net148 hold148/a_326_118# 0
C6536 _076_ tx_inst.data_reg\[0\] 0
C6537 FILLER_9_79/a_32_246# _183_ 0
C6538 net173 _141_ 0
C6539 clknet_4_14_0_clk _443_/a_354_412# 0
C6540 hold168/a_326_118# net168 0.01465f
C6541 hold168/a_438_182# net172 0
C6542 _229_ _423_/a_165_412# 0
C6543 _154_ _122_ 0.00138f
C6544 _284_ net154 0.07399f
C6545 _360_/a_71_118# _656_/a_843_236# 0
C6546 net97 _282_ 0
C6547 net46 _308_ 0
C6548 baud_inst.counter\[1\] hold135/a_326_118# 0
C6549 _198_ tx_inst.state\[2\] 0.00957f
C6550 hold62/a_438_182# _084_ 0.00183f
C6551 hold149/a_438_182# fanout49/a_40_152# 0
C6552 hold175/a_438_182# FILLER_19_139/a_40_246# 0
C6553 net48 _058_ 1.76712f
C6554 VPWR FILLER_26_151/a_32_246# 0.07917f
C6555 net44 _687_/a_1583_191# 0.01582f
C6556 _386_/a_496_118# _211_ 0.00259f
C6557 net28 _647_/a_843_236# 0
C6558 _648_/a_38_114# _648_/a_132_114# 0
C6559 _660_/a_1840_334# _654_/a_298_337# 0
C6560 _660_/a_1583_191# _654_/a_38_114# 0
C6561 FILLER_5_84/a_40_246# net29 0
C6562 clknet_4_6_0_clk _668_/a_2250_412# 0
C6563 _230_ net26 0
C6564 tx_data[1] net40 0.00162f
C6565 _380_/a_59_156# net170 0.00514f
C6566 hold55/a_56_118# rx 0
C6567 net9 _146_ 0.0148f
C6568 _155_ net127 0
C6569 _546_/a_192_429# _026_ 0.0132f
C6570 _145_ _209_ 0
C6571 _230_ net32 1.35607f
C6572 _641_/a_1583_191# baud_inst.counter\[25\] 0
C6573 net73 net2 0
C6574 _656_/a_1489_191# VPWR 0
C6575 _646_/a_681_505# _240_ 0
C6576 _124_ _648_/a_2250_412# 0
C6577 hold52/a_438_182# net32 0
C6578 _672_/a_132_114# net61 0
C6579 _672_/a_1583_191# _033_ 0
C6580 _466_/a_120_432# _264_ 0
C6581 _114_ baud_inst.counter\[22\] 0.04046f
C6582 _694_/a_324_432# _107_ 0.02371f
C6583 _633_/a_324_432# _266_ 0
C6584 _633_/a_741_93# net30 0.00236f
C6585 _659_/a_324_432# _211_ 0.03717f
C6586 net31 VPWR 0.55853f
C6587 _128_ hold72/a_326_118# 0
C6588 net12 _632_/a_1489_191# 0
C6589 _132_ _261_ 0
C6590 _644_/a_2250_412# _170_ 0
C6591 _053_ _262_ 0
C6592 _661_/a_612_127# net155 0.00231f
C6593 _228_ _409_/a_73_118# 0.00131f
C6594 net79 input4/a_40_152# 0
C6595 _151_ clknet_4_1_0_clk 0
C6596 _379_/a_268_412# _206_ 0
C6597 _035_ _182_ 0.04314f
C6598 hold101/a_438_182# _296_ 0.0048f
C6599 _248_ _228_ 0
C6600 _184_ _096_ 0
C6601 _186_ _683_/a_2002_114# 0.00142f
C6602 _410_/a_257_140# net49 0
C6603 _656_/a_843_236# input9/a_40_152# 0
C6604 _656_/a_298_337# net9 0.00134f
C6605 _671_/a_741_93# _671_/a_1583_191# -0
C6606 net48 _636_/a_1583_191# 0.00295f
C6607 _076_ _365_/a_155_412# 0
C6608 hold161/a_56_118# net161 0.00113f
C6609 net177 _012_ 0
C6610 clknet_4_7_0_clk _639_/a_741_93# 0
C6611 _198_ _197_ 0.0128f
C6612 net39 _089_ 2.14708f
C6613 baud_inst.counter\[14\] _687_/a_38_114# 0
C6614 baud_inst.counter\[15\] _687_/a_324_432# 0
C6615 rx_inst.data_reg\[4\] _647_/a_1583_191# 0.00231f
C6616 _155_ _271_ 0
C6617 net124 _124_ 0.00271f
C6618 _660_/a_38_114# clknet_4_5_0_clk 0
C6619 hold179/a_326_118# net55 0.00165f
C6620 net31 _239_ 0.0264f
C6621 FILLER_15_17/a_40_246# hold102/a_56_118# 0.00786f
C6622 VPWR clkbuf_4_15_0_clk/a_27_118# 0.05813f
C6623 _160_ _122_ 0
C6624 _194_ FILLER_7_176/a_32_246# 0.02056f
C6625 _058_ _250_ 0.19037f
C6626 _129_ rx_inst.state\[1\] 0.00204f
C6627 clknet_4_6_0_clk _667_/a_1583_191# 0
C6628 _017_ VPWR 0.0824f
C6629 hold65/a_438_182# hold72/a_326_118# 0
C6630 _429_/a_244_412# _158_ 0.00217f
C6631 fanout30/a_40_152# _234_ 0
C6632 net184 hold184/a_56_118# 0
C6633 _534_/a_46_156# _021_ 0
C6634 hold97/a_56_118# _183_ 0
C6635 hold97/a_326_118# baud_inst.counter\[10\] 0.01854f
C6636 _284_ clknet_4_3_0_clk 0.05498f
C6637 _692_/a_741_93# net164 0
C6638 _692_/a_324_432# clknet_4_10_0_clk 0.00631f
C6639 net51 clknet_0_clk 0.06046f
C6640 FILLER_15_185/a_32_246# hold119/a_326_118# 0
C6641 _082_ clknet_4_12_0_clk 0
C6642 net82 _123_ 0
C6643 hold111/a_326_118# net64 0.00725f
C6644 _655_/a_38_114# net181 0.00303f
C6645 _339_/a_886_118# clknet_4_4_0_clk 0
C6646 baud_inst.counter\[7\] hold93/a_438_182# 0
C6647 tx _705_/a_324_432# 0.00123f
C6648 _177_ net46 2.14216f
C6649 _179_ clknet_0_clk 0
C6650 _078_ _215_ 0.0033f
C6651 _351_/a_46_156# VPWR 0.00382f
C6652 _513_/a_435_412# _189_ 0
C6653 _156_ hold73/a_326_118# 0
C6654 _689_/a_324_432# _101_ 0.05294f
C6655 FILLER_24_229/a_32_246# net18 0.00101f
C6656 FILLER_21_192/a_40_246# VPWR 0.1348f
C6657 tx_inst.data_reg\[4\] net54 0
C6658 _001_ _666_/a_612_127# 0
C6659 _678_/a_298_337# clknet_4_1_0_clk 0.00173f
C6660 tx_inst.state\[4\] _376_/a_76_160# 0
C6661 FILLER_13_89/a_40_246# VPWR 0.13412f
C6662 _680_/a_741_93# _287_ 0
C6663 _680_/a_324_432# _038_ 0
C6664 _680_/a_843_236# net135 0
C6665 hold157/a_326_118# net40 0
C6666 hold70/a_438_182# rx_inst.data_reg\[6\] 0.01209f
C6667 _114_ _694_/a_2250_412# 0.00426f
C6668 net3 _380_/a_496_118# 0.00288f
C6669 _375_/a_170_412# _199_ 0.00372f
C6670 clk _658_/a_324_432# 0
C6671 net55 tx_inst.data_reg\[1\] 0.0128f
C6672 net94 net97 0
C6673 net92 net108 0.00573f
C6674 FILLER_10_147/a_32_246# _667_/a_741_93# 0
C6675 _102_ baud_inst.counter\[16\] 0
C6676 hold59/a_56_118# _115_ 0
C6677 net120 _106_ 0.03304f
C6678 rx_inst.state\[2\] _052_ 0
C6679 _407_/a_146_122# net175 0.00584f
C6680 net49 _701_/a_132_114# 0
C6681 net94 net86 0.00837f
C6682 net92 net181 0.00278f
C6683 _685_/a_324_432# hold91/a_438_182# 0
C6684 _248_ _153_ 0
C6685 _241_ hold180/a_56_118# 0.00704f
C6686 clknet_4_12_0_clk clknet_0_clk 1.29866f
C6687 hold152/a_438_182# FILLER_10_110/a_40_246# 0.00941f
C6688 hold121/a_438_182# _693_/a_1583_191# 0
C6689 net121 _693_/a_741_93# 0.03086f
C6690 net159 net6 0.11242f
C6691 net123 clknet_0_clk 0.03338f
C6692 hold162/a_56_118# _696_/a_324_432# 0
C6693 _031_ VPWR 0.18753f
C6694 _313_ _308_ 0.01541f
C6695 _663_/a_612_127# net168 0
C6696 input1/a_40_152# rst 0.02785f
C6697 hold66/a_326_118# _635_/a_843_236# 0
C6698 hold66/a_438_182# _635_/a_741_93# 0
C6699 hold166/a_438_182# net51 0.00996f
C6700 _309_ net162 0.15541f
C6701 hold181/a_326_118# VPWR 0.00616f
C6702 net146 _166_ 0.98418f
C6703 FILLER_11_32/a_32_246# _688_/a_1583_191# 0
C6704 _643_/a_324_432# net111 0
C6705 _675_/a_324_432# net38 0.07394f
C6706 _286_ _182_ 0.50244f
C6707 _689_/a_2250_412# _688_/a_1583_191# 0
C6708 _689_/a_1489_191# _688_/a_741_93# 0
C6709 _206_ _392_/a_285_118# 0.00153f
C6710 clknet_4_1_0_clk FILLER_4_108/a_40_246# 0
C6711 clkbuf_0_clk/a_116_82# FILLER_14_148/a_40_246# 0
C6712 net2 net118 0.01324f
C6713 FILLER_15_89/a_32_246# hold90/a_438_182# 0.00985f
C6714 _261_ _451_/a_257_140# 0.00309f
C6715 net31 _167_ 0.01115f
C6716 FILLER_2_46/a_40_246# _085_ 0
C6717 tx_inst.bit_index\[1\] net34 0.26108f
C6718 _067_ tx_inst.data_reg\[1\] 0
C6719 baud_inst.counter\[8\] FILLER_8_63/a_40_246# 0
C6720 rx_data[1] _158_ 0.00101f
C6721 hold68/a_326_118# _028_ 0
C6722 _230_ hold175/a_438_182# 0.00877f
C6723 hold90/a_56_118# net29 0.01434f
C6724 VPWR _633_/a_2250_412# 0.00307f
C6725 _133_ FILLER_20_177/a_32_246# 0
C6726 _707_/a_2250_412# _704_/a_2250_412# 0.0027f
C6727 net51 _704_/a_298_337# 0
C6728 _673_/a_612_127# net29 0.00116f
C6729 net45 baud_inst.counter\[29\] 0.05042f
C6730 FILLER_11_144/a_32_246# _667_/a_741_93# 0.00112f
C6731 net81 hold73/a_56_118# 0
C6732 _050_ hold73/a_326_118# 0
C6733 net84 _635_/a_324_432# 0.00469f
C6734 _638_/a_612_127# net65 0
C6735 net31 _225_ 0.29592f
C6736 clknet_4_8_0_clk clknet_4_9_0_clk 0
C6737 _667_/a_1583_191# net29 0
C6738 baud_inst.counter\[14\] _686_/a_2002_114# 0.00111f
C6739 _390_/a_382_118# _213_ 0.01671f
C6740 net43 _664_/a_2250_412# 0.0023f
C6741 _707_/a_612_127# net43 0
C6742 _404_/a_46_156# VPWR 0.0061f
C6743 _644_/a_612_127# clknet_4_14_0_clk 0.00368f
C6744 _143_ _339_/a_1377_160# 0.00136f
C6745 _220_ _667_/a_843_236# 0
C6746 rx_inst.state\[2\] _406_/a_154_118# 0
C6747 _415_/a_170_412# net49 0
C6748 _266_ clkbuf_4_15_0_clk/a_27_118# 0
C6749 hold52/a_326_118# _242_ 0
C6750 clk _042_ 0
C6751 net136 _681_/a_1583_191# 0.00131f
C6752 _171_ _665_/a_612_127# 0
C6753 net42 _667_/a_741_93# 0
C6754 hold156/a_438_182# baud_inst.counter\[16\] 0.00206f
C6755 _081_ _671_/a_2250_412# 0.00138f
C6756 _517_/a_209_168# _515_/a_76_160# 0
C6757 net49 hold180/a_326_118# 0.00573f
C6758 _673_/a_681_505# _086_ 0.00136f
C6759 _673_/a_132_114# net40 0
C6760 net172 _665_/a_298_337# 0
C6761 baud_inst.counter\[22\] _107_ 0.01738f
C6762 net45 _303_ 0
C6763 _009_ _681_/a_1840_334# 0
C6764 _230_ FILLER_25_150/a_32_246# 0
C6765 _092_ FILLER_5_59/a_40_246# 0.00227f
C6766 _498_/a_165_412# net152 0
C6767 FILLER_23_143/a_32_246# net52 0.01302f
C6768 clk _656_/a_843_236# 0.02535f
C6769 _466_/a_22_110# FILLER_16_203/a_32_246# 0
C6770 _646_/a_132_114# clknet_0_clk 0
C6771 fanout48/a_40_152# FILLER_29_145/a_40_246# 0.01f
C6772 net45 _695_/a_1583_191# 0
C6773 _678_/a_550_127# net40 0
C6774 net27 _651_/a_612_127# 0
C6775 hold178/a_438_182# _290_ 0.00158f
C6776 net89 net88 0.0269f
C6777 net74 rx_inst.data_reg\[4\] 0
C6778 _645_/a_1785_429# clknet_4_14_0_clk 0.00118f
C6779 net106 hold107/a_56_118# 0.07943f
C6780 VPWR _130_ 0.06644f
C6781 net122 _667_/a_298_337# 0.00491f
C6782 _668_/a_1583_191# _668_/a_2250_412# 0
C6783 FILLER_3_207/a_40_246# _120_ 0.00418f
C6784 _021_ _692_/a_612_127# 0
C6785 clknet_4_0_0_clk FILLER_5_32/a_40_246# 0
C6786 net48 hold112/a_326_118# 0.0235f
C6787 _422_/a_248_122# VPWR 0
C6788 net12 _635_/a_2250_412# 0.00169f
C6789 net174 _276_ 0.01936f
C6790 _091_ _678_/a_612_127# 0
C6791 _436_/a_244_140# _136_ 0
C6792 _436_/a_550_140# _249_ 0.0011f
C6793 FILLER_21_192/a_40_246# _266_ 0
C6794 net173 _197_ 0
C6795 tx_inst.state\[1\] hold50/a_326_118# 0.02023f
C6796 clknet_4_7_0_clk hold50/a_438_182# 0
C6797 _686_/a_2250_412# net130 0
C6798 _686_/a_1840_334# clknet_4_9_0_clk 0.00117f
C6799 _444_/a_244_412# _159_ 0
C6800 _339_/a_71_118# clknet_0_clk 0.03041f
C6801 _527_/a_435_412# net101 0.00129f
C6802 _059_ _648_/a_843_236# 0.00109f
C6803 net79 _673_/a_741_93# 0.05505f
C6804 VPWR _666_/a_38_114# 0.02579f
C6805 _294_ _684_/a_1489_191# 0
C6806 clknet_4_0_0_clk FILLER_6_54/a_32_246# 0
C6807 _696_/a_324_432# net141 0.0409f
C6808 _696_/a_38_114# _310_ 0
C6809 net13 _633_/a_2002_114# 0
C6810 FILLER_8_118/a_32_246# _282_ 0
C6811 clknet_4_14_0_clk _256_ 0.00697f
C6812 rx_inst.bit_index\[0\] _254_ 0.00257f
C6813 _177_ _313_ 1.44613f
C6814 _229_ _241_ 0.00908f
C6815 baud_inst.counter\[20\] net121 0.01314f
C6816 _175_ _477_/a_22_110# 0
C6817 hold160/a_326_118# _163_ 0
C6818 _140_ _247_ 0
C6819 FILLER_4_172/a_32_246# net41 0
C6820 hold145/a_56_118# tx_inst.data_reg\[3\] 0.02236f
C6821 _143_ tx_inst.data_reg\[1\] 0
C6822 FILLER_16_154/a_32_246# net51 0
C6823 net44 _687_/a_2002_114# 0
C6824 hold57/a_438_182# _216_ 0
C6825 rx_done VPWR 0.14474f
C6826 net28 _647_/a_612_127# 0
C6827 hold151/a_326_118# net48 0.00166f
C6828 net32 hold127/a_438_182# 0
C6829 hold173/a_56_118# net56 0
C6830 FILLER_13_68/a_40_246# baud_inst.counter\[13\] 0.00149f
C6831 _440_/a_244_140# _252_ 0
C6832 _466_/a_120_432# _269_ 0
C6833 hold112/a_438_182# _259_ 0.00195f
C6834 _314_ net134 0
C6835 _126_ _047_ 0.00212f
C6836 clknet_4_5_0_clk _664_/a_298_337# 0.02216f
C6837 net34 hold174/a_56_118# 0.01149f
C6838 _376_/a_76_160# FILLER_7_210/a_40_246# 0.01902f
C6839 _064_ _142_ 0.05509f
C6840 _676_/a_324_432# baud_inst.counter\[13\] 0
C6841 output16/a_40_152# _650_/a_1840_334# 0
C6842 _531_/a_209_168# _105_ 0
C6843 tx_inst.data_reg\[2\] VPWR 0.21025f
C6844 net42 _064_ 0.08814f
C6845 _646_/a_550_127# _240_ 0
C6846 net143 _058_ 0
C6847 clknet_4_0_0_clk hold61/a_56_118# 0
C6848 _074_ _706_/a_324_432# 0
C6849 hold154/a_438_182# _090_ 0
C6850 net147 VPWR 0.0743f
C6851 clknet_4_12_0_clk _697_/a_1785_429# 0
C6852 net106 _694_/a_324_432# 0
C6853 VPWR net46 1.28515f
C6854 hold113/a_56_118# clknet_0_clk 0.01959f
C6855 net136 _279_ 0
C6856 _642_/a_298_337# _053_ 0.03231f
C6857 net49 _247_ 0
C6858 FILLER_14_202/a_40_246# VPWR 0.14487f
C6859 net5 _212_ 0.01288f
C6860 clknet_0_clk _687_/a_1489_191# 0
C6861 _147_ FILLER_4_108/a_40_246# 0.00124f
C6862 baud_inst.counter\[28\] _700_/a_1583_191# 0.03159f
C6863 hold150/a_326_118# _158_ 0
C6864 clkbuf_4_11_0_clk/a_27_118# _698_/a_741_93# 0.00394f
C6865 _655_/a_550_127# clknet_0_clk 0
C6866 baud_inst.counter\[8\] VPWR 0.2478f
C6867 _098_ hold128/a_56_118# 0.00304f
C6868 _374_/a_550_140# _205_ 0
C6869 hold64/a_326_118# hold84/a_326_118# 0
C6870 net165 _148_ 0.00194f
C6871 _155_ _648_/a_843_236# 0.00388f
C6872 hold121/a_438_182# _023_ 0
C6873 net92 _495_/a_154_118# 0.0023f
C6874 net156 _684_/a_741_93# 0
C6875 hold147/a_438_182# _694_/a_324_432# 0
C6876 _656_/a_1583_191# net9 0.05074f
C6877 net79 net95 0
C6878 net21 _478_/a_229_118# 0
C6879 net37 FILLER_15_185/a_32_246# 0
C6880 FILLER_17_162/a_32_246# _435_/a_72_436# 0
C6881 net48 _636_/a_2002_114# 0
C6882 _660_/a_681_505# net54 0.00103f
C6883 _660_/a_741_93# _214_ 0.01151f
C6884 hold120/a_438_182# clknet_4_10_0_clk 0
C6885 hold142/a_56_118# FILLER_22_86/a_32_246# 0
C6886 net62 VPWR 0.24523f
C6887 baud_inst.counter\[15\] _687_/a_2250_412# 0.00272f
C6888 _192_ _201_ 0
C6889 _660_/a_1840_334# clknet_4_5_0_clk 0.02304f
C6890 net129 baud_inst.counter\[13\] 0.01524f
C6891 _294_ _187_ 0
C6892 baud_inst.counter\[2\] _673_/a_1583_191# 0
C6893 _398_/a_115_308# net183 0
C6894 _089_ _676_/a_843_236# 0
C6895 _643_/a_38_114# FILLER_23_186/a_40_246# 0
C6896 hold56/a_326_118# _166_ 0
C6897 hold152/a_438_182# net152 0.00314f
C6898 hold152/a_326_118# baud_inst.counter\[4\] 0.00788f
C6899 net26 _394_/a_120_432# 0
C6900 _171_ _394_/a_22_110# 0
C6901 _705_/a_298_337# _166_ 0.00103f
C6902 _234_ _405_/a_27_156# 0
C6903 clknet_4_11_0_clk _700_/a_741_93# 0.02331f
C6904 clknet_0_clk _520_/a_155_412# 0
C6905 _422_/a_248_122# _167_ 0
C6906 net47 net65 0.23143f
C6907 fanout45/a_40_152# net149 0.00498f
C6908 _673_/a_38_114# clknet_4_1_0_clk 0.00775f
C6909 tx _705_/a_2250_412# 0.00218f
C6910 FILLER_11_32/a_32_246# _101_ 0
C6911 clkbuf_0_clk/a_116_82# _669_/a_1583_191# 0.00181f
C6912 net37 hold119/a_326_118# 0.01292f
C6913 _689_/a_2250_412# _101_ 0
C6914 _011_ _189_ 0
C6915 _189_ _684_/a_298_337# 0.00215f
C6916 _678_/a_1583_191# clknet_4_1_0_clk 0.00168f
C6917 hold137/a_326_118# net41 0.00327f
C6918 clknet_4_3_0_clk _653_/a_38_114# 0
C6919 _635_/a_2250_412# _632_/a_1583_191# 0
C6920 _635_/a_1840_334# _632_/a_1840_334# 0
C6921 _635_/a_741_93# _632_/a_1489_191# 0
C6922 _635_/a_1583_191# _632_/a_2250_412# 0
C6923 net85 _632_/a_132_114# 0
C6924 net179 clknet_4_4_0_clk 0
C6925 net15 hold138/a_56_118# 0
C6926 _090_ hold92/a_326_118# 0.00957f
C6927 hold182/a_56_118# _083_ 0.00874f
C6928 clk _658_/a_2250_412# 0.00968f
C6929 net184 net168 0
C6930 baud_inst.counter\[26\] _697_/a_132_114# 0
C6931 _284_ baud_inst.counter\[5\] 0.4921f
C6932 _432_/a_350_122# net25 0
C6933 _138_ _633_/a_324_432# 0
C6934 _264_ hold71/a_438_182# 0.00226f
C6935 net47 FILLER_29_145/a_40_246# 0.01023f
C6936 net49 _701_/a_1489_191# 0.00636f
C6937 _654_/a_741_93# FILLER_2_208/a_40_246# 0
C6938 baud_inst.counter\[18\] clknet_4_2_0_clk 0
C6939 _232_ _633_/a_324_432# 0
C6940 net31 _428_/a_252_412# 0
C6941 tx_data[2] _212_ 0
C6942 FILLER_2_208/a_40_246# _664_/a_1583_191# 0
C6943 _075_ _200_ 0
C6944 _292_ _684_/a_843_236# 0.03512f
C6945 _429_/a_142_412# clknet_0_clk 0
C6946 hold178/a_438_182# net108 0
C6947 _638_/a_324_432# clknet_4_15_0_clk 0.02148f
C6948 baud_inst.counter\[21\] _112_ 0
C6949 _659_/a_324_432# tx_inst.data_reg\[5\] 0
C6950 _170_ _044_ 0
C6951 _507_/a_170_412# net40 0
C6952 hold172/a_326_118# net21 0.02342f
C6953 _643_/a_2250_412# net111 0
C6954 _675_/a_2250_412# net38 0.00277f
C6955 _675_/a_1840_334# _085_ 0
C6956 _706_/a_324_432# _201_ 0
C6957 _706_/a_38_114# _203_ 0
C6958 baud_inst.counter\[17\] _688_/a_741_93# 0
C6959 net28 _409_/a_73_118# 0
C6960 FILLER_14_202/a_40_246# _266_ 0.01118f
C6961 net45 FILLER_28_53/a_32_246# 0.01668f
C6962 net29 _682_/a_1583_191# 0.00163f
C6963 _706_/a_2250_412# FILLER_2_237/a_40_246# 0
C6964 _556_/a_155_160# _313_ 0
C6965 _131_ net24 0.0048f
C6966 baud_inst.counter\[21\] FILLER_21_31/a_40_246# 0.01108f
C6967 net28 fanout43/a_40_152# 0.03846f
C6968 _234_ _417_/a_120_432# 0.00172f
C6969 _193_ _174_ 0.4199f
C6970 _092_ _679_/a_38_114# 0.03843f
C6971 rx hold80/a_56_118# 0.01218f
C6972 clknet_4_8_0_clk _687_/a_741_93# 0.03226f
C6973 _652_/a_298_337# net137 0
C6974 _194_ hold184/a_326_118# 0.01217f
C6975 _173_ hold184/a_438_182# 0.00238f
C6976 baud_inst.counter\[27\] hold141/a_56_118# 0
C6977 _650_/a_843_236# _668_/a_843_236# 0
C6978 net75 _105_ 0.00139f
C6979 VPWR _313_ 0.91374f
C6980 net70 net65 0.03276f
C6981 fanout37/a_40_152# clknet_4_6_0_clk 0
C6982 hold181/a_56_118# net60 0
C6983 net40 _682_/a_324_432# 0.00442f
C6984 net62 _266_ 0
C6985 _168_ net30 0.08715f
C6986 _528_/a_175_118# _296_ 0.00117f
C6987 hold99/a_56_118# _697_/a_843_236# 0
C6988 hold99/a_326_118# _697_/a_741_93# 0
C6989 hold99/a_438_182# _697_/a_324_432# 0
C6990 _153_ FILLER_14_185/a_32_246# 0
C6991 _244_ _238_ 0.00315f
C6992 hold54/a_438_182# _042_ 0
C6993 FILLER_13_100/a_40_246# _089_ 0
C6994 net51 net43 0.06925f
C6995 net132 clknet_4_14_0_clk 0
C6996 net62 _167_ 0.00194f
C6997 _646_/a_843_236# _058_ 0
C6998 hold136/a_56_118# baud_inst.counter\[9\] 0
C6999 _170_ net25 0.75158f
C7000 net44 _691_/a_38_114# 0.00395f
C7001 _200_ _665_/a_681_505# 0
C7002 _662_/a_132_114# net41 0
C7003 _673_/a_550_127# _086_ 0
C7004 _171_ FILLER_5_192/a_40_246# 0
C7005 clknet_4_5_0_clk FILLER_7_210/a_40_246# 0
C7006 _168_ _647_/a_324_432# 0
C7007 hold151/a_56_118# _135_ 0.04611f
C7008 net153 baud_inst.counter\[4\] 0.00465f
C7009 _035_ net152 0.00338f
C7010 clk _656_/a_612_127# 0.00486f
C7011 net169 net168 0.00707f
C7012 _515_/a_76_160# baud_inst.counter\[15\] 0
C7013 _646_/a_1489_191# clknet_0_clk 0.00448f
C7014 _123_ _648_/a_550_127# 0
C7015 _414_/a_279_412# _224_ 0
C7016 _233_ _405_/a_27_156# 0
C7017 net126 clknet_4_15_0_clk 0.01604f
C7018 baud_inst.counter\[31\] hold58/a_56_118# 0.02791f
C7019 _664_/a_298_337# _005_ 0.04314f
C7020 hold123/a_438_182# clknet_4_9_0_clk 0.00133f
C7021 net37 _667_/a_132_114# 0
C7022 net122 _667_/a_1583_191# 0.03634f
C7023 _668_/a_741_93# rx_inst.state\[1\] 0
C7024 _707_/a_843_236# net51 0.00151f
C7025 net71 hold72/a_438_182# 0.00705f
C7026 _232_ FILLER_26_151/a_32_246# 0.01099f
C7027 _655_/a_298_337# net38 0.01512f
C7028 _091_ net93 0.00206f
C7029 _102_ _016_ 0.00245f
C7030 _526_/a_146_122# _300_ 0
C7031 clknet_4_6_0_clk _650_/a_1840_334# 0
C7032 baud_inst.counter\[28\] clknet_4_8_0_clk 0
C7033 _498_/a_165_412# _035_ -0
C7034 _206_ _388_/a_496_118# 0.00155f
C7035 _675_/a_38_114# baud_inst.counter\[3\] 0
C7036 _678_/a_38_114# hold94/a_326_118# 0
C7037 _339_/a_1109_431# clknet_0_clk 0
C7038 _678_/a_298_337# hold94/a_438_182# 0.00102f
C7039 _217_ net27 0.13403f
C7040 hold63/a_438_182# VPWR 0.00283f
C7041 VPWR _685_/a_741_93# 0.01226f
C7042 _059_ _648_/a_612_127# 0.00339f
C7043 net52 _236_ 0.07173f
C7044 VPWR _666_/a_1840_334# 0.00171f
C7045 _657_/a_298_337# clknet_4_1_0_clk 0
C7046 VPWR _689_/a_741_93# 0.033f
C7047 _358_/a_72_436# _162_ 0
C7048 _083_ net29 0
C7049 _178_ clknet_0_clk 0.00244f
C7050 _189_ baud_inst.counter\[16\] 0
C7051 _696_/a_1840_334# _310_ 0
C7052 _696_/a_1583_191# _025_ 0.02894f
C7053 FILLER_17_199/a_40_246# _647_/a_1583_191# 0
C7054 baud_inst.counter\[3\] FILLER_2_46/a_40_246# 0.06819f
C7055 net44 hold99/a_438_182# 0
C7056 _062_ _220_ 0.02589f
C7057 net104 _105_ 0
C7058 VPWR FILLER_0_80/a_40_246# 0.13942f
C7059 _360_/a_1453_124# _067_ 0
C7060 tx_inst.bit_index\[1\] _656_/a_741_93# 0.00385f
C7061 hold55/a_326_118# _665_/a_1583_191# 0
C7062 hold55/a_56_118# _665_/a_1840_334# 0
C7063 _663_/a_324_432# clkbuf_4_7_0_clk/a_27_118# 0
C7064 net94 net38 0.03018f
C7065 _637_/a_132_114# net30 0
C7066 net31 _232_ 0.29386f
C7067 _646_/a_38_114# net48 0.01358f
C7068 _214_ _664_/a_324_432# 0
C7069 net54 _664_/a_843_236# 0
C7070 clk clknet_4_3_0_clk 0
C7071 _467_/a_22_110# hold84/a_438_182# 0
C7072 FILLER_16_176/a_40_246# _223_ 0.00202f
C7073 _648_/a_38_114# rx_inst.data_reg\[5\] 0
C7074 clknet_4_5_0_clk _654_/a_741_93# 0.03024f
C7075 _658_/a_741_93# _148_ 0
C7076 _660_/a_324_432# tx_inst.data_reg\[0\] 0.00803f
C7077 _660_/a_843_236# _144_ 0.00594f
C7078 _413_/a_170_412# _242_ 0
C7079 hold118/a_56_118# _636_/a_843_236# 0
C7080 clknet_4_5_0_clk _664_/a_1583_191# 0
C7081 tx_inst.state\[1\] _705_/a_741_93# 0.00385f
C7082 clknet_4_7_0_clk _705_/a_843_236# 0.01095f
C7083 net132 hold132/a_56_118# 0
C7084 _055_ hold132/a_326_118# 0.00957f
C7085 _655_/a_2250_412# _385_/a_46_156# 0.00185f
C7086 fanout49/a_40_152# VPWR 0.03658f
C7087 _555_/a_209_168# net67 0.00974f
C7088 _036_ _287_ 0
C7089 _530_/a_155_412# VPWR 0.00202f
C7090 hold151/a_438_182# FILLER_25_141/a_32_246# 0
C7091 _288_ _682_/a_298_337# 0
C7092 net54 net21 0.13585f
C7093 net182 _083_ 0.01082f
C7094 hold99/a_326_118# clknet_0_clk 0.00889f
C7095 _394_/a_22_110# net146 0
C7096 _690_/a_843_236# VPWR 0.00974f
C7097 _449_/a_27_156# _452_/a_155_412# 0
C7098 _699_/a_1840_334# _547_/a_81_118# 0
C7099 net136 _674_/a_324_432# 0
C7100 _246_ fanout32/a_40_152# 0
C7101 _680_/a_324_432# hold116/a_438_182# 0
C7102 net39 hold109/a_326_118# 0.00425f
C7103 clknet_4_12_0_clk _110_ 0
C7104 clknet_4_14_0_clk _238_ 0.00169f
C7105 net159 net8 0
C7106 hold158/a_56_118# net161 0.00134f
C7107 _233_ _417_/a_120_432# 0.00186f
C7108 _690_/a_324_432# FILLER_17_24/a_32_246# 0
C7109 _642_/a_132_114# _132_ 0
C7110 _642_/a_681_505# clknet_4_12_0_clk 0
C7111 _642_/a_843_236# rx_inst.bit_index\[2\] 0
C7112 _113_ _028_ 0.00582f
C7113 clknet_4_11_0_clk _546_/a_341_118# 0
C7114 FILLER_16_176/a_40_246# _240_ 0.0205f
C7115 baud_inst.counter\[28\] _700_/a_2002_114# 0
C7116 _113_ hold133/a_326_118# 0.00123f
C7117 _181_ _504_/a_474_130# 0
C7118 baud_inst.counter\[4\] _280_ 0.04009f
C7119 _449_/a_27_156# clknet_0_clk 0.00216f
C7120 hold139/a_438_182# net25 0.00129f
C7121 hold69/a_438_182# hold71/a_438_182# 0
C7122 net85 _635_/a_324_432# 0.0201f
C7123 _376_/a_76_160# FILLER_5_207/a_32_246# 0
C7124 _204_ _205_ 0
C7125 _265_ rx_inst.data_reg\[7\] 0
C7126 _155_ _648_/a_612_127# 0.00259f
C7127 _645_/a_324_432# FILLER_29_145/a_40_246# 0
C7128 FILLER_22_133/a_40_246# net52 0
C7129 _042_ _665_/a_324_432# 0
C7130 _285_ _282_ 0
C7131 clknet_4_14_0_clk hold124/a_326_118# 0
C7132 _656_/a_2002_114# net9 0.0017f
C7133 _286_ net152 0
C7134 _660_/a_550_127# net54 0
C7135 hold56/a_56_118# _651_/a_1840_334# 0
C7136 hold56/a_326_118# _651_/a_1583_191# 0
C7137 clknet_4_7_0_clk _050_ 0
C7138 _316_ _554_/a_248_122# -0
C7139 _232_ _440_/a_550_140# 0.00118f
C7140 _021_ hold149/a_326_118# 0.00974f
C7141 clknet_4_4_0_clk _653_/a_298_337# 0
C7142 net31 _442_/a_248_122# 0
C7143 VPWR _262_ 0.03017f
C7144 _659_/a_843_236# _339_/a_71_118# 0
C7145 net35 _229_ 0
C7146 _643_/a_324_432# clknet_4_15_0_clk 0.00112f
C7147 _339_/a_71_118# net43 0.00427f
C7148 _529_/a_45_160# _528_/a_81_118# 0.00153f
C7149 _216_ net183 0.73137f
C7150 _414_/a_165_412# net49 0.00108f
C7151 _263_ net25 0
C7152 _089_ _676_/a_612_127# 0.00273f
C7153 FILLER_13_137/a_32_246# _667_/a_324_432# 0
C7154 _194_ hold56/a_56_118# 0
C7155 tx_inst.bit_index\[0\] _007_ 0.07844f
C7156 _486_/a_358_436# net62 0.0105f
C7157 hold58/a_438_182# _703_/a_741_93# 0
C7158 hold58/a_326_118# _703_/a_843_236# 0
C7159 net65 _649_/a_324_432# 0
C7160 _646_/a_324_432# _157_ 0.01494f
C7161 _041_ net28 0.10504f
C7162 clknet_4_11_0_clk _700_/a_1785_429# 0
C7163 _661_/a_298_337# _209_ 0
C7164 input2/a_40_152# net22 0.00332f
C7165 FILLER_9_70/a_40_246# _683_/a_1840_334# 0.00121f
C7166 clknet_0_clk _297_ 0.04999f
C7167 _073_ _479_/a_120_432# 0.00133f
C7168 FILLER_24_133/a_32_246# net24 0
C7169 hold175/a_326_118# net25 0.0398f
C7170 _344_/a_252_412# clknet_4_8_0_clk 0
C7171 _673_/a_1840_334# clknet_4_1_0_clk 0
C7172 _073_ _117_ 0
C7173 output21/a_40_152# net22 0.00181f
C7174 net26 net180 0.0436f
C7175 _657_/a_741_93# net41 0.03517f
C7176 clknet_4_0_0_clk _681_/a_1489_191# 0.00476f
C7177 _189_ _684_/a_1583_191# 0.01367f
C7178 rx_inst.state\[3\] VPWR 0.43108f
C7179 _058_ FILLER_17_201/a_32_246# 0
C7180 net37 _650_/a_298_337# 0
C7181 clknet_4_12_0_clk clkbuf_4_13_0_clk/a_27_118# 0
C7182 _663_/a_324_432# _216_ 0
C7183 _164_ baud_inst.counter\[19\] 0
C7184 _240_ _647_/a_843_236# 0.00707f
C7185 hold77/a_326_118# net47 0
C7186 rx_inst.data_reg\[0\] net30 0.02913f
C7187 net42 _670_/a_1840_334# 0
C7188 _690_/a_2250_412# baud_inst.counter\[19\] 0.01316f
C7189 _170_ _139_ 0.23208f
C7190 net55 _066_ 0.02622f
C7191 baud_inst.counter\[21\] _535_/a_350_122# 0.00322f
C7192 _667_/a_38_114# net63 0.02622f
C7193 rx_data[3] net138 0
C7194 _699_/a_298_337# _701_/a_2250_412# 0
C7195 hold140/a_438_182# _698_/a_741_93# 0
C7196 baud_inst.counter\[27\] _546_/a_435_412# 0
C7197 hold140/a_326_118# _698_/a_843_236# 0
C7198 baud_inst.counter\[26\] _546_/a_192_429# 0.00716f
C7199 _191_ baud_inst.counter\[4\] 0.12863f
C7200 baud_inst.counter\[26\] _697_/a_1489_191# 0
C7201 _657_/a_298_337# _147_ 0.0091f
C7202 _657_/a_38_114# _068_ 0.02931f
C7203 _286_ hold115/a_438_182# 0
C7204 net37 _670_/a_843_236# 0
C7205 tx_inst.data_reg\[4\] VPWR 0.30847f
C7206 clkbuf_4_6_0_clk/a_27_118# clknet_4_6_0_clk 0.03358f
C7207 net130 hold91/a_56_118# 0.00554f
C7208 _098_ hold154/a_56_118# 0
C7209 net26 _668_/a_38_114# 0
C7210 _473_/a_22_110# _157_ 0
C7211 _638_/a_2250_412# clknet_4_15_0_clk 0
C7212 _694_/a_324_432# _693_/a_1583_191# 0
C7213 _694_/a_38_114# _693_/a_1840_334# 0
C7214 _659_/a_2250_412# tx_inst.data_reg\[5\] 0.00875f
C7215 net148 fanout44/a_40_152# 0
C7216 baud_inst.counter\[17\] _688_/a_1785_429# 0.004f
C7217 _206_ _200_ 0.02337f
C7218 _143_ _653_/a_324_432# 0.0198f
C7219 _118_ _704_/a_843_236# 0
C7220 _517_/a_209_168# clkbuf_4_8_0_clk/a_27_118# 0.0018f
C7221 net36 clknet_4_14_0_clk 0.00318f
C7222 baud_inst.counter\[1\] net86 0.018f
C7223 _492_/a_170_412# _280_ 0.00246f
C7224 hold157/a_438_182# _015_ 0
C7225 net47 _633_/a_843_236# 0.00215f
C7226 _234_ _140_ 0.00314f
C7227 rx_inst.bit_index\[1\] hold175/a_56_118# 0.14984f
C7228 _092_ _679_/a_1840_334# 0
C7229 hold128/a_438_182# _292_ 0
C7230 net2 net80 0.20169f
C7231 _677_/a_324_432# FILLER_8_92/a_32_246# 0
C7232 clknet_4_8_0_clk _687_/a_1785_429# 0.00215f
C7233 _641_/a_38_114# _697_/a_1583_191# 0
C7234 _550_/a_209_168# hold106/a_56_118# 0
C7235 clkload3/Y FILLER_23_186/a_40_246# 0.01988f
C7236 net41 net170 0.00847f
C7237 net92 _162_ 0
C7238 _062_ _667_/a_1840_334# 0
C7239 baud_inst.counter\[20\] baud_inst.counter\[21\] 2.73773f
C7240 _078_ net56 0
C7241 _641_/a_741_93# _262_ 0
C7242 FILLER_17_96/a_32_246# clknet_0_clk 0.01575f
C7243 hold79/a_326_118# _672_/a_1583_191# 0
C7244 _073_ net11 0
C7245 hold68/a_326_118# net49 0
C7246 fanout38/a_40_152# FILLER_8_19/a_40_246# 0.01226f
C7247 hold172/a_326_118# clknet_4_5_0_clk 0
C7248 _284_ clknet_0_clk 0.06037f
C7249 net103 _296_ 0.26346f
C7250 net54 FILLER_2_208/a_40_246# 0.0045f
C7251 net94 _285_ 0.65159f
C7252 net92 _283_ 0.47508f
C7253 hold178/a_326_118# baud_inst.counter\[17\] 0
C7254 _265_ _639_/a_1489_191# 0
C7255 net101 _522_/a_209_168# 0
C7256 _651_/a_2250_412# net168 0.00105f
C7257 clknet_4_3_0_clk _652_/a_550_127# 0
C7258 _189_ _356_/a_146_122# 0
C7259 _674_/a_38_114# clknet_4_0_0_clk 0.04763f
C7260 _661_/a_298_337# _207_ 0
C7261 _636_/a_298_337# VPWR 0
C7262 _554_/a_350_122# _027_ 0
C7263 net44 _691_/a_1840_334# 0.00508f
C7264 _632_/a_38_114# _264_ 0.02556f
C7265 FILLER_22_43/a_40_246# net46 0
C7266 _383_/a_46_156# _210_ 0
C7267 _654_/a_298_337# _065_ 0.03121f
C7268 _200_ _665_/a_550_127# 0
C7269 clknet_4_12_0_clk hold143/a_326_118# 0
C7270 clknet_4_1_0_clk _086_ 0.04226f
C7271 _680_/a_298_337# hold117/a_326_118# 0
C7272 _680_/a_38_114# hold117/a_56_118# 0
C7273 _353_/a_146_122# _182_ 0.00188f
C7274 _234_ net49 0.00516f
C7275 _694_/a_38_114# FILLER_24_19/a_40_246# 0.00201f
C7276 _144_ _664_/a_741_93# 0
C7277 net13 _048_ 0.01409f
C7278 rx_inst.data_reg\[3\] clknet_0_clk 0.11537f
C7279 _225_ _262_ 0.12759f
C7280 _673_/a_2250_412# _672_/a_843_236# 0
C7281 _673_/a_843_236# _672_/a_2250_412# 0
C7282 hold184/a_438_182# FILLER_4_172/a_32_246# 0
C7283 _091_ clknet_4_1_0_clk 0.09851f
C7284 _664_/a_681_505# tx_inst.state\[2\] 0
C7285 net122 _667_/a_2002_114# 0
C7286 _485_/a_120_432# net63 0.00137f
C7287 _374_/a_142_412# _204_ 0
C7288 net37 _667_/a_1489_191# 0
C7289 _668_/a_1785_429# rx_inst.state\[1\] 0
C7290 _707_/a_612_127# net51 0
C7291 net28 FILLER_14_185/a_32_246# 0.00108f
C7292 _692_/a_324_432# VPWR 0.01026f
C7293 _518_/a_45_160# _684_/a_741_93# 0
C7294 _678_/a_324_432# baud_inst.counter\[6\] 0.04029f
C7295 FILLER_9_79/a_32_246# clknet_0_clk 0
C7296 _655_/a_1583_191# net38 0
C7297 _046_ hold111/a_438_182# 0
C7298 clkbuf_4_6_0_clk/a_27_118# net29 0.04335f
C7299 _663_/a_741_93# _666_/a_741_93# 0.00523f
C7300 _663_/a_324_432# _666_/a_843_236# 0
C7301 net44 _641_/a_132_114# 0
C7302 _179_ _347_/a_248_122# 0
C7303 _686_/a_1583_191# hold91/a_326_118# 0.00358f
C7304 _686_/a_324_432# net91 0.01786f
C7305 _675_/a_1840_334# baud_inst.counter\[3\] 0.00269f
C7306 clknet_4_5_0_clk FILLER_5_207/a_32_246# 0
C7307 output16/a_40_152# FILLER_16_203/a_32_246# 0.00624f
C7308 _093_ FILLER_5_32/a_40_246# 0.00164f
C7309 _657_/a_1583_191# clknet_4_1_0_clk 0.00511f
C7310 _094_ FILLER_8_14/a_32_246# 0
C7311 _677_/a_1489_191# _089_ 0
C7312 hold160/a_326_118# net157 0
C7313 VPWR _689_/a_1785_429# 0
C7314 _696_/a_2002_114# _025_ 0
C7315 _125_ clknet_4_13_0_clk 0.49275f
C7316 _360_/a_1377_160# _067_ 0
C7317 _360_/a_589_385# tx_inst.data_reg\[2\] 0
C7318 net184 _656_/a_1583_191# 0
C7319 _360_/a_886_118# clknet_4_4_0_clk 0.04377f
C7320 _288_ _039_ 1.04887f
C7321 _264_ _124_ 0
C7322 _447_/a_175_118# VPWR 0
C7323 net34 _397_/a_165_412# 0.0027f
C7324 _284_ _182_ 0
C7325 _663_/a_2250_412# clkbuf_4_7_0_clk/a_27_118# 0
C7326 _199_ FILLER_7_210/a_40_246# 0.00432f
C7327 _646_/a_1840_334# net48 0.00141f
C7328 hold142/a_56_118# net140 0.01239f
C7329 clknet_4_12_0_clk _249_ 0.13335f
C7330 clknet_4_14_0_clk _472_/a_22_110# 0.00246f
C7331 _648_/a_1840_334# rx_inst.data_reg\[5\] 0.0016f
C7332 _467_/a_120_432# _264_ 0.00711f
C7333 clknet_4_5_0_clk _654_/a_1785_429# 0
C7334 _660_/a_550_127# _065_ 0
C7335 _660_/a_2250_412# tx_inst.data_reg\[0\] 0
C7336 _178_ hold120/a_56_118# 0.00566f
C7337 _641_/a_681_505# clknet_0_clk 0
C7338 clknet_4_7_0_clk _705_/a_612_127# 0.00203f
C7339 rx_data[4] net119 0
C7340 net48 hold118/a_326_118# 0
C7341 hold114/a_326_118# _027_ 0.00385f
C7342 hold170/a_438_182# _660_/a_843_236# 0
C7343 tx_inst.data_reg\[6\] _660_/a_38_114# 0.00929f
C7344 net2 net52 0.17548f
C7345 _206_ _656_/a_38_114# 0
C7346 _018_ VPWR 0.08822f
C7347 VPWR net19 0.22171f
C7348 net122 FILLER_10_145/a_40_246# 0
C7349 _288_ _682_/a_1583_191# 0.04704f
C7350 _699_/a_1583_191# net113 0.00174f
C7351 baud_inst.counter\[21\] _701_/a_298_337# 0
C7352 _690_/a_612_127# VPWR 0.00143f
C7353 _447_/a_175_118# _239_ 0
C7354 _164_ FILLER_17_24/a_32_246# 0.01342f
C7355 _227_ net29 0.00272f
C7356 net105 _550_/a_380_412# 0.00585f
C7357 _506_/a_155_412# _505_/a_76_160# 0
C7358 FILLER_9_79/a_32_246# _182_ 0.01918f
C7359 _233_ _140_ 0.1422f
C7360 _642_/a_1489_191# _132_ 0.0054f
C7361 _691_/a_741_93# _692_/a_843_236# 0
C7362 hold107/a_326_118# _701_/a_741_93# 0.00125f
C7363 hold107/a_438_182# _701_/a_324_432# 0
C7364 _678_/a_741_93# _677_/a_324_432# 0
C7365 _678_/a_324_432# _677_/a_741_93# 0
C7366 hold159/a_438_182# _382_/a_382_118# 0
C7367 _201_ net168 0
C7368 _202_ _200_ 0.00373f
C7369 _203_ net172 0.10607f
C7370 FILLER_15_162/a_40_246# fanout32/a_40_152# 0.01f
C7371 _391_/a_268_412# net54 0.00381f
C7372 hold146/a_438_182# VPWR 0.00336f
C7373 _662_/a_1840_334# _706_/a_324_432# 0
C7374 _662_/a_1583_191# _706_/a_741_93# 0
C7375 _668_/a_324_432# FILLER_12_208/a_32_246# 0
C7376 _699_/a_298_337# baud_inst.counter\[29\] 0
C7377 _379_/a_268_412# _208_ 0.0012f
C7378 FILLER_15_185/a_32_246# net26 0.01842f
C7379 _292_ _505_/a_76_160# 0
C7380 hold123/a_56_118# _191_ 0.09086f
C7381 hold147/a_326_118# _107_ 0.00102f
C7382 hold155/a_326_118# tx_inst.data_reg\[1\] 0.00556f
C7383 _680_/a_2250_412# net86 0
C7384 clknet_4_5_0_clk net54 0.13071f
C7385 _636_/a_38_114# net30 0
C7386 clknet_4_14_0_clk _648_/a_741_93# 0.03321f
C7387 hold56/a_438_182# _651_/a_1489_191# 0
C7388 VPWR hold51/a_326_118# 0.00103f
C7389 _642_/a_298_337# VPWR 0.00246f
C7390 _058_ FILLER_18_169/a_40_246# 0.00355f
C7391 _305_ _694_/a_741_93# 0.00162f
C7392 _023_ _694_/a_324_432# 0
C7393 baud_inst.counter\[22\] _693_/a_1583_191# 0
C7394 net29 hold62/a_438_182# 0
C7395 hold87/a_56_118# _309_ 0
C7396 hold162/a_56_118# net99 0
C7397 _659_/a_1583_191# _339_/a_382_118# 0
C7398 net33 _665_/a_843_236# 0.00113f
C7399 clknet_4_4_0_clk _653_/a_1583_191# 0
C7400 hold111/a_438_182# _043_ 0
C7401 _073_ _040_ 0
C7402 _671_/a_298_337# VPWR 0.00535f
C7403 net20 rx 0.414f
C7404 _052_ _130_ 0
C7405 hold122/a_326_118# _216_ 0
C7406 net58 _700_/a_324_432# 0
C7407 _660_/a_681_505# VPWR 0
C7408 _233_ net49 0.00937f
C7409 hold143/a_56_118# net64 0.01076f
C7410 net143 _473_/a_120_432# 0.00128f
C7411 _089_ _034_ 0.0272f
C7412 hold182/a_56_118# _676_/a_324_432# 0
C7413 _293_ hold91/a_326_118# 0
C7414 _083_ _670_/a_741_93# 0.00219f
C7415 VPWR _686_/a_298_337# 0.00253f
C7416 baud_inst.counter\[26\] FILLER_19_77/a_32_246# 0
C7417 _646_/a_2250_412# _157_ 0.00284f
C7418 net65 _649_/a_2250_412# 0.00723f
C7419 hold160/a_326_118# _188_ 0.03205f
C7420 tx_inst.bit_index\[1\] _398_/a_358_436# 0.00334f
C7421 hold179/a_56_118# net43 0
C7422 output14/a_40_152# net47 0
C7423 fanout34/a_40_152# clknet_4_6_0_clk 0.00108f
C7424 _073_ _006_ 0.0246f
C7425 _513_/a_435_412# _182_ 0
C7426 baud_inst.counter\[30\] _703_/a_38_114# 0.05303f
C7427 baud_inst.counter\[31\] _703_/a_324_432# 0.0159f
C7428 baud_inst.counter\[28\] _703_/a_741_93# 0
C7429 _179_ _703_/a_298_337# 0
C7430 _008_ _672_/a_324_432# 0.0441f
C7431 net79 _672_/a_741_93# 0.00658f
C7432 baud_inst.counter\[26\] clknet_4_8_0_clk 0.09995f
C7433 input3/a_40_152# _388_/a_382_118# 0.00128f
C7434 clknet_4_0_0_clk baud_inst.counter\[9\] 0.12432f
C7435 hold88/a_438_182# _097_ 0
C7436 _013_ fanout29/a_40_152# 0.0223f
C7437 _691_/a_1583_191# _164_ 0
C7438 _691_/a_1840_334# _302_ 0
C7439 net49 net76 0
C7440 _170_ hold119/a_438_182# 0
C7441 _240_ _647_/a_612_127# 0.00125f
C7442 VPWR _457_/a_22_110# -0
C7443 _691_/a_1489_191# _690_/a_741_93# 0
C7444 _691_/a_1840_334# _690_/a_1840_334# 0
C7445 _270_ rx_inst.data_reg\[4\] 0.44775f
C7446 hold126/a_56_118# clknet_4_15_0_clk 0.00299f
C7447 _640_/a_741_93# _640_/a_1489_191# -0
C7448 _640_/a_1583_191# _640_/a_2250_412# 0
C7449 hold125/a_56_118# clknet_0_clk 0.01607f
C7450 _694_/a_843_236# _701_/a_324_432# 0
C7451 _218_ fanout34/a_40_152# 0
C7452 net45 _552_/a_155_412# 0
C7453 hold69/a_326_118# rx_inst.data_reg\[6\] 0
C7454 _101_ _688_/a_324_432# 0.01756f
C7455 baud_inst.counter\[14\] fanout29/a_40_152# 0.00271f
C7456 baud_inst.counter\[27\] _026_ 0.09736f
C7457 FILLER_24_229/a_32_246# net12 0
C7458 FILLER_23_204/a_40_246# clknet_0_clk 0.01578f
C7459 hold76/a_326_118# baud_inst.counter\[21\] 0.00607f
C7460 FILLER_0_103/a_32_246# _213_ 0.00532f
C7461 _222_ _141_ 0.07858f
C7462 _462_/a_120_432# net30 0
C7463 _447_/a_175_118# _167_ 0.00117f
C7464 clknet_4_5_0_clk _368_/a_155_412# 0
C7465 _635_/a_1583_191# hold84/a_56_118# 0.00364f
C7466 _003_ _670_/a_2250_412# 0.00194f
C7467 _637_/a_298_337# net47 0
C7468 net82 _264_ 0.05325f
C7469 clknet_4_9_0_clk net91 0.04427f
C7470 net133 _700_/a_843_236# 0.01167f
C7471 _028_ _700_/a_324_432# 0
C7472 _065_ FILLER_2_208/a_40_246# 0
C7473 _659_/a_741_93# tx_inst.data_reg\[1\] 0.0062f
C7474 net98 net29 0
C7475 _046_ clknet_0_clk 0.00298f
C7476 _058_ VPWR 0.18024f
C7477 hold173/a_56_118# hold57/a_326_118# 0
C7478 hold173/a_326_118# hold57/a_56_118# 0
C7479 _522_/a_209_168# _522_/a_474_130# 0
C7480 baud_inst.counter\[12\] net40 0.13968f
C7481 _266_ net19 0.12497f
C7482 _645_/a_1583_191# net150 0.00143f
C7483 _663_/a_298_337# clknet_0_clk 0
C7484 _643_/a_38_114# clknet_0_clk 0.0013f
C7485 _133_ _223_ 0.03435f
C7486 hold168/a_326_118# _198_ 0.01808f
C7487 _143_ _653_/a_2250_412# 0.00645f
C7488 _118_ _704_/a_612_127# 0
C7489 _642_/a_1840_334# net24 0
C7490 _675_/a_324_432# VPWR 0.02427f
C7491 net47 _633_/a_612_127# 0
C7492 _688_/a_1583_191# _688_/a_2250_412# 0
C7493 tx input11/a_40_152# 0.00548f
C7494 hold98/a_326_118# net40 0
C7495 hold121/a_326_118# net120 0
C7496 hold63/a_56_118# clk 0.03999f
C7497 clkbuf_4_8_0_clk/a_27_118# baud_inst.counter\[15\] 0.04032f
C7498 hold126/a_326_118# _637_/a_38_114# 0
C7499 hold126/a_438_182# _637_/a_298_337# 0
C7500 net88 net40 0
C7501 _642_/a_38_114# _641_/a_324_432# 0
C7502 _642_/a_298_337# _641_/a_741_93# 0
C7503 _660_/a_843_236# net179 0
C7504 _668_/a_843_236# rx_inst.state\[4\] 0
C7505 _104_ _527_/a_192_429# 0
C7506 output16/a_40_152# net118 0
C7507 hold79/a_438_182# _672_/a_1489_191# 0
C7508 _650_/a_2250_412# _668_/a_1489_191# 0
C7509 _242_ _253_ 0.03836f
C7510 _680_/a_324_432# net38 0.02922f
C7511 _129_ clknet_4_13_0_clk 0.22706f
C7512 _390_/a_382_118# net38 0.01481f
C7513 net101 _296_ 0.0817f
C7514 hold89/a_326_118# _189_ 0
C7515 _059_ _244_ 0.00132f
C7516 hold120/a_438_182# VPWR 0.01084f
C7517 rx_inst.bit_index\[2\] fanout35/a_40_152# 0.02026f
C7518 hold99/a_326_118# _110_ 0
C7519 _514_/a_155_412# VPWR 0.01176f
C7520 _671_/a_324_432# _000_ 0
C7521 net173 _221_ 0
C7522 FILLER_13_68/a_40_246# net29 0.01628f
C7523 _189_ baud_inst.counter\[13\] 1.91317f
C7524 _699_/a_324_432# _311_ 0
C7525 _674_/a_1840_334# clknet_4_0_0_clk 0.02271f
C7526 clknet_4_7_0_clk output23/a_40_152# 0.00691f
C7527 net144 _058_ 0
C7528 _017_ net157 0
C7529 _662_/a_298_337# _200_ 0
C7530 _090_ _142_ 0.00228f
C7531 _636_/a_1583_191# VPWR 0.0047f
C7532 hold180/a_326_118# net25 0.00296f
C7533 _159_ _244_ 0
C7534 _303_ _105_ 0
C7535 _632_/a_1840_334# _264_ 0.00407f
C7536 _654_/a_843_236# tx_inst.data_reg\[0\] 0.00149f
C7537 net115 _681_/a_1583_191# 0
C7538 _064_ net39 0.00245f
C7539 net42 _090_ 0.00908f
C7540 hold112/a_438_182# net24 0.01352f
C7541 net36 hold176/a_56_118# 0
C7542 hold76/a_56_118# _694_/a_1583_191# 0
C7543 hold170/a_56_118# _654_/a_38_114# 0.02058f
C7544 _683_/a_324_432# net29 0.01689f
C7545 _284_ FILLER_10_110/a_40_246# 0.00533f
C7546 _673_/a_1489_191# _672_/a_1583_191# 0
C7547 _673_/a_1583_191# _672_/a_1489_191# 0
C7548 net39 net40 0.76042f
C7549 _661_/a_1840_334# net41 0
C7550 _003_ net63 0.00281f
C7551 FILLER_12_89/a_40_246# net40 0.01656f
C7552 _692_/a_2250_412# VPWR 0.0333f
C7553 _703_/a_38_114# _703_/a_132_114# -0
C7554 _643_/a_1583_191# _240_ 0
C7555 _678_/a_2250_412# baud_inst.counter\[6\] 0.02402f
C7556 _278_ _652_/a_324_432# 0
C7557 rx_inst.state\[3\] _652_/a_741_93# 0
C7558 _691_/a_298_337# hold164/a_56_118# 0
C7559 clkbuf_4_12_0_clk/a_27_118# net37 0.01918f
C7560 baud_inst.counter\[20\] _301_ 0.00448f
C7561 _248_ _223_ 0.02447f
C7562 _663_/a_843_236# _666_/a_2250_412# 0.00135f
C7563 _109_ FILLER_19_77/a_32_246# 0.00138f
C7564 baud_inst.counter\[22\] _023_ 0.08266f
C7565 net31 _445_/a_279_412# 0
C7566 _172_ clknet_0_clk 0.19706f
C7567 _704_/a_2250_412# VPWR 0
C7568 rx_data[7] net30 1.94605f
C7569 net30 hold72/a_56_118# 0
C7570 hold129/a_438_182# baud_inst.counter\[13\] 0.00723f
C7571 _264_ _648_/a_681_505# 0
C7572 _043_ clknet_0_clk 0.10813f
C7573 _072_ _657_/a_132_114# 0
C7574 tx_inst.data_reg\[7\] _657_/a_741_93# 0
C7575 FILLER_3_207/a_40_246# tx_inst.data_reg\[0\] 0
C7576 hold181/a_56_118# FILLER_6_54/a_32_246# 0
C7577 _205_ VPWR 0.16042f
C7578 _489_/a_358_436# hold135/a_56_118# 0.04074f
C7579 net182 _676_/a_324_432# 0
C7580 _109_ clknet_4_8_0_clk 0.04579f
C7581 _181_ _348_/a_146_122# 0.00172f
C7582 _644_/a_38_114# _158_ 0.00143f
C7583 hold100/a_438_182# net100 0.00684f
C7584 _216_ hold169/a_438_182# 0.00746f
C7585 tx_inst.bit_index\[1\] _067_ 0.00258f
C7586 _360_/a_1023_118# tx_inst.data_reg\[2\] 0
C7587 net34 _219_ 0.08162f
C7588 hold55/a_438_182# tx_inst.state\[3\] 0
C7589 net129 net29 0.07417f
C7590 FILLER_8_63/a_40_246# _282_ 0
C7591 _155_ _244_ 0.15491f
C7592 _058_ _266_ 0.00326f
C7593 net8 _384_/a_382_118# 0
C7594 net54 _005_ 0
C7595 _094_ hold117/a_326_118# 0
C7596 _248_ _240_ 0
C7597 _267_ VPWR 0.22115f
C7598 _069_ _148_ 0.00652f
C7599 clknet_4_5_0_clk _065_ 0.19467f
C7600 net14 hold83/a_326_118# 0.00112f
C7601 rx_data[2] hold83/a_56_118# 0.06697f
C7602 rx_inst.bit_index\[1\] hold180/a_56_118# 0
C7603 _058_ _167_ 0
C7604 _645_/a_298_337# _158_ 0
C7605 _654_/a_298_337# VPWR 0.00312f
C7606 _698_/a_1583_191# net99 0.00218f
C7607 baud_inst.counter\[30\] clknet_4_11_0_clk 0.89299f
C7608 hold58/a_56_118# VPWR 0.05085f
C7609 _118_ _478_/a_27_156# 0
C7610 _058_ _647_/a_741_93# 0.00192f
C7611 tx_inst.data_reg\[6\] _660_/a_1840_334# 0.00603f
C7612 VPWR _664_/a_843_236# 0.00714f
C7613 _011_ clknet_0_clk 0
C7614 _646_/a_1840_334# net143 0.00223f
C7615 _206_ _656_/a_1840_334# 0.02698f
C7616 _516_/a_165_412# net40 0
C7617 clknet_4_3_0_clk baud_inst.counter\[13\] 0.0012f
C7618 baud_inst.counter\[1\] net38 0.03621f
C7619 net55 _665_/a_741_93# 0.00439f
C7620 baud_inst.counter\[6\] net95 0
C7621 _288_ _682_/a_2002_114# 0
C7622 baud_inst.counter\[22\] _701_/a_843_236# 0
C7623 _699_/a_2002_114# net113 0
C7624 net39 _670_/a_38_114# 0.00333f
C7625 rx_inst.data_reg\[2\] hold78/a_56_118# 0
C7626 _314_ net133 0
C7627 _031_ hold134/a_326_118# 0
C7628 _059_ clknet_4_14_0_clk 0.05212f
C7629 _289_ _505_/a_76_160# 0.02914f
C7630 net128 hold90/a_438_182# 0
C7631 _247_ net25 0.04343f
C7632 clkbuf_0_clk/a_116_82# _278_ 0
C7633 _690_/a_324_432# baud_inst.counter\[16\] 0
C7634 _109_ _686_/a_1840_334# 0
C7635 net44 hold103/a_326_118# 0.00531f
C7636 _132_ rx_inst.bit_index\[2\] 0.03779f
C7637 _691_/a_1583_191# _692_/a_1583_191# 0
C7638 _678_/a_1840_334# _677_/a_843_236# 0
C7639 hold88/a_438_182# net90 0
C7640 _536_/a_341_118# _105_ 0
C7641 FILLER_25_198/a_32_246# _648_/a_1583_191# 0
C7642 hold98/a_438_182# _682_/a_324_432# 0
C7643 hold98/a_56_118# _682_/a_843_236# 0
C7644 hold98/a_326_118# _682_/a_741_93# 0.00367f
C7645 hold108/a_326_118# _186_ 0.06829f
C7646 clknet_4_14_0_clk _159_ 0.16039f
C7647 net14 _634_/a_843_236# 0.00579f
C7648 net21 VPWR 0.31546f
C7649 _062_ net27 0.02966f
C7650 _396_/a_155_412# VPWR 0.00259f
C7651 clknet_4_15_0_clk _649_/a_298_337# 0.00373f
C7652 clkbuf_4_15_0_clk/a_27_118# _649_/a_843_236# 0
C7653 _680_/a_1840_334# hold115/a_326_118# 0.00181f
C7654 _680_/a_1583_191# hold115/a_438_182# 0
C7655 _699_/a_1583_191# baud_inst.counter\[29\] 0.00209f
C7656 _111_ clknet_0_clk 0.01586f
C7657 _206_ _382_/a_382_118# 0.02773f
C7658 hold74/a_438_182# net19 0
C7659 _352_/a_46_156# net40 0
C7660 hold65/a_326_118# VPWR 0.0068f
C7661 net37 net26 0.27293f
C7662 _636_/a_1583_191# _266_ 0.00233f
C7663 _636_/a_1840_334# net30 0.00344f
C7664 _534_/a_46_156# _106_ 0
C7665 net49 FILLER_25_25/a_40_246# 0.00543f
C7666 _183_ _502_/a_279_412# 0.00138f
C7667 _682_/a_298_337# clknet_4_2_0_clk 0.00244f
C7668 _642_/a_1583_191# VPWR 0.00854f
C7669 hold53/a_56_118# net53 0.00246f
C7670 clkbuf_4_7_0_clk/a_27_118# _166_ 0
C7671 net2 _121_ 0.0245f
C7672 _223_ net139 0.00187f
C7673 net37 net32 0.90338f
C7674 _392_/a_59_156# net41 0.02191f
C7675 _081_ net30 0
C7676 _671_/a_1583_191# VPWR 0.02504f
C7677 _660_/a_550_127# VPWR 0
C7678 net42 rx_inst.state\[4\] 0.00176f
C7679 _246_ FILLER_16_166/a_32_246# 0
C7680 _110_ FILLER_17_96/a_32_246# 0
C7681 hold121/a_56_118# net76 0.00446f
C7682 net143 _273_ 0
C7683 _390_/a_59_156# _655_/a_843_236# 0
C7684 _635_/a_324_432# FILLER_19_228/a_40_246# 0
C7685 _637_/a_741_93# _634_/a_843_236# 0
C7686 _637_/a_843_236# _634_/a_741_93# 0
C7687 _091_ hold94/a_438_182# 0.04841f
C7688 _083_ _670_/a_1785_429# 0
C7689 VPWR _686_/a_1583_191# 0.00647f
C7690 hold52/a_326_118# net52 0.00729f
C7691 hold168/a_56_118# clkbuf_4_5_0_clk/a_27_118# 0.00419f
C7692 net48 _647_/a_298_337# 0.01008f
C7693 _127_ _267_ 0.00136f
C7694 tx_inst.bit_index\[1\] _143_ 0.09802f
C7695 FILLER_18_158/a_40_246# _224_ 0.00255f
C7696 net179 _120_ 0.02386f
C7697 clk clknet_0_clk 0.02573f
C7698 net39 _682_/a_741_93# 0.003f
C7699 net34 tx_inst.bit_index\[2\] 2.06255f
C7700 _011_ _182_ 0
C7701 baud_inst.counter\[31\] _703_/a_2250_412# 0.00982f
C7702 net79 _672_/a_1785_429# 0.00124f
C7703 _661_/a_843_236# _072_ 0.00161f
C7704 _661_/a_38_114# tx_inst.data_reg\[7\] 0
C7705 clknet_4_4_0_clk _148_ 0.00224f
C7706 _083_ FILLER_11_123/a_40_246# 0
C7707 FILLER_12_0/a_32_246# _296_ 0
C7708 net37 hold62/a_326_118# 0.00823f
C7709 tx_data[0] _388_/a_496_118# 0
C7710 _661_/a_550_127# clknet_4_1_0_clk 0
C7711 _176_ net41 0
C7712 net26 _650_/a_298_337# 0.00275f
C7713 net104 net103 0
C7714 net7 _381_/a_268_412# 0
C7715 tx_inst.data_reg\[4\] _360_/a_589_385# 0.00562f
C7716 _068_ net41 0.26514f
C7717 clknet_4_14_0_clk _155_ 0.07735f
C7718 hold112/a_326_118# VPWR 0.01203f
C7719 _240_ net139 0
C7720 hold167/a_438_182# net29 0.0134f
C7721 _118_ hold172/a_56_118# 0
C7722 hold63/a_326_118# _080_ 0.00957f
C7723 _691_/a_843_236# clknet_4_8_0_clk 0.0067f
C7724 _640_/a_741_93# rx_inst.bit_index\[0\] 0
C7725 _640_/a_843_236# clknet_4_14_0_clk 0.01556f
C7726 hold179/a_326_118# _654_/a_843_236# 0
C7727 hold179/a_438_182# _654_/a_741_93# 0
C7728 net54 _199_ 0
C7729 net180 hold180/a_438_182# 0.0291f
C7730 _694_/a_1489_191# _701_/a_298_337# 0
C7731 clknet_4_8_0_clk _541_/a_474_130# 0.00191f
C7732 net45 _315_ 0.14657f
C7733 hold69/a_438_182# _632_/a_1840_334# 0
C7734 hold165/a_56_118# tx_inst.data_reg\[0\] 0.0464f
C7735 hold97/a_438_182# net97 0.0205f
C7736 _646_/a_132_114# clknet_4_12_0_clk 0
C7737 _178_ _347_/a_248_122# 0
C7738 _359_/a_22_110# net27 0.00178f
C7739 _093_ _681_/a_1489_191# 0
C7740 _089_ _351_/a_46_156# 0
C7741 hold124/a_56_118# net65 0
C7742 _697_/a_1489_191# FILLER_20_106/a_32_246# 0
C7743 _128_ net30 0.03927f
C7744 _267_ _266_ 0.15038f
C7745 _246_ _156_ 0
C7746 _531_/a_209_168# net101 0
C7747 _350_/a_279_412# baud_inst.counter\[9\] 0
C7748 net48 fanout30/a_40_152# 0
C7749 rx_inst.bit_index\[1\] _229_ 0.06148f
C7750 fanout25/a_40_152# _241_ 0
C7751 hold132/a_56_118# _159_ 0.00762f
C7752 _635_/a_843_236# _264_ 0.02123f
C7753 net155 _381_/a_268_412# 0
C7754 VPWR _211_ 0.10385f
C7755 net118 clknet_4_6_0_clk 0.00477f
C7756 hold85/a_56_118# _264_ 0
C7757 net133 _700_/a_612_127# 0.00344f
C7758 VPWR _282_ 0.17237f
C7759 hold158/a_56_118# _524_/a_248_122# 0
C7760 _659_/a_1785_429# tx_inst.data_reg\[1\] 0.0021f
C7761 _095_ net29 0
C7762 hold65/a_326_118# _127_ 0
C7763 hold133/a_438_182# _700_/a_1840_334# 0
C7764 _290_ _684_/a_741_93# 0
C7765 _522_/a_380_412# _015_ 0.00449f
C7766 _522_/a_474_130# _296_ 0.00157f
C7767 _110_ net162 0.00151f
C7768 hold151/a_326_118# VPWR 0.00513f
C7769 hold150/a_438_182# net48 0.00559f
C7770 _126_ output19/a_40_152# 0.01003f
C7771 hold74/a_326_118# rx_data[7] 0.00682f
C7772 hold164/a_438_182# VPWR 0.00829f
C7773 _246_ rx_inst.state\[2\] 0.0026f
C7774 _114_ _305_ 0.10257f
C7775 hold179/a_326_118# FILLER_3_207/a_40_246# 0
C7776 _499_/a_474_130# _282_ 0
C7777 _036_ _495_/a_154_118# 0
C7778 _376_/a_76_160# VPWR 0.03475f
C7779 _663_/a_1583_191# clknet_0_clk 0.01589f
C7780 _041_ _223_ 0.00545f
C7781 hold131/a_56_118# net78 0.00141f
C7782 _374_/a_142_412# VPWR 0
C7783 _643_/a_1840_334# clknet_0_clk 0.00676f
C7784 rx_data[4] net81 0
C7785 net16 clknet_4_13_0_clk 0.01395f
C7786 net32 _134_ 0
C7787 net45 _551_/a_272_160# 0
C7788 _284_ net152 0.02216f
C7789 _427_/a_248_122# _244_ -0
C7790 _661_/a_1583_191# FILLER_0_130/a_32_246# 0
C7791 _675_/a_2250_412# VPWR 0.00363f
C7792 net47 net78 0.01374f
C7793 baud_inst.counter\[30\] hold113/a_326_118# 0
C7794 FILLER_2_81/a_32_246# clknet_4_1_0_clk 0
C7795 _282_ hold93/a_326_118# 0.01475f
C7796 _117_ net146 0.02472f
C7797 _250_ _647_/a_298_337# 0
C7798 _157_ _647_/a_38_114# 0
C7799 net176 _697_/a_843_236# 0
C7800 net121 _022_ 0.01923f
C7801 net48 _448_/a_142_412# 0.00409f
C7802 _449_/a_27_156# _249_ 0
C7803 FILLER_24_156/a_32_246# _242_ 0.03839f
C7804 _216_ _166_ 0.03464f
C7805 _642_/a_741_93# _641_/a_1583_191# 0
C7806 hold65/a_438_182# net30 0.05569f
C7807 hold65/a_326_118# _266_ 0
C7808 net176 _261_ 0
C7809 _052_ _262_ 0.00106f
C7810 _476_/a_146_122# _274_ 0
C7811 hold79/a_438_182# baud_inst.counter\[0\] 0.00273f
C7812 tx_inst.data_reg\[3\] _070_ 0.00125f
C7813 _291_ _184_ 0
C7814 rx_inst.data_reg\[3\] clkbuf_4_13_0_clk/a_27_118# 0.16066f
C7815 _680_/a_2250_412# net38 0.01468f
C7816 FILLER_5_156/a_32_246# clknet_0_clk 0
C7817 _082_ net2 0
C7818 _687_/a_1840_334# _308_ 0
C7819 _293_ VPWR 0.14895f
C7820 net67 _702_/a_1489_191# 0.01816f
C7821 _555_/a_380_412# _115_ 0
C7822 _671_/a_1583_191# _266_ 0.00233f
C7823 _671_/a_1840_334# net30 0
C7824 _671_/a_2250_412# _000_ 0.05146f
C7825 hold64/a_438_182# _122_ 0.00375f
C7826 net155 _658_/a_550_127# 0
C7827 hold174/a_326_118# _216_ 0
C7828 net178 _688_/a_1840_334# 0.00136f
C7829 _114_ _701_/a_741_93# 0.00124f
C7830 FILLER_9_79/a_32_246# net152 0
C7831 _079_ hold122/a_326_118# 0
C7832 hold101/a_326_118# _017_ 0
C7833 baud_inst.counter\[18\] hold102/a_326_118# 0
C7834 _489_/a_115_308# _038_ 0.01158f
C7835 VPWR FILLER_2_208/a_40_246# 0.16827f
C7836 FILLER_2_46/a_40_246# net60 0.00374f
C7837 _679_/a_324_432# _037_ 0.01087f
C7838 _679_/a_843_236# net95 0.04371f
C7839 hold114/a_326_118# net49 0
C7840 net2 _452_/a_155_412# 0.0053f
C7841 _377_/a_268_412# net7 0
C7842 net10 input7/a_40_152# 0.00424f
C7843 hold77/a_438_182# _471_/a_22_110# 0
C7844 _683_/a_2250_412# net29 0.00722f
C7845 _426_/a_154_118# net24 0
C7846 tx_inst.data_reg\[6\] _654_/a_741_93# 0
C7847 _171_ _006_ 0.00188f
C7848 _673_/a_1840_334# clknet_4_0_0_clk 0
C7849 _344_/a_150_412# baud_inst.counter\[26\] 0
C7850 _344_/a_252_412# baud_inst.counter\[27\] 0.00426f
C7851 _232_ _447_/a_175_118# 0.002f
C7852 _133_ _447_/a_81_118# 0
C7853 _448_/a_244_412# _259_ 0.00152f
C7854 _230_ _158_ 0
C7855 net27 FILLER_7_176/a_32_246# 0.00336f
C7856 hold63/a_56_118# _169_ 0.00103f
C7857 _177_ _703_/a_324_432# 0
C7858 net2 clknet_0_clk 0.04054f
C7859 VPWR _687_/a_38_114# 0
C7860 _467_/a_22_110# hold138/a_56_118# 0
C7861 rx_inst.state\[3\] _652_/a_1785_429# 0
C7862 hold74/a_56_118# _636_/a_2250_412# 0.00101f
C7863 hold74/a_326_118# _636_/a_1840_334# 0
C7864 hold74/a_438_182# _636_/a_1583_191# 0
C7865 net74 _636_/a_741_93# 0.01574f
C7866 FILLER_1_30/a_32_246# _087_ 0
C7867 _291_ FILLER_9_72/a_32_246# 0
C7868 _663_/a_1489_191# _666_/a_1583_191# 0
C7869 _513_/a_341_118# clkbuf_4_2_0_clk/a_27_118# 0
C7870 _075_ _666_/a_741_93# 0.02737f
C7871 _655_/a_298_337# VPWR 0.00729f
C7872 _241_ FILLER_17_162/a_32_246# 0.00206f
C7873 _178_ _703_/a_298_337# 0
C7874 _378_/a_285_118# _207_ 0
C7875 _519_/a_81_118# baud_inst.counter\[12\] 0.01623f
C7876 _663_/a_298_337# net43 0.00141f
C7877 baud_inst.counter\[18\] FILLER_15_42/a_40_246# 0.00136f
C7878 clkload3/Y clknet_0_clk 0
C7879 _406_/a_154_118# _262_ 0
C7880 hold155/a_56_118# _384_/a_59_156# 0
C7881 _659_/a_1489_191# VPWR 0
C7882 _644_/a_1840_334# _158_ 0.02847f
C7883 hold53/a_326_118# _161_ 0
C7884 hold181/a_438_182# _092_ 0
C7885 _689_/a_1840_334# baud_inst.counter\[16\] 0
C7886 hold166/a_56_118# net49 0
C7887 _032_ hold58/a_326_118# 0
C7888 VPWR _688_/a_741_93# 0.04616f
C7889 rx_done clknet_4_7_0_clk 0.00565f
C7890 _486_/a_358_436# _205_ 0.02715f
C7891 net109 hold109/a_326_118# 0.00106f
C7892 _292_ hold109/a_56_118# 0
C7893 baud_inst.counter\[22\] _695_/a_324_432# 0.02399f
C7894 baud_inst.counter\[23\] _695_/a_741_93# 0.02744f
C7895 net121 _108_ 0
C7896 baud_inst.counter\[28\] _556_/a_192_429# 0.04785f
C7897 net94 VPWR 0.31118f
C7898 tx _077_ 0
C7899 tx_data[3] net7 0
C7900 net98 _288_ 0.00457f
C7901 _009_ net116 0
C7902 _519_/a_81_118# net88 0.00385f
C7903 _660_/a_741_93# clk 0.01162f
C7904 _645_/a_1583_191# _158_ 0.00262f
C7905 FILLER_12_117/a_40_246# VPWR 0.13536f
C7906 _654_/a_1583_191# VPWR 0.00561f
C7907 hold166/a_438_182# net2 0
C7908 _698_/a_2002_114# net99 0
C7909 _675_/a_298_337# _088_ 0.02784f
C7910 _411_/a_115_308# clknet_0_clk 0
C7911 hold170/a_326_118# clknet_4_5_0_clk 0.00136f
C7912 net92 _499_/a_380_412# -0
C7913 rx_inst.data_reg\[3\] hold143/a_326_118# 0.00435f
C7914 VPWR _664_/a_612_127# 0.00243f
C7915 net57 _399_/a_154_118# 0
C7916 _012_ net40 0
C7917 clknet_0_clk _684_/a_1583_191# 0.02726f
C7918 _079_ net49 0
C7919 hold177/a_438_182# _296_ 0
C7920 _466_/a_120_432# _240_ 0
C7921 _039_ clknet_4_2_0_clk 0
C7922 _246_ _226_ 0.01399f
C7923 baud_inst.counter\[22\] _701_/a_612_127# 0
C7924 _283_ hold153/a_326_118# 0.0022f
C7925 _651_/a_324_432# FILLER_9_169/a_32_246# 0
C7926 net84 _156_ 0.01702f
C7927 net45 hold106/a_438_182# 0.01678f
C7928 _206_ net6 1.18069f
C7929 net94 hold93/a_326_118# 0
C7930 net92 hold93/a_56_118# 0.04644f
C7931 _690_/a_2250_412# baud_inst.counter\[16\] 0.00101f
C7932 hold107/a_56_118# net107 0.00337f
C7933 _653_/a_38_114# net43 0.00149f
C7934 _678_/a_38_114# net154 0
C7935 _663_/a_1583_191# hold146/a_56_118# 0.00104f
C7936 net42 net168 0.10518f
C7937 net98 _682_/a_681_505# 0
C7938 _007_ _666_/a_38_114# 0.01787f
C7939 _166_ _666_/a_843_236# 0.02719f
C7940 _676_/a_741_93# _670_/a_324_432# 0
C7941 rx _704_/a_38_114# 0
C7942 hold89/a_56_118# net87 0.06752f
C7943 _505_/a_76_160# net135 0.00628f
C7944 net172 _366_/a_170_412# 0
C7945 FILLER_13_228/a_40_246# rx_inst.state\[1\] 0.03087f
C7946 net74 hold81/a_326_118# 0
C7947 _463_/a_120_432# net30 0.00347f
C7948 _636_/a_298_337# hold73/a_326_118# 0
C7949 _636_/a_38_114# hold73/a_56_118# 0
C7950 clknet_4_15_0_clk _649_/a_1583_191# 0.01178f
C7951 clkbuf_4_15_0_clk/a_27_118# _649_/a_612_127# 0
C7952 _040_ _706_/a_843_236# 0
C7953 net87 _187_ 0.01063f
C7954 baud_inst.counter\[14\] _684_/a_324_432# 0
C7955 _490_/a_45_160# _038_ 0.11688f
C7956 _279_ _504_/a_474_130# 0
C7957 hold152/a_438_182# _284_ 0
C7958 _636_/a_2002_114# _266_ 0
C7959 hold151/a_56_118# _252_ 0
C7960 _350_/a_165_412# net29 0
C7961 hold109/a_438_182# _096_ 0.00493f
C7962 clknet_4_13_0_clk _668_/a_741_93# 0
C7963 _639_/a_324_432# rx_inst.state\[1\] 0.00486f
C7964 rx_inst.data_reg\[1\] _633_/a_38_114# 0
C7965 baud_inst.counter\[0\] net40 0
C7966 _392_/a_382_118# _392_/a_285_118# -0
C7967 clknet_4_0_0_clk _086_ 0
C7968 _682_/a_1583_191# clknet_4_2_0_clk 0
C7969 _305_ _107_ 0.01302f
C7970 net49 net1 0.0156f
C7971 _698_/a_38_114# _130_ 0
C7972 _391_/a_268_412# VPWR 0
C7973 tx_inst.data_reg\[5\] _339_/a_589_385# 0.00176f
C7974 hold123/a_326_118# VPWR 0.0072f
C7975 _091_ _185_ 0
C7976 net97 _684_/a_324_432# 0
C7977 _411_/a_115_308# hold166/a_438_182# 0
C7978 _671_/a_2002_114# VPWR 0.00129f
C7979 net54 FILLER_1_201/a_40_246# 0
C7980 hold177/a_326_118# baud_inst.counter\[12\] 0.02595f
C7981 hold177/a_56_118# net128 0.0031f
C7982 net49 _690_/a_1583_191# 0.02125f
C7983 clknet_4_10_0_clk _549_/a_155_412# 0
C7984 hold66/a_326_118# clknet_4_13_0_clk 0.0469f
C7985 baud_inst.counter\[19\] _688_/a_1840_334# 0
C7986 hold134/a_326_118# _313_ 0
C7987 net55 FILLER_1_212/a_32_246# 0.00111f
C7988 clknet_4_5_0_clk VPWR 1.06205f
C7989 FILLER_2_237/a_40_246# FILLER_4_237/a_40_246# 0
C7990 _637_/a_612_127# _634_/a_741_93# 0
C7991 _637_/a_1583_191# _634_/a_1583_191# 0
C7992 hold120/a_326_118# net45 0
C7993 net118 _668_/a_1583_191# 0
C7994 _632_/a_681_505# net65 0
C7995 _632_/a_843_236# _122_ 0.00285f
C7996 _378_/a_59_156# _213_ 0.02248f
C7997 _171_ _176_ 0.00311f
C7998 _481_/a_22_110# _192_ 0.00279f
C7999 baud_inst.counter\[8\] _505_/a_170_160# 0.00506f
C8000 _186_ clkbuf_4_2_0_clk/a_27_118# 0.00303f
C8001 net48 _647_/a_1583_191# 0.0202f
C8002 _134_ FILLER_25_150/a_32_246# 0.00632f
C8003 net48 _154_ 0.03156f
C8004 net27 FILLER_8_191/a_32_246# 0
C8005 _689_/a_38_114# _016_ 0.00698f
C8006 _689_/a_741_93# net157 0
C8007 _661_/a_612_127# _072_ 0.00483f
C8008 _661_/a_1840_334# tx_inst.data_reg\[7\] 0.01313f
C8009 _702_/a_38_114# _115_ 0.00873f
C8010 _702_/a_298_337# net68 0
C8011 net3 _146_ 0
C8012 _117_ _705_/a_298_337# 0
C8013 _451_/a_155_412# _161_ 0
C8014 _640_/a_2250_412# _263_ 0
C8015 FILLER_16_176/a_40_246# _136_ 0
C8016 net104 net101 0.00111f
C8017 _092_ net135 0.17662f
C8018 hold65/a_56_118# _049_ 0
C8019 _046_ clkbuf_4_13_0_clk/a_27_118# 0.06618f
C8020 FILLER_16_56/a_32_246# clknet_0_clk 0.01527f
C8021 _691_/a_612_127# clknet_4_8_0_clk 0.0025f
C8022 _640_/a_612_127# clknet_4_14_0_clk 0.00107f
C8023 _640_/a_1785_429# rx_inst.bit_index\[0\] 0
C8024 _491_/a_435_412# _085_ 0
C8025 _019_ _348_/a_248_122# 0.00196f
C8026 FILLER_4_100/a_40_246# _385_/a_46_156# 0.00582f
C8027 _198_ _665_/a_132_114# 0
C8028 _677_/a_1583_191# _142_ 0.00157f
C8029 _184_ baud_inst.counter\[4\] 0.15294f
C8030 hold77/a_438_182# _044_ 0.00224f
C8031 _694_/a_324_432# net107 0
C8032 _178_ _179_ 0.2024f
C8033 hold66/a_56_118# _122_ 0.02026f
C8034 net66 _474_/a_22_110# 0
C8035 hold54/a_438_182# _077_ 0
C8036 hold97/a_326_118# hold115/a_326_118# 0
C8037 net42 _677_/a_1583_191# 0
C8038 _652_/a_681_505# net43 0
C8039 _357_/a_252_412# net29 0.00102f
C8040 hold85/a_56_118# _269_ 0
C8041 _646_/a_1489_191# clknet_4_12_0_clk 0.00285f
C8042 _093_ baud_inst.counter\[9\] 0.0015f
C8043 baud_inst.counter\[23\] FILLER_19_55/a_40_246# 0
C8044 tx_data[6] FILLER_0_156/a_32_246# 0.02325f
C8045 _655_/a_843_236# tx_inst.data_reg\[1\] 0
C8046 net62 _007_ 0
C8047 rx hold51/a_56_118# 0
C8048 net48 FILLER_20_198/a_40_246# 0
C8049 FILLER_16_154/a_32_246# net2 0
C8050 output15/a_40_152# _636_/a_38_114# 0
C8051 _268_ FILLER_27_210/a_40_246# 0
C8052 _556_/a_341_118# _703_/a_38_114# 0
C8053 _635_/a_612_127# _264_ 0
C8054 _151_ _209_ 0.05406f
C8055 hold91/a_56_118# net91 0.00139f
C8056 _690_/a_741_93# FILLER_17_22/a_40_246# 0.00125f
C8057 net133 net134 0.54634f
C8058 net156 _100_ 0
C8059 fanout41/a_40_152# _206_ 0.01001f
C8060 _169_ clknet_0_clk 0.03309f
C8061 hold75/a_438_182# baud_inst.counter\[22\] 0.00461f
C8062 _646_/a_38_114# VPWR 0.02819f
C8063 net51 _459_/a_229_118# 0
C8064 clknet_4_11_0_clk _703_/a_1489_191# 0.0046f
C8065 baud_inst.counter\[7\] _678_/a_298_337# 0.00309f
C8066 clknet_4_3_0_clk _678_/a_38_114# 0.01987f
C8067 input11/a_40_152# _665_/a_2250_412# 0
C8068 tx_data[0] _656_/a_38_114# 0
C8069 net3 _656_/a_298_337# 0
C8070 _650_/a_843_236# _061_ 0
C8071 _650_/a_38_114# rx_inst.data_reg\[7\] 0
C8072 FILLER_26_88/a_40_246# _115_ 0
C8073 net31 _439_/a_150_412# 0.00158f
C8074 _107_ _693_/a_1489_191# 0.00247f
C8075 _663_/a_2002_114# clknet_0_clk 0
C8076 _230_ _407_/a_248_122# 0
C8077 _216_ _651_/a_1583_191# 0
C8078 VPWR _703_/a_324_432# 0
C8079 net41 _388_/a_382_118# 0
C8080 _635_/a_741_93# _156_ 0
C8081 net48 hold125/a_438_182# 0.04279f
C8082 net50 _275_ 0.00205f
C8083 net146 _006_ 0.00121f
C8084 hold179/a_438_182# net54 0
C8085 baud_inst.counter\[4\] FILLER_9_72/a_32_246# 0.00204f
C8086 net156 hold157/a_56_118# 0.01678f
C8087 _672_/a_38_114# FILLER_0_40/a_40_246# 0
C8088 input7/a_40_152# input8/a_40_152# 0.0015f
C8089 _688_/a_550_127# net161 0
C8090 _136_ _647_/a_843_236# 0
C8091 _157_ _647_/a_1840_334# 0.01884f
C8092 _104_ _300_ 0.03705f
C8093 net176 _697_/a_612_127# 0
C8094 net48 _160_ 0.24212f
C8095 _698_/a_1489_191# net140 0
C8096 net53 net24 0
C8097 hold147/a_56_118# _693_/a_1840_334# 0
C8098 hold147/a_326_118# _693_/a_1583_191# 0
C8099 _398_/a_115_308# _397_/a_279_412# 0
C8100 _398_/a_358_436# _397_/a_165_412# 0
C8101 _053_ _641_/a_298_337# 0
C8102 _642_/a_1840_334# _641_/a_2250_412# 0
C8103 _642_/a_298_337# _052_ 0
C8104 _705_/a_298_337# net11 0
C8105 _341_/a_1453_124# tx_inst.data_reg\[2\] 0
C8106 _341_/a_805_385# clknet_4_4_0_clk 0
C8107 _284_ _035_ 0
C8108 clk net43 0.22917f
C8109 _548_/a_170_160# _310_ 0
C8110 net71 VPWR 0.06178f
C8111 hold127/a_438_182# clknet_4_15_0_clk 0
C8112 _378_/a_382_118# net8 0
C8113 baud_inst.counter\[13\] _685_/a_38_114# 0.00322f
C8114 hold162/a_326_118# net46 0.00171f
C8115 _646_/a_38_114# net144 0.01877f
C8116 _675_/a_1840_334# net60 0
C8117 _675_/a_1583_191# _181_ 0
C8118 FILLER_8_70/a_32_246# net29 0.00402f
C8119 VPWR _473_/a_120_432# 0
C8120 _643_/a_741_93# net48 0
C8121 net173 net184 0.16328f
C8122 hold183/a_438_182# _142_ 0.00832f
C8123 _144_ tx_inst.data_reg\[0\] 0.02287f
C8124 net48 hold144/a_326_118# 0.05569f
C8125 _679_/a_612_127# net95 0.0091f
C8126 _234_ net25 0.05689f
C8127 hold167/a_326_118# _670_/a_843_236# 0
C8128 hold167/a_438_182# _670_/a_741_93# 0
C8129 clknet_4_12_0_clk _449_/a_27_156# 0
C8130 net35 fanout25/a_40_152# 0.00139f
C8131 _676_/a_741_93# _281_ 0
C8132 baud_inst.counter\[18\] _518_/a_139_160# 0
C8133 _690_/a_843_236# _298_ 0
C8134 clkbuf_4_8_0_clk/a_27_118# _687_/a_741_93# 0
C8135 VPWR _001_ 0.18945f
C8136 _098_ hold90/a_56_118# 0
C8137 _431_/a_379_118# clknet_0_clk 0.001f
C8138 baud_inst.counter\[27\] baud_inst.counter\[26\] 1.82412f
C8139 _479_/a_22_110# _200_ 0
C8140 _457_/a_22_110# hold73/a_326_118# 0
C8141 baud_inst.counter\[20\] FILLER_21_31/a_40_246# 0.01116f
C8142 _421_/a_150_412# net24 0
C8143 VPWR _687_/a_1840_334# 0.0039f
C8144 net84 hold138/a_438_182# 0.00355f
C8145 rx_data[7] hold73/a_56_118# 0.00466f
C8146 net74 _636_/a_1785_429# 0.00326f
C8147 _353_/a_248_122# _280_ 0
C8148 clknet_0_clk _084_ 0.03725f
C8149 _655_/a_1583_191# VPWR 0.01401f
C8150 clkbuf_4_2_0_clk/a_27_118# _684_/a_324_432# 0
C8151 clknet_4_7_0_clk _666_/a_1840_334# 0
C8152 net160 clknet_4_2_0_clk 0
C8153 clknet_4_13_0_clk _635_/a_38_114# 0.00182f
C8154 _679_/a_1583_191# net40 0
C8155 net122 _676_/a_2250_412# 0
C8156 clkbuf_4_12_0_clk/a_27_118# net32 0
C8157 net74 net48 0.00911f
C8158 _151_ _207_ 0.00188f
C8159 baud_inst.counter\[12\] net128 0.19412f
C8160 tx_inst.data_reg\[7\] _068_ 0
C8161 _077_ _665_/a_324_432# 0.02207f
C8162 hold96/a_56_118# _037_ 0.02068f
C8163 _041_ FILLER_12_166/a_40_246# 0.00154f
C8164 hold86/a_326_118# baud_inst.counter\[1\] 0.00813f
C8165 FILLER_4_108/a_40_246# _209_ 0.01525f
C8166 _663_/a_1583_191# net43 0.02078f
C8167 tx_inst.data_reg\[5\] VPWR 0.17252f
C8168 _355_/a_150_412# baud_inst.counter\[19\] 0
C8169 hold144/a_438_182# _259_ 0
C8170 net57 net56 0
C8171 VPWR _688_/a_1785_429# 0
C8172 _089_ _685_/a_741_93# -0
C8173 clkload0/Y VPWR 0.05382f
C8174 _345_/a_354_412# _178_ 0
C8175 _229_ fanout28/a_40_152# 0
C8176 baud_inst.counter\[22\] _695_/a_2250_412# 0
C8177 baud_inst.counter\[23\] _695_/a_1785_429# 0.00365f
C8178 _095_ _288_ 0.0237f
C8179 _241_ _436_/a_142_412# 0.00114f
C8180 baud_inst.counter\[31\] net58 0
C8181 baud_inst.counter\[28\] _316_ 0.28427f
C8182 tx_inst.data_reg\[6\] net54 0.0285f
C8183 _036_ _162_ 0
C8184 net128 net88 0.00193f
C8185 _127_ net71 1.63448f
C8186 _633_/a_1583_191# net77 0.00162f
C8187 _660_/a_1785_429# clk 0
C8188 _202_ _369_/a_146_122# 0
C8189 _645_/a_2002_114# _158_ 0
C8190 _635_/a_298_337# _122_ 0
C8191 _065_ FILLER_1_201/a_40_246# 0.0112f
C8192 _283_ _036_ 0.14147f
C8193 VPWR _005_ 0.35778f
C8194 _663_/a_1489_191# _215_ 0
C8195 FILLER_12_46/a_32_246# net97 0
C8196 clknet_0_clk _684_/a_2002_114# 0.00168f
C8197 net167 hold90/a_326_118# 0
C8198 hold148/a_56_118# net49 0
C8199 _361_/a_146_122# _194_ 0
C8200 _361_/a_248_122# _173_ 0
C8201 net173 net169 0
C8202 _677_/a_38_114# clknet_4_1_0_clk 0
C8203 hold178/a_326_118# VPWR 0
C8204 _230_ FILLER_18_158/a_40_246# 0.00117f
C8205 baud_inst.counter\[22\] net107 0.04737f
C8206 net129 FILLER_14_72/a_32_246# 0
C8207 FILLER_16_70/a_40_246# clknet_0_clk 0
C8208 _543_/a_146_122# net46 0
C8209 hold149/a_326_118# _106_ 0
C8210 _680_/a_741_93# _680_/a_843_236# 0
C8211 _653_/a_1840_334# net43 0.00361f
C8212 net88 _014_ 0.02423f
C8213 net141 _099_ 0.00105f
C8214 _310_ net46 0.04159f
C8215 net98 _682_/a_550_127# 0
C8216 _166_ _666_/a_612_127# 0.00486f
C8217 _009_ _682_/a_1489_191# 0.01399f
C8218 net2 _704_/a_1583_191# 0.03198f
C8219 _676_/a_2250_412# _670_/a_741_93# 0
C8220 rx _704_/a_1840_334# 0.04525f
C8221 net14 net83 0
C8222 _048_ hold83/a_326_118# 0.00278f
C8223 _178_ hold113/a_56_118# 0
C8224 _669_/a_843_236# net29 0.00164f
C8225 net71 _266_ 0.0244f
C8226 _268_ net30 0.49834f
C8227 _674_/a_741_93# _504_/a_380_412# 0
C8228 _216_ _394_/a_22_110# 0.00171f
C8229 _358_/a_268_436# _186_ 0.00155f
C8230 net128 net39 0
C8231 _171_ _276_ 0.03996f
C8232 net35 FILLER_17_162/a_32_246# 0
C8233 net2 net43 0.01022f
C8234 _634_/a_843_236# hold82/a_438_182# 0
C8235 _266_ _473_/a_120_432# 0.00121f
C8236 _183_ net29 0.05019f
C8237 _699_/a_132_114# net46 0
C8238 net26 net32 0.00993f
C8239 baud_inst.counter\[28\] hold133/a_438_182# 0.00376f
C8240 tx_inst.data_reg\[5\] _339_/a_1023_118# 0
C8241 _141_ _400_/a_192_429# 0.00297f
C8242 _403_/a_22_110# net183 0.00523f
C8243 tx net43 0.02885f
C8244 _230_ hold166/a_326_118# 0
C8245 hold112/a_326_118# _232_ 0
C8246 hold112/a_56_118# _133_ 0.03483f
C8247 _170_ _227_ 0.11916f
C8248 _672_/a_38_114# clknet_4_0_0_clk 0
C8249 hold98/a_438_182# net39 0
C8250 _671_/a_741_93# _140_ 0
C8251 net49 _690_/a_2002_114# 0
C8252 _671_/a_843_236# _235_ 0
C8253 clkload2/Y VPWR 0.00532f
C8254 clknet_4_10_0_clk _027_ 0
C8255 hold128/a_56_118# baud_inst.counter\[14\] 0
C8256 _233_ net25 0
C8257 _267_ _638_/a_1489_191# 0
C8258 _462_/a_22_110# net70 0.0122f
C8259 net37 FILLER_21_165/a_40_246# 0.01006f
C8260 _390_/a_59_156# _145_ 0
C8261 net159 _655_/a_2250_412# 0.00234f
C8262 net72 _634_/a_741_93# 0
C8263 _048_ _634_/a_843_236# 0.01641f
C8264 _637_/a_1489_191# _634_/a_1840_334# 0
C8265 _153_ _668_/a_1489_191# 0
C8266 _632_/a_612_127# _122_ 0.00151f
C8267 _074_ _198_ 0.00118f
C8268 net48 _647_/a_2002_114# 0
C8269 _645_/a_2250_412# net78 0
C8270 _023_ hold147/a_326_118# 0.00112f
C8271 _305_ hold147/a_438_182# 0
C8272 input2/a_40_152# _707_/a_1840_334# 0
C8273 net2 _707_/a_843_236# 0.00815f
C8274 hold138/a_438_182# _635_/a_741_93# 0
C8275 _705_/a_38_114# _275_ 0
C8276 net26 hold62/a_326_118# 0
C8277 baud_inst.counter\[23\] net120 0
C8278 baud_inst.counter\[21\] _022_ 0.03455f
C8279 _675_/a_681_505# _087_ 0
C8280 _680_/a_298_337# _094_ 0
C8281 FILLER_10_78/a_32_246# net29 0
C8282 hold145/a_438_182# clknet_4_4_0_clk 0.00965f
C8283 _377_/a_46_156# net4 0.00116f
C8284 _117_ _705_/a_1583_191# 0
C8285 net87 _025_ 0
C8286 net154 net29 0.00167f
C8287 net32 hold62/a_326_118# 0
C8288 net47 hold72/a_326_118# 0
C8289 net143 _647_/a_1583_191# 0
C8290 baud_inst.counter\[17\] _684_/a_324_432# 0
C8291 hold179/a_438_182# _065_ 0.00101f
C8292 baud_inst.counter\[13\] clknet_0_clk 0.1167f
C8293 _270_ FILLER_18_210/a_32_246# 0.00502f
C8294 _174_ net41 0.00411f
C8295 FILLER_5_164/a_40_246# _194_ 0.00195f
C8296 _029_ _701_/a_324_432# 0.00144f
C8297 net106 _701_/a_741_93# 0
C8298 _189_ net29 0.12986f
C8299 baud_inst.counter\[20\] _693_/a_741_93# 0
C8300 rx_inst.data_reg\[3\] clknet_4_12_0_clk 0
C8301 hold168/a_438_182# _664_/a_843_236# 0
C8302 rx_inst.state\[3\] _089_ 0
C8303 baud_inst.counter\[12\] _516_/a_279_412# 0
C8304 hold67/a_326_118# _702_/a_1583_191# 0
C8305 hold67/a_56_118# _702_/a_1840_334# 0
C8306 FILLER_0_103/a_32_246# net38 0
C8307 _678_/a_741_93# net137 0
C8308 hold88/a_56_118# _294_ 0.03766f
C8309 net39 _090_ 0.17061f
C8310 hold160/a_56_118# net103 0
C8311 hold69/a_326_118# rx_data[6] 0
C8312 net44 _544_/a_268_412# 0
C8313 _283_ _652_/a_38_114# 0
C8314 _032_ _703_/a_741_93# 0.00307f
C8315 FILLER_8_70/a_32_246# hold95/a_438_182# 0
C8316 VPWR _199_ 0.21372f
C8317 hold77/a_326_118# _648_/a_324_432# 0
C8318 _633_/a_741_93# _472_/a_22_110# 0.00117f
C8319 _175_ _359_/a_22_110# 0.0203f
C8320 net115 net29 0
C8321 _419_/a_154_118# _237_ 0
C8322 rx_inst.bit_index\[0\] _425_/a_46_156# 0
C8323 hold171/a_56_118# _206_ 0.00187f
C8324 _646_/a_1840_334# VPWR 0.00174f
C8325 _690_/a_612_127# net157 0
C8326 _187_ _354_/a_170_412# 0
C8327 hold175/a_56_118# _425_/a_46_156# 0
C8328 _679_/a_2250_412# net93 0
C8329 clknet_4_3_0_clk _678_/a_1840_334# 0.02135f
C8330 baud_inst.counter\[31\] _027_ 0.004f
C8331 net182 net154 0
C8332 net3 _656_/a_1583_191# 0
C8333 hold101/a_326_118# _690_/a_843_236# 0
C8334 _650_/a_612_127# _061_ 0.00775f
C8335 _650_/a_1840_334# rx_inst.data_reg\[7\] 0
C8336 hold101/a_438_182# _690_/a_741_93# 0
C8337 _489_/a_115_308# net86 0.00653f
C8338 _489_/a_358_436# net181 0.01327f
C8339 _663_/a_38_114# _078_ 0
C8340 net143 FILLER_20_198/a_40_246# 0.01224f
C8341 hold178/a_56_118# _513_/a_192_429# 0.00157f
C8342 hold124/a_56_118# _637_/a_298_337# 0.00262f
C8343 VPWR _703_/a_2250_412# 0.01055f
C8344 tx_data[1] tx_data[3] 0.21465f
C8345 net85 _156_ 0.0073f
C8346 net182 _189_ 0
C8347 hold118/a_326_118# VPWR 0.00879f
C8348 _549_/a_155_412# _308_ 0
C8349 net66 net111 0.00848f
C8350 _360_/a_71_118# hold165/a_326_118# 0
C8351 hold129/a_438_182# net29 0.05079f
C8352 _544_/a_46_156# clknet_0_clk 0.00136f
C8353 net7 tx_data[5] 0
C8354 tx_data[4] net8 0.10586f
C8355 _689_/a_1785_429# _298_ 0
C8356 _355_/a_354_412# VPWR 0
C8357 net37 _137_ 0
C8358 _136_ _647_/a_612_127# 0
C8359 baud_inst.counter\[20\] _535_/a_350_122# 0.00263f
C8360 net31 _246_ 0.17566f
C8361 net176 net142 0
C8362 _398_/a_494_160# _218_ 0
C8363 _398_/a_358_436# _219_ 0.09422f
C8364 _438_/a_248_122# _161_ 0.00121f
C8365 _053_ _641_/a_1583_191# 0
C8366 _642_/a_1583_191# _052_ 0
C8367 _313_ _543_/a_146_122# 0
C8368 _341_/a_1377_160# tx_inst.data_reg\[2\] 0.00136f
C8369 _341_/a_308_118# clknet_4_4_0_clk 0
C8370 _705_/a_1583_191# net11 0
C8371 net119 _456_/a_257_140# 0
C8372 hold183/a_56_118# _062_ 0.00456f
C8373 VPWR net175 0.13291f
C8374 net109 net40 0
C8375 baud_inst.counter\[13\] _182_ 0
C8376 net53 _641_/a_324_432# 0
C8377 hold53/a_56_118# _641_/a_1840_334# 0
C8378 baud_inst.counter\[21\] _108_ 0.22771f
C8379 _633_/a_741_93# _648_/a_741_93# 0
C8380 _313_ _310_ 0.00984f
C8381 _350_/a_165_412# _288_ 0.00468f
C8382 _083_ _676_/a_1583_191# 0
C8383 net70 hold72/a_326_118# 0
C8384 _206_ net8 0.32265f
C8385 _390_/a_382_118# VPWR 0.01411f
C8386 _680_/a_324_432# VPWR 0.01221f
C8387 baud_inst.counter\[13\] _685_/a_1840_334# 0.00502f
C8388 net28 _667_/a_843_236# 0
C8389 _699_/a_324_432# hold114/a_438_182# 0
C8390 _699_/a_843_236# hold114/a_56_118# 0
C8391 _699_/a_741_93# hold114/a_326_118# 0.00768f
C8392 net143 _160_ 0
C8393 baud_inst.counter\[3\] _491_/a_435_412# 0
C8394 _675_/a_2002_114# _181_ 0
C8395 _158_ _272_ 0.03944f
C8396 VPWR _273_ 0.17168f
C8397 hold156/a_438_182# _288_ 0
C8398 net120 FILLER_21_33/a_32_246# 0
C8399 clknet_4_12_0_clk _647_/a_681_505# 0
C8400 _633_/a_2250_412# _271_ 0
C8401 clk _654_/a_681_505# 0
C8402 net96 net95 -0
C8403 clknet_4_3_0_clk net29 0.23146f
C8404 net167 _670_/a_132_114# 0
C8405 _002_ _670_/a_1583_191# 0
C8406 rx_inst.state\[2\] FILLER_17_160/a_40_246# 0.01103f
C8407 net48 _140_ 0
C8408 _650_/a_843_236# _156_ 0
C8409 rx_inst.bit_index\[2\] _260_ 0.01851f
C8410 net145 fanout41/a_40_152# 0.00163f
C8411 _198_ _201_ 0.90925f
C8412 _440_/a_244_412# _253_ 0
C8413 _520_/a_155_412# _297_ 0.00364f
C8414 hold177/a_438_182# _294_ 0
C8415 tx_inst.data_reg\[6\] _065_ 0.43711f
C8416 FILLER_5_164/a_40_246# _341_/a_886_118# 0
C8417 hold162/a_56_118# _697_/a_132_114# 0
C8418 _384_/a_59_156# _383_/a_268_412# 0
C8419 _643_/a_1583_191# hold143/a_438_182# 0
C8420 _643_/a_2250_412# hold143/a_56_118# 0
C8421 _643_/a_741_93# net143 0
C8422 hold113/a_438_182# VPWR 0.00711f
C8423 _643_/a_1840_334# hold143/a_326_118# 0
C8424 hold56/a_56_118# net27 0.02235f
C8425 tx_inst.bit_index\[1\] hold173/a_56_118# 0
C8426 hold116/a_56_118# _505_/a_76_160# 0
C8427 hold54/a_56_118# net21 0
C8428 tx_inst.state\[1\] _704_/a_38_114# 0.00494f
C8429 clknet_4_7_0_clk _704_/a_324_432# 0.04093f
C8430 _034_ net40 0.00345f
C8431 _655_/a_2002_114# VPWR 0
C8432 hold156/a_56_118# _682_/a_1583_191# 0
C8433 _169_ net43 0.11945f
C8434 clknet_4_13_0_clk _635_/a_1840_334# 0
C8435 baud_inst.counter\[26\] _541_/a_380_412# 0
C8436 _045_ FILLER_29_221/a_32_246# 0
C8437 tx_inst.state\[3\] FILLER_4_237/a_40_246# 0
C8438 net174 clknet_0_clk 0
C8439 _285_ _186_ 0
C8440 _663_/a_2002_114# net43 0
C8441 _170_ _242_ 0.00129f
C8442 net48 net49 0.08099f
C8443 net55 _380_/a_382_118# 0.01303f
C8444 _661_/a_1583_191# _658_/a_38_114# 0
C8445 tx_inst.data_reg\[6\] clkbuf_4_4_0_clk/a_27_118# 0.00232f
C8446 net182 clknet_4_3_0_clk 0.01243f
C8447 baud_inst.counter\[14\] FILLER_17_81/a_32_246# 0
C8448 _206_ clkbuf_4_5_0_clk/a_27_118# 0.06408f
C8449 _133_ _136_ 0
C8450 _183_ hold95/a_438_182# 0
C8451 clkbuf_4_7_0_clk/a_27_118# _668_/a_324_432# 0
C8452 net106 hold105/a_438_182# 0
C8453 _646_/a_2250_412# net30 0
C8454 _646_/a_1840_334# _266_ 0.00424f
C8455 clkbuf_4_1_0_clk/a_27_118# _211_ 0
C8456 net49 _692_/a_550_127# 0
C8457 net71 _461_/a_22_110# 0
C8458 VPWR _161_ 0.64541f
C8459 _282_ clkbuf_4_1_0_clk/a_27_118# 0
C8460 hold137/a_326_118# net137 0
C8461 _487_/a_146_122# net172 0
C8462 FILLER_12_171/a_40_246# _651_/a_324_432# 0
C8463 _432_/a_248_122# _241_ 0
C8464 _241_ _157_ 0.23465f
C8465 net14 output17/a_40_152# 0.00154f
C8466 net32 FILLER_25_150/a_32_246# 0
C8467 _698_/a_741_93# clknet_0_clk 0.00921f
C8468 hold127/a_326_118# clknet_0_clk 0.00346f
C8469 _087_ net38 0.08673f
C8470 net79 _679_/a_612_127# 0
C8471 _277_ FILLER_15_162/a_40_246# 0
C8472 tx_inst.bit_index\[2\] _398_/a_358_436# 0.01749f
C8473 net42 _004_ 0
C8474 clknet_4_7_0_clk net19 0
C8475 _127_ _273_ 0
C8476 hold118/a_438_182# net30 0.00709f
C8477 _646_/a_1583_191# _647_/a_843_236# 0
C8478 _646_/a_843_236# _647_/a_1583_191# 0
C8479 _662_/a_681_505# net55 0
C8480 _531_/a_209_168# _531_/a_474_130# 0
C8481 _083_ _098_ 0
C8482 clknet_4_13_0_clk _650_/a_324_432# 0.01319f
C8483 _243_ _252_ 0
C8484 net49 baud_inst.counter\[17\] 0.11122f
C8485 _699_/a_324_432# _551_/a_76_160# 0
C8486 fanout40/a_40_152# baud_inst.counter\[19\] 0
C8487 net31 _444_/a_244_412# 0
C8488 _656_/a_1583_191# _150_ 0
C8489 _067_ _380_/a_382_118# 0
C8490 tx_inst.data_reg\[7\] _388_/a_382_118# 0
C8491 _656_/a_1840_334# _208_ 0.00684f
C8492 baud_inst.counter\[1\] VPWR 0.21373f
C8493 hold160/a_326_118# net40 0
C8494 _180_ hold90/a_326_118# 0
C8495 _641_/a_741_93# net175 0
C8496 _641_/a_38_114# net24 0
C8497 _556_/a_192_429# _556_/a_435_412# -0
C8498 hold100/a_56_118# net99 0.01322f
C8499 tx_inst.state\[1\] hold146/a_326_118# 0
C8500 _694_/a_298_337# FILLER_25_25/a_40_246# 0
C8501 _046_ clknet_4_12_0_clk 0
C8502 _170_ FILLER_21_175/a_32_246# 0
C8503 net98 clknet_4_2_0_clk 0
C8504 net2 _704_/a_2002_114# 0
C8505 _097_ baud_inst.counter\[10\] 0
C8506 net121 _302_ 0.02416f
C8507 net43 _665_/a_324_432# 0.01293f
C8508 _153_ _650_/a_681_505# 0
C8509 _518_/a_45_160# _100_ 0
C8510 _632_/a_741_93# clknet_4_15_0_clk 0
C8511 clknet_4_7_0_clk hold51/a_326_118# 0.00161f
C8512 _676_/a_2250_412# FILLER_11_123/a_40_246# 0.01012f
C8513 hold150/a_438_182# FILLER_29_179/a_40_246# 0.00941f
C8514 _643_/a_38_114# clknet_4_12_0_clk 0
C8515 _341_/a_295_385# clknet_0_clk 0
C8516 _266_ _273_ 0.03802f
C8517 _112_ _701_/a_1583_191# 0.00129f
C8518 _694_/a_741_93# net46 0.00422f
C8519 _697_/a_843_236# _025_ 0
C8520 _699_/a_1489_191# net46 0.00152f
C8521 FILLER_12_46/a_32_246# baud_inst.counter\[17\] 0
C8522 FILLER_12_82/a_32_246# net130 0
C8523 net43 _084_ 0
C8524 _248_ _136_ 0.12006f
C8525 clkbuf_4_10_0_clk/a_27_118# _699_/a_324_432# 0
C8526 _253_ net52 0
C8527 _143_ hold137/a_56_118# 0.01578f
C8528 _222_ _221_ 0.67798f
C8529 net49 _250_ 0.00126f
C8530 _644_/a_1583_191# FILLER_26_172/a_40_246# 0
C8531 _225_ net175 0.88515f
C8532 _657_/a_298_337# _209_ 0
C8533 _119_ _006_ 0
C8534 _429_/a_244_140# VPWR 0
C8535 _672_/a_1840_334# clknet_4_0_0_clk 0
C8536 _672_/a_1583_191# baud_inst.counter\[0\] 0.00136f
C8537 _204_ _405_/a_27_156# 0
C8538 _671_/a_612_127# _235_ 0
C8539 _267_ net18 0.00438f
C8540 _217_ clknet_4_4_0_clk 0
C8541 _048_ _634_/a_612_127# 0.02356f
C8542 net17 _634_/a_1840_334# 0
C8543 baud_inst.counter\[20\] _701_/a_298_337# 0
C8544 _660_/a_298_337# _206_ 0.00959f
C8545 _360_/a_71_118# FILLER_3_150/a_40_246# 0.02109f
C8546 hold59/a_56_118# _314_ 0
C8547 VPWR _365_/a_257_140# 0
C8548 _446_/a_248_122# _223_ 0
C8549 net2 _249_ 0
C8550 FILLER_4_183/a_40_246# _197_ 0
C8551 fanout41/a_40_152# hold137/a_438_182# 0.00137f
C8552 net27 _200_ 0.62504f
C8553 _017_ _527_/a_341_118# 0.01211f
C8554 _644_/a_324_432# net48 0.0011f
C8555 _045_ hold83/a_56_118# 0.00874f
C8556 VPWR FILLER_1_201/a_40_246# 0.13631f
C8557 _152_ hold50/a_438_182# 0
C8558 hold112/a_438_182# _054_ 0
C8559 _537_/a_192_429# _023_ 0.00149f
C8560 _499_/a_209_168# VPWR 0.01029f
C8561 net34 net26 0
C8562 FILLER_16_203/a_32_246# _650_/a_1489_191# 0
C8563 _692_/a_38_114# _105_ 0.04504f
C8564 hold77/a_56_118# _059_ 0
C8565 _646_/a_843_236# _160_ 0
C8566 _662_/a_38_114# _198_ 0
C8567 tx_inst.state\[4\] _166_ 0.60339f
C8568 _453_/a_170_412# net25 0
C8569 _116_ _702_/a_1489_191# 0
C8570 net143 _647_/a_2002_114# 0
C8571 _658_/a_324_432# net41 0.00952f
C8572 _182_ _502_/a_279_412# 0
C8573 tx_inst.data_reg\[5\] _652_/a_741_93# 0
C8574 hold153/a_56_118# VPWR 0.00159f
C8575 net179 tx_inst.data_reg\[0\] 0.54745f
C8576 _158_ _648_/a_298_337# 0
C8577 _637_/a_741_93# rx_inst.data_reg\[6\] 0
C8578 net154 _493_/a_45_160# 0
C8579 baud_inst.counter\[26\] FILLER_23_83/a_32_246# 0
C8580 baud_inst.counter\[20\] _693_/a_1785_429# 0.00102f
C8581 _096_ _682_/a_843_236# 0.00138f
C8582 _683_/a_324_432# clknet_4_2_0_clk 0.00179f
C8583 _645_/a_38_114# net48 0.02544f
C8584 hold165/a_326_118# clk 0.00224f
C8585 hold182/a_56_118# baud_inst.counter\[5\] 0
C8586 net128 _012_ 0.00666f
C8587 _270_ _636_/a_741_93# 0
C8588 _125_ _636_/a_324_432# 0.01109f
C8589 hold67/a_438_182# _702_/a_1489_191# 0
C8590 _306_ _548_/a_170_160# 0
C8591 hold163/a_438_182# _020_ 0
C8592 _242_ _263_ 0
C8593 _045_ _634_/a_741_93# 0.00106f
C8594 _177_ net58 0
C8595 hold65/a_326_118# net18 0
C8596 _679_/a_2250_412# clknet_4_1_0_clk 0
C8597 hold128/a_326_118# clknet_4_9_0_clk 0.00195f
C8598 _103_ FILLER_17_22/a_40_246# 0
C8599 rx_data[2] _124_ 0.04423f
C8600 FILLER_11_142/a_40_246# VPWR 0.12403f
C8601 _556_/a_192_429# net59 0.01129f
C8602 net58 _703_/a_550_127# 0
C8603 fanout35/a_40_152# _224_ 0
C8604 _633_/a_843_236# _123_ 0.07059f
C8605 clknet_0_clk _649_/a_1489_191# 0.01605f
C8606 hold153/a_326_118# hold153/a_438_182# 0
C8607 _483_/a_22_110# FILLER_14_164/a_32_246# 0
C8608 _090_ _676_/a_843_236# 0
C8609 net39 _676_/a_681_505# 0
C8610 hold167/a_326_118# net26 0
C8611 net5 net171 0.03504f
C8612 _489_/a_115_308# hold115/a_56_118# 0
C8613 _202_ clkbuf_4_5_0_clk/a_27_118# 0
C8614 _061_ rx_inst.state\[4\] 0
C8615 _377_/a_46_156# net40 0
C8616 clknet_4_3_0_clk hold95/a_438_182# 0.0207f
C8617 hold153/a_326_118# hold93/a_56_118# 0
C8618 net156 _522_/a_209_168# 0
C8619 _103_ _299_ 0.00178f
C8620 clknet_4_12_0_clk _043_ 0.04398f
C8621 hold175/a_326_118# _242_ 0
C8622 tx_start tx_inst.state\[3\] 0.00549f
C8623 _671_/a_681_505# _084_ 0
C8624 _061_ net119 0.01088f
C8625 baud_inst.counter\[18\] _690_/a_1583_191# 0.00103f
C8626 VPWR FILLER_28_204/a_32_246# 0.0818f
C8627 _242_ _237_ 0
C8628 net39 _683_/a_681_505# 0
C8629 hold85/a_438_182# _047_ 0
C8630 _225_ _161_ 0
C8631 hold178/a_326_118# _163_ 0
C8632 rx_data[4] _168_ 0
C8633 VPWR clkbuf_4_14_0_clk/a_27_118# 0.07541f
C8634 _358_/a_72_436# FILLER_12_82/a_32_246# 0.01002f
C8635 _059_ _633_/a_741_93# 0.00316f
C8636 _691_/a_324_432# VPWR 0.00846f
C8637 rx_inst.bit_index\[2\] _428_/a_354_412# 0
C8638 net33 net11 0.24135f
C8639 _136_ net139 0.00119f
C8640 _143_ _219_ 0
C8641 _159_ _633_/a_741_93# 0.00637f
C8642 _688_/a_741_93# _523_/a_155_412# 0
C8643 hold76/a_326_118# baud_inst.counter\[20\] 0.0064f
C8644 _706_/a_298_337# _200_ 0.00135f
C8645 _706_/a_324_432# net172 0
C8646 clknet_4_5_0_clk hold168/a_438_182# 0.0126f
C8647 hold77/a_56_118# _155_ 0
C8648 hold77/a_326_118# net124 0
C8649 net48 _649_/a_38_114# 0.00451f
C8650 _305_ _693_/a_1583_191# 0.00389f
C8651 net31 FILLER_15_162/a_40_246# 0.02224f
C8652 _230_ _642_/a_843_236# 0.00108f
C8653 net48 net131 0.03244f
C8654 hold179/a_438_182# VPWR 0.00708f
C8655 net150 _056_ 0
C8656 _143_ _678_/a_2250_412# 0
C8657 FILLER_17_201/a_32_246# _647_/a_1583_191# 0
C8658 _633_/a_2250_412# _648_/a_843_236# 0
C8659 _699_/a_1840_334# clknet_0_clk 0
C8660 baud_inst.counter\[10\] net116 0.08536f
C8661 _183_ _288_ 1.22171f
C8662 _231_ _410_/a_155_412# 0
C8663 hold74/a_438_182# hold118/a_326_118# 0
C8664 _227_ _410_/a_257_140# 0.00198f
C8665 hold74/a_326_118# hold118/a_438_182# 0
C8666 _239_ clkbuf_4_14_0_clk/a_27_118# 0.00228f
C8667 _680_/a_2250_412# VPWR 0.00307f
C8668 _004_ _667_/a_2250_412# 0
C8669 net49 _374_/a_550_140# 0
C8670 _641_/a_298_337# VPWR 0.00303f
C8671 FILLER_24_133/a_32_246# _256_ 0.01443f
C8672 _549_/a_155_412# VPWR 0.00235f
C8673 _656_/a_843_236# net41 0
C8674 FILLER_25_177/a_40_246# clkbuf_4_14_0_clk/a_27_118# 0.01094f
C8675 _414_/a_279_412# net37 0.00121f
C8676 _314_ FILLER_27_46/a_32_246# 0
C8677 hold162/a_56_118# _546_/a_192_429# 0
C8678 _468_/a_120_432# _157_ 0.00423f
C8679 hold181/a_326_118# _673_/a_1583_191# 0.00463f
C8680 FILLER_4_100/a_40_246# _655_/a_1840_334# 0
C8681 clk net51 0.16312f
C8682 VPWR _458_/a_279_412# 0
C8683 hold132/a_438_182# _242_ 0
C8684 _428_/a_354_412# _243_ 0.00336f
C8685 _384_/a_285_412# _210_ 0.00619f
C8686 tx_inst.bit_index\[1\] _659_/a_1785_429# 0
C8687 _206_ _386_/a_285_118# 0.00153f
C8688 VPWR _647_/a_298_337# 0.01787f
C8689 clknet_4_11_0_clk net45 0.89189f
C8690 net44 _698_/a_612_127# 0
C8691 hold170/a_326_118# tx_inst.data_reg\[6\] 0.00872f
C8692 _678_/a_38_114# clknet_0_clk 0
C8693 clknet_4_7_0_clk _704_/a_2250_412# 0
C8694 _539_/a_45_160# _301_ 0.01097f
C8695 hold57/a_438_182# VPWR 0.00464f
C8696 hold104/a_438_182# net104 0
C8697 _462_/a_22_110# _649_/a_2250_412# 0
C8698 tx_data[2] net171 0.03101f
C8699 baud_inst.counter\[5\] net29 0.04629f
C8700 _108_ _301_ 0.00281f
C8701 _339_/a_71_118# _172_ 0
C8702 baud_inst.counter\[7\] _091_ 0.04948f
C8703 _049_ net64 0
C8704 hold142/a_56_118# _026_ 0.00262f
C8705 clknet_0_clk net77 0
C8706 _657_/a_38_114# _149_ 0
C8707 _206_ _659_/a_38_114# 0.02228f
C8708 _017_ net40 0
C8709 hold53/a_438_182# _224_ 0
C8710 FILLER_19_178/a_40_246# _223_ 0
C8711 _693_/a_324_432# fanout46/a_40_152# 0
C8712 clk _214_ 0.02485f
C8713 _283_ _511_/a_354_412# 0
C8714 _516_/a_279_412# _012_ 0
C8715 _688_/a_1840_334# baud_inst.counter\[16\] 0.00292f
C8716 rx_data[2] net82 0.01944f
C8717 net49 clknet_4_10_0_clk 0.1655f
C8718 _288_ net115 0.00866f
C8719 _393_/a_170_412# net168 0
C8720 _152_ net172 0
C8721 _693_/a_324_432# net149 0.0382f
C8722 _698_/a_1785_429# clknet_0_clk 0.00174f
C8723 rx_inst.bit_index\[1\] fanout25/a_40_152# 0
C8724 _266_ FILLER_28_204/a_32_246# 0
C8725 _177_ _027_ 0.03907f
C8726 _351_/a_46_156# net40 0
C8727 fanout30/a_40_152# VPWR 0.01609f
C8728 _638_/a_132_114# _273_ 0
C8729 net79 net96 0
C8730 clkbuf_4_4_0_clk/a_27_118# net183 0
C8731 _166_ FILLER_7_210/a_40_246# 0.01193f
C8732 _430_/a_170_412# clknet_0_clk 0
C8733 _489_/a_115_308# net38 0.00628f
C8734 tx_inst.bit_index\[2\] _143_ 0.36449f
C8735 clknet_4_7_0_clk _707_/a_132_114# 0
C8736 fanout29/a_40_152# VPWR 0.00579f
C8737 hold179/a_326_118# net179 0.01749f
C8738 clknet_4_6_0_clk _666_/a_132_114# 0
C8739 _646_/a_2250_412# _647_/a_2250_412# 0.00235f
C8740 _662_/a_550_127# net55 0
C8741 _117_ net23 0
C8742 _531_/a_380_412# _020_ 0.02095f
C8743 net184 _396_/a_257_140# 0
C8744 net182 baud_inst.counter\[5\] 0
C8745 hold130/a_326_118# baud_inst.counter\[13\] 0.00316f
C8746 _639_/a_1840_334# rx_inst.data_reg\[7\] 0
C8747 clknet_4_13_0_clk _650_/a_2250_412# 0.01262f
C8748 _109_ clkbuf_4_8_0_clk/a_27_118# 0
C8749 _640_/a_298_337# net52 0
C8750 net38 _681_/a_324_432# 0.05848f
C8751 hold150/a_438_182# VPWR 0.00686f
C8752 tx_inst.data_reg\[6\] VPWR 0.3215f
C8753 _705_/a_298_337# hold50/a_56_118# 0
C8754 _675_/a_324_432# net61 0.01326f
C8755 _675_/a_1840_334# hold61/a_56_118# 0
C8756 _644_/a_132_114# hold151/a_56_118# 0
C8757 _644_/a_38_114# _135_ 0.00607f
C8758 _031_ _555_/a_209_168# 0.01936f
C8759 _690_/a_298_337# _527_/a_192_429# 0
C8760 _078_ hold169/a_326_118# 0.01037f
C8761 clkload1/Y _166_ 0
C8762 _641_/a_1785_429# net175 0
C8763 _641_/a_1840_334# net24 0.00622f
C8764 hold98/a_56_118# _512_/a_165_412# 0
C8765 net39 _677_/a_1583_191# 0.02551f
C8766 clknet_4_7_0_clk net21 0.00851f
C8767 _095_ clknet_4_2_0_clk 0.02395f
C8768 net31 FILLER_18_160/a_32_246# 0
C8769 _556_/a_192_429# _032_ 0.00817f
C8770 _556_/a_155_160# net58 0
C8771 _556_/a_435_412# _316_ 0.00414f
C8772 baud_inst.counter\[18\] baud_inst.counter\[14\] 0.00227f
C8773 clk FILLER_3_150/a_40_246# 0.009f
C8774 net72 hold71/a_438_182# 0
C8775 _440_/a_142_412# _056_ 0
C8776 net17 hold71/a_56_118# 0.03223f
C8777 _070_ _382_/a_59_156# 0
C8778 hold117/a_326_118# _681_/a_1583_191# 0
C8779 hold117/a_56_118# _681_/a_1840_334# 0.00193f
C8780 net35 _259_ 0
C8781 _674_/a_1489_191# net135 0.00117f
C8782 FILLER_11_123/a_40_246# FILLER_11_125/a_32_246# 0.0524f
C8783 _448_/a_142_412# VPWR 0.00202f
C8784 tx_data[1] tx_data[5] 0.88211f
C8785 _546_/a_192_429# net141 0
C8786 _643_/a_1840_334# clknet_4_12_0_clk 0
C8787 _645_/a_298_337# _135_ 0.00119f
C8788 _112_ _701_/a_2002_114# 0
C8789 _040_ net33 0.07598f
C8790 _697_/a_612_127# _025_ 0
C8791 net44 baud_inst.counter\[21\] 0.03166f
C8792 net58 VPWR 0.11898f
C8793 _000_ net30 0.10724f
C8794 net26 hold180/a_438_182# 0.01099f
C8795 net163 _104_ 0.09936f
C8796 FILLER_18_148/a_40_246# VPWR 0.13298f
C8797 FILLER_26_141/a_40_246# _253_ 0.0198f
C8798 clkbuf_4_12_0_clk/a_27_118# _137_ 0.00188f
C8799 baud_inst.counter\[31\] net49 0.13531f
C8800 hold159/a_326_118# net38 0.00357f
C8801 _227_ hold180/a_326_118# 0.01414f
C8802 _231_ hold180/a_56_118# 0
C8803 hold87/a_326_118# _180_ 0.00228f
C8804 rx_inst.state\[2\] clknet_4_14_0_clk 0
C8805 _117_ clkbuf_4_7_0_clk/a_27_118# 0.0029f
C8806 net35 _157_ 0
C8807 net35 _432_/a_248_122# 0
C8808 _048_ net83 0.05739f
C8809 FILLER_21_165/a_40_246# net32 0.00245f
C8810 _378_/a_59_156# net38 0.00109f
C8811 _660_/a_1583_191# _206_ 0
C8812 _291_ _502_/a_165_412# 0
C8813 net2 net51 5.2859f
C8814 net138 _635_/a_1489_191# 0
C8815 clknet_4_15_0_clk _648_/a_1583_191# 0
C8816 net87 net103 0
C8817 _206_ FILLER_0_156/a_32_246# 0.00146f
C8818 _644_/a_2250_412# net48 0.00118f
C8819 hold80/a_56_118# rx_inst.state\[1\] 0
C8820 _305_ _023_ 0.02636f
C8821 clk _339_/a_71_118# 0
C8822 _191_ FILLER_12_128/a_40_246# 0.00857f
C8823 net21 _665_/a_1583_191# 0.00816f
C8824 net49 hold149/a_438_182# 0.0026f
C8825 _646_/a_612_127# _160_ 0
C8826 _688_/a_741_93# net157 0
C8827 _688_/a_38_114# _016_ 0
C8828 _692_/a_1840_334# _105_ 0
C8829 VPWR _418_/a_268_412# 0
C8830 _658_/a_2250_412# net41 0.00599f
C8831 clknet_4_1_0_clk _382_/a_382_118# 0
C8832 hold122/a_326_118# _204_ 0
C8833 hold177/a_56_118# _292_ 0.01424f
C8834 _158_ _648_/a_1583_191# 0.00217f
C8835 net100 _180_ 0
C8836 _685_/a_38_114# net29 0.00585f
C8837 _645_/a_1840_334# net48 0.0036f
C8838 net45 hold113/a_326_118# 0.00239f
C8839 net4 FILLER_0_80/a_40_246# 0
C8840 _499_/a_380_412# _036_ 0
C8841 _028_ VPWR 0.23146f
C8842 hold168/a_56_118# tx_inst.state\[2\] 0.03204f
C8843 _125_ _636_/a_2250_412# 0.01202f
C8844 _490_/a_45_160# net38 0.0023f
C8845 hold133/a_326_118# VPWR 0.00477f
C8846 FILLER_25_7/a_40_246# net1 0.00575f
C8847 clknet_4_12_0_clk net2 0.0143f
C8848 hold57/a_326_118# net57 0
C8849 net48 _270_ 0.19512f
C8850 _646_/a_324_432# _054_ 0
C8851 _646_/a_741_93# net47 0
C8852 clknet_4_5_0_clk _665_/a_298_337# 0.01495f
C8853 _316_ net59 0
C8854 _036_ hold93/a_56_118# 0.03034f
C8855 net42 _666_/a_324_432# 0.02002f
C8856 net62 _667_/a_741_93# 0
C8857 FILLER_19_55/a_40_246# _296_ 0.02324f
C8858 _633_/a_612_127# _123_ 0.01052f
C8859 clknet_0_clk rx_inst.data_reg\[6\] 0
C8860 _658_/a_843_236# tx_inst.data_reg\[3\] 0
C8861 _069_ _657_/a_1583_191# 0
C8862 _129_ hold81/a_56_118# 0.02764f
C8863 _265_ hold81/a_326_118# 0.00521f
C8864 _112_ _311_ 0
C8865 net155 _385_/a_46_156# 0
C8866 _206_ _385_/a_268_412# 0.00225f
C8867 _677_/a_741_93# baud_inst.counter\[6\] 0.00102f
C8868 _152_ _705_/a_843_236# 0
C8869 net39 _676_/a_550_127# 0
C8870 net50 _705_/a_38_114# 0.02167f
C8871 _142_ FILLER_9_169/a_32_246# 0
C8872 fanout30/a_40_152# _167_ 0.0968f
C8873 net156 _296_ 0.97962f
C8874 _411_/a_115_308# net51 0
C8875 _287_ _037_ 2.00701f
C8876 hold101/a_56_118# clknet_4_8_0_clk 0
C8877 hold101/a_438_182# _103_ 0
C8878 _114_ net46 0.00131f
C8879 clknet_0_clk _668_/a_298_337# 0.00294f
C8880 hold111/a_56_118# _635_/a_298_337# 0
C8881 hold115/a_56_118# _681_/a_2250_412# 0
C8882 _189_ FILLER_14_72/a_32_246# 0
C8883 net178 _684_/a_298_337# 0.0333f
C8884 _638_/a_741_93# VPWR 0.01878f
C8885 _102_ clknet_4_2_0_clk 0.02839f
C8886 _639_/a_843_236# _050_ -0
C8887 net26 _137_ 0
C8888 _639_/a_324_432# clknet_4_13_0_clk 0.00525f
C8889 _639_/a_741_93# net81 0.00634f
C8890 _691_/a_2250_412# VPWR 0.01088f
C8891 net31 _441_/a_154_118# 0.00275f
C8892 rx_inst.bit_index\[2\] _245_ 0.01295f
C8893 _691_/a_1583_191# FILLER_17_24/a_32_246# 0
C8894 _696_/a_38_114# net99 0
C8895 _048_ _470_/a_22_110# 0
C8896 net138 hold84/a_326_118# 0.0047f
C8897 _315_ hold107/a_438_182# 0
C8898 _355_/a_150_412# baud_inst.counter\[16\] 0.00835f
C8899 hold182/a_56_118# clknet_0_clk 0.00191f
C8900 _688_/a_741_93# _298_ 0.00457f
C8901 _643_/a_843_236# net24 0.00197f
C8902 FILLER_8_189/a_40_246# net168 0.01241f
C8903 _187_ _687_/a_298_337# 0
C8904 _411_/a_115_308# clknet_4_12_0_clk 0
C8905 _230_ _642_/a_612_127# 0
C8906 _411_/a_358_436# _132_ 0
C8907 net36 _131_ 0.00699f
C8908 _216_ _667_/a_1583_191# 0
C8909 FILLER_2_110/a_32_246# hold159/a_326_118# 0.00121f
C8910 _661_/a_681_505# _209_ 0
C8911 hold162/a_56_118# clknet_4_8_0_clk 0.00528f
C8912 _633_/a_1583_191# _648_/a_1489_191# 0
C8913 hold123/a_326_118# _063_ 0
C8914 _231_ _229_ 0.00176f
C8915 FILLER_19_228/a_40_246# _156_ 0.00128f
C8916 _633_/a_1583_191# FILLER_29_198/a_40_246# 0.00234f
C8917 net10 input10/a_40_152# 0.01035f
C8918 _643_/a_1583_191# net64 0
C8919 net49 _204_ 0
C8920 net49 _703_/a_681_505# 0
C8921 net100 net140 0.00123f
C8922 clknet_4_6_0_clk clknet_0_clk 0.13269f
C8923 _641_/a_1583_191# VPWR 0.0055f
C8924 _027_ VPWR 0.13157f
C8925 net119 _156_ 0
C8926 _089_ _293_ 0
C8927 net120 hold147/a_56_118# 0.00415f
C8928 _675_/a_1583_191# _279_ 0
C8929 net79 _504_/a_380_412# 0
C8930 _339_/a_382_118# _653_/a_843_236# 0
C8931 _339_/a_1453_124# _653_/a_1583_191# 0.00102f
C8932 _652_/a_298_337# VPWR 0.0033f
C8933 _125_ _157_ 0.01058f
C8934 _225_ FILLER_18_148/a_40_246# 0.01184f
C8935 _009_ hold156/a_326_118# 0.00284f
C8936 FILLER_15_162/a_40_246# net62 0
C8937 net42 _168_ 0.01866f
C8938 FILLER_27_194/a_40_246# _633_/a_1583_191# 0
C8939 _673_/a_324_432# clknet_0_clk 0
C8940 _218_ clknet_0_clk 0.00452f
C8941 _245_ _243_ 0.14965f
C8942 net171 _210_ 0.09771f
C8943 net79 hold60/a_438_182# 0
C8944 rx_inst.data_reg\[0\] _632_/a_132_114# 0
C8945 VPWR _647_/a_1583_191# 0.00793f
C8946 _680_/a_1583_191# _181_ 0
C8947 _657_/a_1583_191# clknet_4_4_0_clk 0.00466f
C8948 net31 FILLER_17_160/a_40_246# 0.01548f
C8949 baud_inst.counter\[21\] _302_ 1.4426f
C8950 _154_ VPWR 0.24545f
C8951 _232_ _161_ 0.00124f
C8952 _639_/a_1583_191# FILLER_16_221/a_32_246# 0
C8953 _047_ hold84/a_326_118# 0.00115f
C8954 _388_/a_559_412# _146_ 0.00123f
C8955 _388_/a_496_118# net165 0
C8956 _678_/a_1840_334# clknet_0_clk 0.0013f
C8957 rx_data[0] net17 0.00314f
C8958 hold156/a_438_182# clknet_4_2_0_clk 0.00193f
C8959 hold74/a_56_118# net30 0.00486f
C8960 net148 _105_ 0.00496f
C8961 net121 _692_/a_1489_191# 0
C8962 hold139/a_326_118# FILLER_20_177/a_32_246# 0
C8963 net34 hold56/a_438_182# 0
C8964 _127_ _638_/a_741_93# 0
C8965 hold59/a_56_118# _703_/a_298_337# 0
C8966 hold172/a_438_182# _665_/a_741_93# 0
C8967 _679_/a_1840_334# _352_/a_46_156# 0
C8968 hold172/a_326_118# _665_/a_843_236# 0
C8969 clknet_4_15_0_clk hold70/a_326_118# 0.04941f
C8970 clknet_4_11_0_clk FILLER_21_96/a_40_246# 0
C8971 hold88/a_326_118# _189_ 0
C8972 _696_/a_298_337# _180_ 0
C8973 net6 tx_data[7] 0.09964f
C8974 _360_/a_886_118# tx_inst.data_reg\[0\] 0.01961f
C8975 _679_/a_324_432# clknet_4_0_0_clk 0
C8976 tx_inst.data_reg\[7\] _658_/a_324_432# 0.06332f
C8977 net79 hold135/a_438_182# 0.00182f
C8978 hold66/a_438_182# rx_inst.data_reg\[0\] 0.01177f
C8979 net66 hold111/a_326_118# 0.01124f
C8980 _147_ _382_/a_382_118# 0.00357f
C8981 _206_ _659_/a_1840_334# 0
C8982 baud_inst.counter\[5\] _493_/a_45_160# 0
C8983 _121_ _668_/a_1583_191# 0.00239f
C8984 _679_/a_2250_412# hold94/a_438_182# 0.00887f
C8985 net31 _427_/a_350_122# 0
C8986 hold97/a_438_182# VPWR 0.00562f
C8987 _082_ net29 0.00921f
C8988 net71 net18 0.04342f
C8989 _641_/a_38_114# FILLER_20_106/a_32_246# 0
C8990 net51 _169_ 0.03675f
C8991 _154_ _239_ 0.13105f
C8992 _405_/a_27_156# VPWR 0.00679f
C8993 _135_ _230_ 0
C8994 _433_/a_244_412# _156_ 0
C8995 _132_ FILLER_19_139/a_40_246# 0
C8996 FILLER_20_198/a_40_246# VPWR 0.16064f
C8997 _638_/a_1489_191# _273_ 0.00363f
C8998 FILLER_19_132/a_40_246# _131_ 0.00497f
C8999 net45 _550_/a_209_168# 0.02964f
C9000 net37 _158_ 0
C9001 _400_/a_192_429# _400_/a_435_412# -0
C9002 clknet_4_7_0_clk _707_/a_1489_191# 0.0052f
C9003 net140 _296_ 0.00155f
C9004 _656_/a_324_432# _388_/a_382_118# 0
C9005 hold124/a_56_118# _462_/a_22_110# 0
C9006 _638_/a_843_236# net30 0.05786f
C9007 _638_/a_741_93# _266_ 0.00128f
C9008 FILLER_25_177/a_40_246# _154_ 0
C9009 clknet_4_6_0_clk _666_/a_1489_191# 0.0052f
C9010 baud_inst.counter\[12\] _292_ 1.09718f
C9011 rx_data[4] _636_/a_38_114# 0.03529f
C9012 net16 _636_/a_324_432# 0.00289f
C9013 _640_/a_1583_191# net52 0.00494f
C9014 _032_ FILLER_23_83/a_32_246# 0
C9015 net38 _681_/a_2250_412# 0.00223f
C9016 _138_ _429_/a_244_140# 0
C9017 fanout36/a_40_152# VPWR 0.04445f
C9018 _706_/a_132_114# _119_ 0
C9019 _706_/a_843_236# _042_ 0.00557f
C9020 net145 _386_/a_285_118# 0
C9021 tx_inst.data_reg\[5\] _653_/a_1489_191# 0
C9022 net178 baud_inst.counter\[16\] 0.06191f
C9023 clknet_4_8_0_clk net141 0.12632f
C9024 hold164/a_326_118# _105_ 0.00771f
C9025 _114_ _313_ 0
C9026 _442_/a_248_122# _161_ 0
C9027 _661_/a_681_505# _207_ 0
C9028 _661_/a_1583_191# net55 0.00444f
C9029 clkbuf_4_0_0_clk/a_27_118# _037_ 0.03444f
C9030 clknet_0_clk net29 0.3338f
C9031 _052_ net175 0
C9032 fanout33/a_40_152# _706_/a_741_93# 0
C9033 hold98/a_326_118# _292_ 0
C9034 hold98/a_56_118# _010_ 0.00531f
C9035 hold98/a_438_182# net109 0
C9036 _090_ _677_/a_1489_191# 0
C9037 hold102/a_326_118# net160 0
C9038 hold102/a_56_118# _296_ 0.00618f
C9039 net49 _688_/a_1489_191# 0
C9040 hold125/a_438_182# VPWR 0.03049f
C9041 _316_ _032_ 0.02855f
C9042 _060_ _268_ 0.00134f
C9043 _638_/a_298_337# net126 0
C9044 _353_/a_248_122# _184_ 0.00216f
C9045 net82 _637_/a_612_127# 0
C9046 net55 _275_ 0.27668f
C9047 _678_/a_1840_334# _182_ 0
C9048 _004_ fanout32/a_40_152# 0
C9049 _465_/a_120_432# clknet_4_13_0_clk 0
C9050 _637_/a_324_432# hold70/a_326_118# 0
C9051 _637_/a_741_93# hold70/a_56_118# 0
C9052 hold69/a_326_118# net69 0.00256f
C9053 FILLER_6_205/a_40_246# _006_ 0.00135f
C9054 net118 rx_inst.data_reg\[7\] 0.25141f
C9055 _158_ _056_ 0.00837f
C9056 _030_ _038_ 0.00202f
C9057 baud_inst.counter\[2\] net135 0.01375f
C9058 VPWR net183 0.14245f
C9059 _292_ net88 0
C9060 _410_/a_155_412# _228_ 0.07946f
C9061 _127_ _154_ 0
C9062 hold173/a_56_118# _397_/a_165_412# 0
C9063 _677_/a_1583_191# _676_/a_843_236# 0
C9064 _677_/a_1840_334# _676_/a_741_93# 0
C9065 _160_ VPWR 0.70173f
C9066 _641_/a_741_93# _641_/a_1583_191# 0
C9067 _360_/a_805_385# VPWR 0
C9068 _101_ _525_/a_46_156# 0.00179f
C9069 FILLER_20_57/a_32_246# baud_inst.counter\[23\] 0
C9070 _645_/a_132_114# net151 0
C9071 net147 _107_ 0
C9072 clknet_4_13_0_clk _264_ 1.66848f
C9073 clknet_4_3_0_clk FILLER_11_123/a_40_246# 0
C9074 net48 _265_ 0.04445f
C9075 _107_ net46 0.00401f
C9076 _186_ VPWR 0.19513f
C9077 rx_inst.state\[3\] FILLER_15_116/a_40_246# 0
C9078 net142 _025_ 0.41759f
C9079 net145 _659_/a_38_114# 0
C9080 net172 net168 0.19466f
C9081 net128 _034_ 0
C9082 _206_ _212_ 0.19565f
C9083 _230_ fanout35/a_40_152# 0.00268f
C9084 _555_/a_209_168# _313_ 0.02715f
C9085 _663_/a_324_432# VPWR 0.00627f
C9086 _372_/a_22_110# VPWR 0
C9087 net182 clknet_0_clk 0.034f
C9088 _643_/a_741_93# VPWR 0.0136f
C9089 tx_inst.data_reg\[7\] _656_/a_843_236# 0
C9090 net93 _287_ 0
C9091 FILLER_12_173/a_32_246# _041_ 0
C9092 hold103/a_56_118# baud_inst.counter\[19\] 0.09412f
C9093 _266_ _647_/a_1583_191# 0.00486f
C9094 hold144/a_326_118# VPWR 0.02333f
C9095 hold166/a_438_182# net29 0.00702f
C9096 VPWR _417_/a_120_432# 0.00142f
C9097 net141 _686_/a_1840_334# 0
C9098 _310_ _686_/a_1583_191# 0.00265f
C9099 _154_ _266_ 0.1382f
C9100 hold151/a_438_182# _256_ 0
C9101 _503_/a_165_412# net181 0.00102f
C9102 clknet_4_1_0_clk net6 0
C9103 _217_ _215_ 0.01039f
C9104 net39 _292_ 0.04679f
C9105 _099_ hold90/a_438_182# 0
C9106 rx_inst.bit_index\[2\] _255_ 0.00129f
C9107 net51 _084_ 0
C9108 clk _339_/a_1109_431# 0
C9109 rx_data[0] _128_ 0
C9110 net65 _264_ 0.02715f
C9111 baud_inst.counter\[18\] baud_inst.counter\[17\] 0.38503f
C9112 _134_ _158_ 0.03161f
C9113 FILLER_23_143/a_32_246# _236_ 0.00428f
C9114 net92 _092_ 0.02289f
C9115 hold161/a_56_118# _522_/a_209_168# 0.00174f
C9116 net16 hold81/a_56_118# 0
C9117 _642_/a_741_93# net25 0
C9118 net144 _160_ 0
C9119 _406_/a_154_118# net175 0.00186f
C9120 _182_ net29 1.21185f
C9121 hold99/a_438_182# net45 0
C9122 hold99/a_326_118# _111_ 0.00178f
C9123 tx_inst.data_reg\[5\] _063_ 0
C9124 hold101/a_326_118# _688_/a_741_93# 0.0011f
C9125 hold101/a_438_182# _688_/a_324_432# 0
C9126 _145_ _066_ 0.04625f
C9127 _678_/a_324_432# FILLER_6_98/a_40_246# 0
C9128 _048_ rx_inst.data_reg\[6\] 0
C9129 baud_inst.counter\[30\] hold59/a_326_118# 0.02493f
C9130 clk hold179/a_56_118# 0.01551f
C9131 net173 _142_ 0.00334f
C9132 baud_inst.counter\[13\] _035_ 0
C9133 _685_/a_1840_334# net29 0
C9134 net74 VPWR 0.15322f
C9135 net44 _301_ 0.1214f
C9136 _170_ _057_ 0
C9137 net54 _665_/a_843_236# 0.00398f
C9138 net44 _526_/a_248_122# 0
C9139 _305_ _695_/a_324_432# 0
C9140 net75 _695_/a_741_93# 0.00473f
C9141 _232_ clkbuf_4_14_0_clk/a_27_118# 0.00115f
C9142 _023_ _695_/a_38_114# 0
C9143 rx_inst.data_reg\[3\] _046_ 0.00921f
C9144 hold138/a_438_182# FILLER_19_228/a_40_246# 0
C9145 rx_inst.state\[2\] hold176/a_56_118# 0.00217f
C9146 VPWR FILLER_0_103/a_32_246# 0.0762f
C9147 clknet_4_5_0_clk _665_/a_1583_191# 0
C9148 _653_/a_741_93# VPWR 0.02524f
C9149 clknet_4_10_0_clk FILLER_24_4/a_40_246# 0
C9150 net78 _123_ 0
C9151 _165_ net46 0.01376f
C9152 baud_inst.counter\[15\] _100_ 0.01038f
C9153 _090_ _034_ 0.0012f
C9154 _022_ FILLER_21_31/a_40_246# 0.03231f
C9155 hold169/a_56_118# _274_ 0.08777f
C9156 net144 hold144/a_326_118# 0.0116f
C9157 _222_ _651_/a_324_432# 0
C9158 net56 _651_/a_843_236# 0.00374f
C9159 _141_ _651_/a_38_114# 0.00187f
C9160 input10/a_40_152# input8/a_40_152# 0
C9161 output13/a_40_152# net47 0.01354f
C9162 _243_ _255_ 0
C9163 _206_ _383_/a_46_156# 0.00858f
C9164 _676_/a_1583_191# _676_/a_2250_412# 0
C9165 _689_/a_741_93# net40 0.00213f
C9166 rx_inst.data_reg\[0\] _635_/a_324_432# 0
C9167 _491_/a_435_412# net60 0.00257f
C9168 _491_/a_192_429# _181_ 0.0197f
C9169 net182 _182_ 0
C9170 hold63/a_56_118# net122 0.00154f
C9171 _206_ _376_/a_272_160# -0
C9172 net55 _071_ 0.01546f
C9173 _516_/a_165_412# _292_ 0
C9174 FILLER_4_102/a_32_246# VPWR 0.06596f
C9175 _638_/a_1785_429# VPWR 0
C9176 FILLER_0_80/a_40_246# net40 0.00235f
C9177 net24 FILLER_25_163/a_32_246# 0
C9178 VPWR _384_/a_59_156# 0.01115f
C9179 _639_/a_2250_412# clknet_4_13_0_clk 0
C9180 net49 _421_/a_354_412# 0
C9181 hold55/a_326_118# hold55/a_438_182# 0
C9182 net72 _124_ 0.01697f
C9183 _031_ net106 0.00156f
C9184 _254_ FILLER_25_141/a_32_246# 0
C9185 _160_ _266_ 0.12066f
C9186 net79 _349_/a_248_122# 0
C9187 rx_inst.state\[3\] _667_/a_741_93# 0.00325f
C9188 net47 net24 0.00662f
C9189 FILLER_4_100/a_40_246# net159 0
C9190 baud_inst.counter\[19\] baud_inst.counter\[16\] 0.32712f
C9191 net89 _687_/a_38_114# 0.02602f
C9192 net55 FILLER_0_154/a_40_246# 0.0047f
C9193 _160_ _167_ 0
C9194 _230_ _132_ 0.0423f
C9195 _199_ _665_/a_298_337# 0.02573f
C9196 _547_/a_81_118# baud_inst.counter\[25\] 0.03021f
C9197 _547_/a_277_118# net99 0.00134f
C9198 _658_/a_1840_334# _388_/a_59_156# 0
C9199 net49 _435_/a_268_436# 0
C9200 _006_ _369_/a_248_122# 0
C9201 _228_ hold180/a_56_118# 0.00589f
C9202 _643_/a_1489_191# _273_ 0.00142f
C9203 fanout41/a_40_152# clknet_4_1_0_clk 0
C9204 _480_/a_22_110# VPWR 0.00906f
C9205 tx_inst.bit_index\[0\] net168 0.00332f
C9206 net49 _703_/a_550_127# 0
C9207 _177_ net49 0.00105f
C9208 _672_/a_741_93# hold60/a_438_182# 0
C9209 _672_/a_843_236# hold60/a_326_118# 0
C9210 _661_/a_298_337# tx_inst.data_reg\[1\] 0
C9211 _705_/a_681_505# net172 0
C9212 _431_/a_81_118# _435_/a_72_436# 0
C9213 net48 _044_ 0.84202f
C9214 _643_/a_741_93# _266_ 0
C9215 _675_/a_1583_191# _674_/a_324_432# 0
C9216 hold137/a_56_118# _659_/a_741_93# 0
C9217 _282_ hold92/a_438_182# 0.01402f
C9218 hold137/a_326_118# _659_/a_324_432# 0
C9219 _414_/a_279_412# net26 0.00432f
C9220 FILLER_16_154/a_32_246# net29 0.02407f
C9221 rx_data[4] rx_data[7] 0.04753f
C9222 net30 _417_/a_22_110# 0
C9223 _339_/a_1377_160# _653_/a_1583_191# 0
C9224 _652_/a_1583_191# VPWR 0.01345f
C9225 _095_ hold156/a_56_118# 0
C9226 baud_inst.counter\[13\] _688_/a_1840_334# 0
C9227 VPWR _684_/a_324_432# 0
C9228 _638_/a_324_432# _049_ 0.01383f
C9229 hold120/a_438_182# _694_/a_741_93# 0
C9230 hold120/a_326_118# _694_/a_843_236# 0
C9231 _674_/a_1840_334# FILLER_2_46/a_40_246# 0
C9232 fanout40/a_40_152# baud_inst.counter\[16\] 0
C9233 _167_ _417_/a_120_432# 0
C9234 _112_ _108_ 0
C9235 _359_/a_22_110# clknet_4_4_0_clk 0.00644f
C9236 _067_ FILLER_0_154/a_40_246# 0.00484f
C9237 _183_ clknet_4_2_0_clk 0
C9238 FILLER_24_218/a_40_246# _267_ 0.01108f
C9239 _657_/a_2002_114# clknet_4_4_0_clk 0
C9240 hold159/a_438_182# _655_/a_2250_412# 0.00887f
C9241 net41 _149_ 0.00392f
C9242 clknet_0_clk hold95/a_438_182# 0
C9243 FILLER_16_56/a_32_246# _520_/a_155_412# 0
C9244 net74 _266_ 0
C9245 _147_ net6 0
C9246 net84 _636_/a_298_337# 0
C9247 FILLER_1_173/a_32_246# net3 0
C9248 _378_/a_382_118# _655_/a_2250_412# 0
C9249 clknet_4_14_0_clk _633_/a_324_432# 0.01963f
C9250 _267_ _632_/a_298_337# 0
C9251 _043_ _638_/a_38_114# 0
C9252 _295_ _189_ 0.00849f
C9253 baud_inst.counter\[8\] FILLER_8_35/a_32_246# 0
C9254 _696_/a_1583_191# _180_ 0
C9255 net39 FILLER_12_106/a_40_246# 0.01103f
C9256 FILLER_14_202/a_40_246# _650_/a_843_236# 0
C9257 net48 net25 0.08338f
C9258 _699_/a_741_93# clknet_4_10_0_clk 0
C9259 hold55/a_438_182# _705_/a_843_236# 0
C9260 _068_ net137 0
C9261 net42 _278_ 0.01815f
C9262 net31 _244_ 0.00904f
C9263 _303_ FILLER_24_19/a_40_246# 0
C9264 hold75/a_326_118# _023_ 0
C9265 clknet_4_11_0_clk _051_ 0.00311f
C9266 _680_/a_38_114# FILLER_5_32/a_40_246# 0
C9267 hold103/a_438_182# VPWR 0.00835f
C9268 rx_inst.state\[2\] _002_ 0.01072f
C9269 net2 _459_/a_229_118# 0
C9270 net18 _273_ 0.00284f
C9271 hold69/a_438_182# net65 0
C9272 _673_/a_681_505# net181 0
C9273 _673_/a_843_236# net86 0.01693f
C9274 _400_/a_192_429# _221_ 0.00754f
C9275 _400_/a_155_160# net183 0
C9276 _485_/a_22_110# _278_ 0.01745f
C9277 net47 FILLER_27_210/a_40_246# 0.01596f
C9278 hold133/a_56_118# net45 0
C9279 _170_ _440_/a_244_412# 0.00308f
C9280 _448_/a_142_412# _232_ 0.00107f
C9281 _656_/a_38_114# net165 0.01146f
C9282 VPWR _087_ 0.33237f
C9283 hold96/a_438_182# baud_inst.counter\[6\] 0
C9284 _638_/a_612_127# net30 0.01208f
C9285 net123 baud_inst.counter\[13\] 0.01119f
C9286 _234_ clkbuf_4_6_0_clk/a_27_118# 0
C9287 _302_ _301_ 0.06387f
C9288 _168_ _650_/a_741_93# 0.01974f
C9289 net126 _049_ 0.01444f
C9290 hold136/a_56_118# _504_/a_209_168# 0
C9291 _189_ clknet_4_2_0_clk 0.02733f
C9292 rx_data[5] hold72/a_56_118# 0
C9293 clknet_4_14_0_clk _455_/a_155_412# 0.00138f
C9294 _313_ _165_ 0.02063f
C9295 net16 _636_/a_2250_412# 0
C9296 rx_data[4] _636_/a_1840_334# 0
C9297 _206_ _664_/a_1489_191# 0.01399f
C9298 baud_inst.counter\[16\] _297_ 0
C9299 _690_/a_298_337# _300_ 0.00386f
C9300 _690_/a_741_93# net101 0.02852f
C9301 _706_/a_612_127# _042_ 0
C9302 fanout47/a_40_152# FILLER_26_141/a_40_246# 0
C9303 clknet_4_6_0_clk net43 0.8722f
C9304 _661_/a_2002_114# net55 0
C9305 _022_ _693_/a_741_93# 0
C9306 net120 _693_/a_681_505# 0
C9307 _449_/a_27_156# net2 0.00223f
C9308 _074_ _654_/a_1840_334# 0
C9309 _662_/a_741_93# _120_ 0.00529f
C9310 _662_/a_843_236# net43 0
C9311 net102 _015_ 0.00126f
C9312 _638_/a_132_114# _154_ 0
C9313 net49 _438_/a_248_122# 0
C9314 _376_/a_76_160# _203_ 0
C9315 _182_ hold95/a_438_182# 0
C9316 _269_ clknet_4_13_0_clk 0.51017f
C9317 rx_data[5] net17 0.14876f
C9318 _493_/a_45_160# clknet_0_clk 0.01467f
C9319 hold122/a_326_118# VPWR 0.0065f
C9320 hold117/a_438_182# baud_inst.counter\[9\] 0
C9321 _518_/a_45_160# _296_ 0.00281f
C9322 _228_ _229_ 0.25796f
C9323 hold173/a_56_118# _219_ 0.00456f
C9324 hold173/a_326_118# _218_ 0.00633f
C9325 hold173/a_438_182# _217_ 0.0037f
C9326 _677_/a_298_337# _034_ 0
C9327 net154 _676_/a_298_337# 0
C9328 _641_/a_298_337# _052_ 0.04009f
C9329 _218_ net43 0
C9330 clkbuf_4_5_0_clk/a_27_118# _479_/a_22_110# 0.01531f
C9331 baud_inst.counter\[28\] _699_/a_843_236# 0.00208f
C9332 _360_/a_308_118# VPWR 0
C9333 net27 _369_/a_146_122# 0.00103f
C9334 _635_/a_681_505# clknet_0_clk 0
C9335 net145 _659_/a_1840_334# 0.00279f
C9336 _113_ _702_/a_741_93# 0.00244f
C9337 clknet_4_1_0_clk _287_ 0.02211f
C9338 net156 _294_ 0
C9339 net122 clknet_0_clk 0.00287f
C9340 _250_ net25 0.12725f
C9341 _283_ hold92/a_56_118# 0.03492f
C9342 net92 hold92/a_326_118# 0.00419f
C9343 _513_/a_341_118# _163_ 0.00176f
C9344 _277_ rx_inst.state\[4\] 0.38867f
C9345 FILLER_8_21/a_32_246# net116 0
C9346 _511_/a_252_412# VPWR 0
C9347 _663_/a_2250_412# VPWR 0.00632f
C9348 tx_inst.data_reg\[7\] _656_/a_612_127# 0
C9349 fanout41/a_40_152# _147_ 0
C9350 _227_ _234_ 0
C9351 _643_/a_1785_429# VPWR 0
C9352 _379_/a_46_156# tx_inst.data_reg\[2\] 0.02085f
C9353 _379_/a_268_412# clknet_4_4_0_clk 0
C9354 hold147/a_438_182# net147 0.0209f
C9355 _547_/a_81_118# baud_inst.counter\[24\] 0.02728f
C9356 _266_ _647_/a_2002_114# 0
C9357 net14 rx_data[6] 0
C9358 VPWR _140_ 0.05035f
C9359 _037_ net181 0.01856f
C9360 net12 _267_ 0.00403f
C9361 baud_inst.counter\[26\] hold142/a_56_118# 0.00617f
C9362 net71 hold71/a_326_118# 0
C9363 baud_inst.counter\[21\] FILLER_22_32/a_40_246# 0.05037f
C9364 net33 FILLER_8_238/a_32_246# 0
C9365 net48 FILLER_21_194/a_32_246# 0
C9366 net55 FILLER_0_130/a_32_246# 0.00156f
C9367 net13 _634_/a_843_236# 0
C9368 net31 clknet_4_14_0_clk 0.54324f
C9369 hold161/a_326_118# net160 0.01132f
C9370 hold161/a_56_118# _296_ 0.0155f
C9371 hold77/a_326_118# _264_ 0.02941f
C9372 _556_/a_155_160# net49 0
C9373 _064_ _386_/a_285_412# 0
C9374 _195_ _396_/a_155_412# 0.05614f
C9375 _234_ hold62/a_438_182# 0
C9376 net128 FILLER_13_89/a_40_246# 0.04225f
C9377 net16 _157_ 0
C9378 hold155/a_326_118# _657_/a_324_432# 0
C9379 hold155/a_56_118# _657_/a_741_93# 0.00119f
C9380 _010_ _683_/a_741_93# 0.0012f
C9381 _292_ _683_/a_843_236# 0.06134f
C9382 net42 FILLER_12_171/a_40_246# 0.01358f
C9383 _674_/a_843_236# net38 0.0015f
C9384 _493_/a_45_160# _182_ 0.03953f
C9385 _294_ _180_ 0.02027f
C9386 hold126/a_326_118# VPWR 0.00424f
C9387 net7 _210_ 0.0211f
C9388 _188_ _355_/a_354_412# 0
C9389 hold99/a_438_182# FILLER_21_96/a_40_246# 0.00941f
C9390 output18/a_40_152# _637_/a_1583_191# 0
C9391 _343_/a_257_140# VPWR 0
C9392 _281_ _685_/a_324_432# 0
C9393 _443_/a_252_412# net24 0
C9394 net49 VPWR 3.05129f
C9395 FILLER_1_173/a_32_246# _150_ 0.03154f
C9396 net43 net29 0.03903f
C9397 fanout31/a_40_152# fanout32/a_40_152# 0.0018f
C9398 _680_/a_298_337# _681_/a_1583_191# 0
C9399 _093_ FILLER_6_21/a_40_246# 0.00208f
C9400 tx_inst.bit_index\[1\] _339_/a_886_118# 0.03828f
C9401 _670_/a_741_93# clknet_0_clk 0.00417f
C9402 net56 _651_/a_612_127# 0.00199f
C9403 _226_ _002_ 0
C9404 _430_/a_170_412# _249_ 0
C9405 net2 FILLER_23_143/a_32_246# 0
C9406 tx_data[7] net8 0.14371f
C9407 _684_/a_1583_191# _297_ 0
C9408 hold74/a_438_182# net74 0
C9409 _305_ net107 0
C9410 _046_ _043_ 0.00324f
C9411 baud_inst.counter\[20\] _022_ 0.58432f
C9412 net155 _210_ 0.00313f
C9413 _194_ _364_/a_155_412# 0
C9414 FILLER_7_40/a_32_246# net116 0
C9415 _679_/a_741_93# FILLER_8_70/a_32_246# 0
C9416 _286_ _502_/a_279_412# 0.00688f
C9417 _689_/a_1785_429# net40 0
C9418 hold173/a_56_118# tx_inst.bit_index\[2\] 0.02524f
C9419 hold110/a_56_118# _683_/a_612_127# 0
C9420 _260_ _224_ -0
C9421 clknet_4_3_0_clk _676_/a_298_337# 0.04664f
C9422 FILLER_8_70/a_32_246# _683_/a_1583_191# 0
C9423 _012_ _292_ 0.0297f
C9424 hold167/a_438_182# _669_/a_324_432# 0
C9425 _050_ net81 0.17841f
C9426 hold167/a_326_118# _669_/a_741_93# 0.0011f
C9427 hold167/a_56_118# _669_/a_843_236# 0.00232f
C9428 _410_/a_155_412# net28 0
C9429 _306_ _692_/a_2250_412# 0
C9430 _633_/a_843_236# _264_ 0
C9431 net73 rx_inst.data_reg\[4\] 0
C9432 net48 _139_ 0
C9433 FILLER_16_176/a_40_246# _235_ 0.00507f
C9434 FILLER_12_46/a_32_246# VPWR 0.06823f
C9435 net49 _239_ 0.00112f
C9436 hold174/a_438_182# _197_ 0.00483f
C9437 _202_ _664_/a_1489_191# 0
C9438 net147 _693_/a_298_337# 0
C9439 _693_/a_298_337# net46 0.00931f
C9440 rx_inst.bit_index\[1\] _642_/a_2250_412# 0
C9441 net44 net90 0
C9442 FILLER_25_177/a_40_246# net49 0.02151f
C9443 net112 net24 0.08039f
C9444 net27 _666_/a_741_93# 0.00162f
C9445 _241_ net30 0
C9446 hold131/a_56_118# net30 0
C9447 _138_ _154_ 0
C9448 _699_/a_1583_191# _703_/a_38_114# 0
C9449 net53 _698_/a_298_337# 0.01842f
C9450 clknet_4_11_0_clk _698_/a_324_432# 0.00599f
C9451 clknet_4_13_0_clk _153_ 0.07885f
C9452 fanout33/a_40_152# _200_ 0
C9453 _163_ _186_ 0
C9454 net31 hold132/a_56_118# 0
C9455 tx_inst.data_reg\[4\] _661_/a_843_236# 0
C9456 _659_/a_324_432# _657_/a_741_93# 0
C9457 _659_/a_741_93# _657_/a_324_432# 0
C9458 hold126/a_56_118# _638_/a_298_337# 0
C9459 _232_ _154_ 0.19246f
C9460 net100 _697_/a_298_337# 0
C9461 _639_/a_132_114# net80 0
C9462 net47 net30 0.07151f
C9463 _094_ _681_/a_298_337# 0.02146f
C9464 net57 hold122/a_56_118# 0
C9465 hold57/a_326_118# _041_ 0
C9466 _701_/a_741_93# net107 0
C9467 _145_ FILLER_2_79/a_40_246# 0
C9468 VPWR _525_/a_268_412# 0
C9469 net35 _435_/a_166_436# 0
C9470 hold126/a_326_118# _127_ 0.01387f
C9471 hold68/a_326_118# _115_ 0.00135f
C9472 _643_/a_1785_429# _266_ 0
C9473 hold140/a_438_182# baud_inst.counter\[25\] 0.01562f
C9474 _675_/a_2250_412# _674_/a_1583_191# 0
C9475 _675_/a_1489_191# _674_/a_741_93# 0
C9476 _081_ _668_/a_843_236# 0.00114f
C9477 _073_ clknet_0_clk 0.00447f
C9478 _678_/a_1840_334# net152 0
C9479 hold130/a_326_118# net29 0.0335f
C9480 VPWR _684_/a_2250_412# 0.00298f
C9481 _671_/a_681_505# net29 0
C9482 FILLER_15_89/a_32_246# _686_/a_1583_191# 0
C9483 _233_ _227_ 0
C9484 net75 net120 0.00347f
C9485 net106 _313_ 0.01145f
C9486 tx_data[0] FILLER_0_156/a_32_246# 0
C9487 _510_/a_146_122# net116 0
C9488 _045_ _124_ 0.03404f
C9489 _677_/a_324_432# net154 0.00304f
C9490 _017_ hold104/a_326_118# 0
C9491 hold102/a_56_118# net104 0
C9492 _294_ baud_inst.counter\[11\] 0
C9493 _167_ _140_ 0.07983f
C9494 net48 _648_/a_38_114# 0.04311f
C9495 clknet_4_1_0_clk clkbuf_4_0_0_clk/a_27_118# 0
C9496 baud_inst.counter\[6\] _382_/a_559_412# 0
C9497 hold169/a_438_182# VPWR 0.0155f
C9498 net42 _671_/a_38_114# 0
C9499 net26 _076_ 0
C9500 clknet_4_5_0_clk _203_ 0
C9501 _638_/a_741_93# _638_/a_1489_191# -0
C9502 net55 _388_/a_59_156# 0.04144f
C9503 FILLER_16_56/a_32_246# _297_ 0
C9504 _013_ hold90/a_56_118# 0
C9505 _517_/a_380_412# net90 -0
C9506 net141 _687_/a_2250_412# 0
C9507 _644_/a_324_432# VPWR 0
C9508 _181_ _088_ 0
C9509 _678_/a_38_114# _035_ 0
C9510 _174_ _656_/a_2250_412# 0
C9511 _073_ _077_ 0.00549f
C9512 hold128/a_56_118# VPWR 0.02118f
C9513 hold126/a_326_118# _266_ 0.00509f
C9514 hold126/a_438_182# net30 0.00702f
C9515 hold142/a_56_118# _109_ 0
C9516 _206_ _655_/a_2250_412# 0.02279f
C9517 _288_ _182_ 0
C9518 clknet_4_14_0_clk _633_/a_2250_412# 0
C9519 net35 net24 0.40543f
C9520 _043_ _638_/a_1840_334# 0
C9521 net178 baud_inst.counter\[13\] 0
C9522 _233_ hold62/a_438_182# 0
C9523 baud_inst.counter\[20\] _108_ 0.0799f
C9524 net43 _668_/a_1583_191# 0
C9525 baud_inst.counter\[14\] hold90/a_56_118# 0.0161f
C9526 _694_/a_298_337# clknet_4_10_0_clk 0.0144f
C9527 _527_/a_192_429# baud_inst.counter\[17\] 0.00326f
C9528 _029_ _552_/a_155_412# 0.00216f
C9529 _360_/a_71_118# clk 0.00354f
C9530 hold125/a_438_182# _138_ 0.0015f
C9531 _232_ fanout36/a_40_152# 0
C9532 _653_/a_741_93# _652_/a_741_93# 0
C9533 _653_/a_324_432# _652_/a_843_236# 0
C9534 _645_/a_38_114# VPWR 0
C9535 net49 _167_ 0.00139f
C9536 net55 _706_/a_681_505# 0
C9537 tx_inst.data_reg\[6\] _360_/a_1023_118# 0
C9538 _180_ net113 0
C9539 hold157/a_326_118# clknet_4_8_0_clk 0
C9540 hold150/a_438_182# hold131/a_438_182# 0
C9541 hold125/a_438_182# _232_ 0.00152f
C9542 hold112/a_326_118# _258_ 0.01022f
C9543 FILLER_19_132/a_40_246# _642_/a_1840_334# 0
C9544 _679_/a_741_93# _183_ 0
C9545 net152 net29 0.0022f
C9546 hold63/a_438_182# FILLER_13_137/a_32_246# 0.00985f
C9547 _707_/a_324_432# _668_/a_2250_412# 0
C9548 hold87/a_326_118# _517_/a_209_168# 0.00262f
C9549 _673_/a_612_127# net86 0
C9550 _673_/a_550_127# net181 0
C9551 net52 _263_ 0.02791f
C9552 _160_ _232_ 0
C9553 _225_ net49 0.22163f
C9554 _656_/a_132_114# _146_ 0
C9555 _488_/a_380_412# _181_ 0
C9556 net70 net30 0.37552f
C9557 rx_inst.bit_index\[2\] _424_/a_244_412# 0
C9558 net32 _158_ 0
C9559 _489_/a_115_308# VPWR 0.0071f
C9560 _183_ _683_/a_1583_191# 0
C9561 hold75/a_56_118# _695_/a_741_93# 0
C9562 hold75/a_326_118# _695_/a_324_432# 0
C9563 hold136/a_56_118# _287_ 0
C9564 FILLER_11_32/a_32_246# _682_/a_843_236# 0
C9565 clknet_4_14_0_clk _130_ 0.00464f
C9566 _689_/a_2250_412# _682_/a_843_236# 0
C9567 _103_ net103 0.00149f
C9568 _206_ tx_inst.state\[2\] 0.56485f
C9569 _443_/a_150_412# VPWR 0
C9570 net111 _474_/a_22_110# 0.00126f
C9571 net22 hold50/a_326_118# 0.00172f
C9572 net37 output19/a_40_152# 0
C9573 VPWR _681_/a_324_432# 0.02651f
C9574 _673_/a_298_337# _655_/a_298_337# 0
C9575 clknet_4_12_0_clk _649_/a_1489_191# 0
C9576 net52 _237_ 0
C9577 _536_/a_192_429# net149 0
C9578 _498_/a_165_412# net29 0
C9579 _696_/a_324_432# net46 0.03245f
C9580 _206_ FILLER_0_174/a_32_246# 0
C9581 net33 _706_/a_1489_191# 0
C9582 _114_ hold120/a_438_182# 0
C9583 net28 hold180/a_56_118# 0
C9584 _643_/a_1840_334# FILLER_23_204/a_40_246# 0.00102f
C9585 _048_ hold70/a_56_118# 0
C9586 _643_/a_132_114# _160_ 0
C9587 hold182/a_56_118# hold152/a_438_182# 0
C9588 hold63/a_326_118# net63 0.00121f
C9589 _205_ _667_/a_741_93# 0.00213f
C9590 hold144/a_56_118# _133_ 0
C9591 baud_inst.counter\[27\] hold162/a_56_118# 0
C9592 tx_inst.data_reg\[1\] _148_ 0
C9593 _641_/a_1583_191# _052_ 0
C9594 _641_/a_132_114# net176 0
C9595 clk input9/a_40_152# 0.00282f
C9596 _117_ _704_/a_681_505# 0
C9597 _168_ _456_/a_257_140# 0.00136f
C9598 net182 net152 0.00142f
C9599 rx_inst.data_reg\[7\] net80 0
C9600 baud_inst.counter\[30\] _699_/a_2250_412# 0
C9601 _179_ _699_/a_1840_334# 0
C9602 tx_done net50 0
C9603 clknet_4_3_0_clk _677_/a_324_432# 0.03736f
C9604 VPWR _649_/a_38_114# 0.01862f
C9605 _662_/a_38_114# _654_/a_1840_334# 0
C9606 _662_/a_324_432# _654_/a_1583_191# 0
C9607 net131 VPWR 0.0306f
C9608 net94 _673_/a_298_337# 0
C9609 _024_ _542_/a_155_412# 0.00371f
C9610 _696_/a_1489_191# baud_inst.counter\[24\] 0
C9611 _696_/a_612_127# _309_ 0
C9612 net34 _398_/a_358_436# 0.01383f
C9613 _513_/a_192_429# _684_/a_1840_334# 0
C9614 _163_ _684_/a_324_432# 0.03358f
C9615 _283_ _678_/a_843_236# 0
C9616 _189_ _683_/a_1583_191# 0
C9617 hold158/a_56_118# _522_/a_209_168# 0
C9618 hold159/a_326_118# VPWR 0.0135f
C9619 net41 clknet_0_clk 0.0433f
C9620 rx_inst.state\[3\] _670_/a_1840_334# 0
C9621 _278_ _670_/a_1583_191# 0
C9622 net113 net140 0
C9623 _257_ _435_/a_72_436# 0
C9624 _045_ net82 0.00324f
C9625 _198_ _706_/a_38_114# 0
C9626 FILLER_8_14/a_32_246# _288_ 0
C9627 net55 net50 0.00112f
C9628 _305_ _533_/a_146_122# 0
C9629 _378_/a_59_156# VPWR 0.00777f
C9630 hold110/a_56_118# net109 0
C9631 fanout42/a_40_152# net43 0.04939f
C9632 _189_ FILLER_14_70/a_40_246# 0
C9633 FILLER_19_178/a_40_246# _136_ 0.01902f
C9634 _545_/a_350_122# _311_ -0
C9635 _653_/a_843_236# _221_ 0
C9636 _073_ hold146/a_56_118# 0
C9637 _514_/a_155_412# net40 0.00242f
C9638 hold76/a_326_118# _022_ 0
C9639 clk _172_ 0.01469f
C9640 _660_/a_324_432# FILLER_2_183/a_32_246# 0
C9641 _117_ _707_/a_324_432# 0
C9642 clknet_4_11_0_clk _699_/a_1583_191# 0
C9643 hold121/a_56_118# VPWR 0.05942f
C9644 net42 _081_ 0.01136f
C9645 _053_ net25 0
C9646 _647_/a_132_114# net139 0
C9647 _173_ clkbuf_4_4_0_clk/a_27_118# 0.00101f
C9648 _292_ _683_/a_612_127# 0.0065f
C9649 _674_/a_612_127# net38 0
C9650 _117_ tx_inst.state\[4\] 0
C9651 VPWR _651_/a_298_337# 0
C9652 _662_/a_324_432# clknet_4_5_0_clk 0.00638f
C9653 _517_/a_209_168# _296_ 0
C9654 hold68/a_326_118# hold105/a_56_118# 0.00189f
C9655 _637_/a_298_337# _264_ 0
C9656 hold68/a_56_118# hold105/a_326_118# 0.00189f
C9657 _254_ net24 0.31267f
C9658 VPWR _490_/a_45_160# 0.00833f
C9659 hold110/a_56_118# net110 0
C9660 _170_ FILLER_26_141/a_40_246# 0
C9661 _643_/a_2250_412# _049_ 0
C9662 hold138/a_56_118# rx_inst.data_reg\[4\] 0.01262f
C9663 _112_ hold114/a_438_182# 0
C9664 VPWR _665_/a_843_236# 0.00421f
C9665 _670_/a_1785_429# clknet_0_clk 0
C9666 net3 _654_/a_38_114# 0
C9667 net41 _386_/a_59_156# 0.10728f
C9668 _673_/a_843_236# net38 0.01758f
C9669 _686_/a_741_93# hold90/a_56_118# 0.00785f
C9670 _686_/a_324_432# hold90/a_326_118# 0
C9671 _464_/a_22_110# _649_/a_1583_191# 0
C9672 FILLER_14_72/a_32_246# _182_ 0
C9673 rx_inst.state\[2\] FILLER_17_131/a_32_246# 0
C9674 FILLER_16_221/a_32_246# _047_ 0
C9675 VPWR _166_ 0.60906f
C9676 _486_/a_358_436# net49 0.00147f
C9677 FILLER_24_218/a_40_246# net71 0
C9678 net55 _367_/a_170_412# 0
C9679 _194_ _197_ 0.02464f
C9680 net26 _666_/a_681_505# 0.00151f
C9681 FILLER_17_81/a_32_246# VPWR 0.06374f
C9682 net110 _683_/a_550_127# 0
C9683 hold110/a_326_118# _096_ 0.00979f
C9684 _555_/a_380_412# _314_ 0.00104f
C9685 clknet_4_3_0_clk _676_/a_1583_191# 0.00133f
C9686 _098_ _189_ 0
C9687 net48 hold119/a_438_182# 0
C9688 _702_/a_38_114# _700_/a_843_236# 0
C9689 baud_inst.counter\[27\] net141 0.0031f
C9690 hold75/a_326_118# hold75/a_438_182# 0
C9691 tx_data[6] net9 0.00781f
C9692 _679_/a_324_432# baud_inst.counter\[7\] 0
C9693 hold184/a_326_118# clknet_4_4_0_clk 0
C9694 _679_/a_741_93# clknet_4_3_0_clk 0.02958f
C9695 _519_/a_277_118# clknet_0_clk 0.00199f
C9696 net167 _669_/a_681_505# 0
C9697 _229_ net28 0.06791f
C9698 _643_/a_1840_334# _043_ 0
C9699 hold88/a_326_118# clknet_0_clk 0.04211f
C9700 FILLER_4_172/a_32_246# net54 0
C9701 _217_ net56 0.05822f
C9702 net122 net43 1.85779f
C9703 hold174/a_326_118# VPWR 0.01168f
C9704 _306_ _687_/a_38_114# 0
C9705 hold55/a_438_182# output23/a_40_152# 0
C9706 hold126/a_56_118# _049_ 0
C9707 hold150/a_56_118# _644_/a_1583_191# 0
C9708 hold59/a_438_182# VPWR 0.01187f
C9709 net2 _236_ 0.10231f
C9710 _202_ tx_inst.state\[2\] 0.10759f
C9711 _100_ _687_/a_741_93# 0.00164f
C9712 _420_/a_248_122# net24 0
C9713 net147 _693_/a_1583_191# 0
C9714 net124 hold72/a_326_118# 0
C9715 _693_/a_1583_191# net46 0.01178f
C9716 _260_ FILLER_19_139/a_40_246# 0
C9717 baud_inst.counter\[26\] _699_/a_843_236# 0
C9718 _266_ _649_/a_38_114# 0
C9719 net30 _649_/a_324_432# 0
C9720 _177_ _699_/a_741_93# 0.00705f
C9721 net53 _698_/a_1583_191# 0
C9722 clknet_4_11_0_clk _698_/a_2250_412# 0
C9723 hold100/a_56_118# _546_/a_192_429# 0.00157f
C9724 tx_data[0] _212_ 0.0151f
C9725 net3 net5 0
C9726 _658_/a_1489_191# net165 0.01759f
C9727 clknet_4_0_0_clk _504_/a_209_168# 0.00148f
C9728 net27 clkbuf_4_5_0_clk/a_27_118# 0.01635f
C9729 _216_ fanout34/a_40_152# 0
C9730 hold76/a_326_118# _108_ 0.01318f
C9731 FILLER_5_156/a_32_246# _172_ 0.01715f
C9732 net100 _697_/a_1583_191# 0
C9733 hold100/a_438_182# _697_/a_612_127# 0
C9734 _050_ hold80/a_438_182# 0.00185f
C9735 net81 hold80/a_326_118# 0.00428f
C9736 _206_ _390_/a_559_412# 0
C9737 clknet_4_0_0_clk hold60/a_56_118# 0.00478f
C9738 hold124/a_438_182# net71 0.00229f
C9739 _254_ _438_/a_146_122# 0
C9740 _178_ _699_/a_38_114# 0.00588f
C9741 _081_ _668_/a_612_127# 0
C9742 rx_inst.state\[2\] _669_/a_1583_191# 0.00216f
C9743 _282_ hold95/a_56_118# 0
C9744 _678_/a_1489_191# _282_ 0.00135f
C9745 baud_inst.counter\[4\] hold95/a_326_118# 0.00108f
C9746 _158_ FILLER_25_150/a_32_246# 0
C9747 tx_inst.bit_index\[1\] net57 0
C9748 hold120/a_438_182# _107_ 0
C9749 clknet_0_clk _454_/a_155_412# 0
C9750 hold139/a_326_118# _223_ 0.00384f
C9751 net71 _271_ 0
C9752 _512_/a_279_412# _183_ 0
C9753 _374_/a_142_412# _667_/a_741_93# 0
C9754 net103 _687_/a_298_337# 0.00116f
C9755 _643_/a_1489_191# _154_ 0
C9756 hold135/a_56_118# clknet_4_0_0_clk 0.03409f
C9757 net120 _532_/a_155_412# 0
C9758 _704_/a_38_114# rx_inst.state\[1\] 0
C9759 _451_/a_155_412# net25 0.00359f
C9760 hold116/a_438_182# _682_/a_1583_191# 0
C9761 _658_/a_2250_412# _656_/a_324_432# 0.00228f
C9762 _395_/a_146_122# net27 0.00626f
C9763 _644_/a_2250_412# VPWR 0.00747f
C9764 net49 _428_/a_252_412# 0
C9765 FILLER_8_19/a_40_246# _681_/a_38_114# 0
C9766 baud_inst.counter\[13\] _297_ 0
C9767 _342_/a_170_412# tx_inst.data_reg\[2\] 0
C9768 _680_/a_1583_191# _279_ 0
C9769 _518_/a_45_160# _294_ 0.00113f
C9770 _202_ _197_ 0
C9771 _357_/a_354_412# _180_ 0
C9772 baud_inst.counter\[17\] _526_/a_350_122# 0.00309f
C9773 net128 _685_/a_741_93# 0.00471f
C9774 _650_/a_843_236# net19 0
C9775 _690_/a_1583_191# net160 0
C9776 _694_/a_1583_191# clknet_4_10_0_clk 0.02297f
C9777 _659_/a_298_337# _070_ 0.02632f
C9778 net108 _682_/a_1840_334# 0
C9779 net97 _682_/a_1583_191# 0.00233f
C9780 _098_ clknet_4_3_0_clk 0
C9781 net67 _700_/a_1583_191# 0
C9782 hold68/a_56_118# _701_/a_2250_412# 0
C9783 _029_ _315_ 0.00107f
C9784 _699_/a_1583_191# hold113/a_326_118# 0.00263f
C9785 _545_/a_248_122# _309_ 0
C9786 _403_/a_120_432# _220_ 0.00295f
C9787 _222_ _401_/a_120_432# 0.00128f
C9788 net23 _705_/a_324_432# 0.0017f
C9789 hold55/a_56_118# net22 0.004f
C9790 hold139/a_326_118# _240_ 0
C9791 _644_/a_298_337# _236_ 0
C9792 _653_/a_843_236# _652_/a_2250_412# 0
C9793 hold110/a_438_182# _183_ 0
C9794 _645_/a_1840_334# VPWR 0
C9795 VPWR FILLER_24_4/a_40_246# 0.15754f
C9796 _046_ net15 0
C9797 net151 _253_ 0.00264f
C9798 baud_inst.counter\[27\] _698_/a_1583_191# 0.00139f
C9799 _660_/a_324_432# _071_ 0.04761f
C9800 _660_/a_741_93# net41 0.00135f
C9801 net55 _706_/a_550_127# 0
C9802 _432_/a_350_122# clknet_0_clk 0
C9803 _695_/a_1583_191# FILLER_19_55/a_40_246# 0
C9804 hold76/a_438_182# net76 0
C9805 hold103/a_56_118# baud_inst.counter\[16\] 0
C9806 _270_ VPWR 0.26905f
C9807 clkbuf_4_10_0_clk/a_27_118# _112_ 0.02016f
C9808 hold178/a_438_182# hold109/a_56_118# 0
C9809 _483_/a_22_110# net28 0.01959f
C9810 _483_/a_120_432# _277_ 0.00221f
C9811 FILLER_21_31/a_40_246# _302_ 0
C9812 hold134/a_326_118# _028_ 0.0185f
C9813 clknet_4_1_0_clk net181 0.07747f
C9814 net62 rx_inst.state\[4\] 0.03119f
C9815 net51 _668_/a_298_337# 0.01151f
C9816 net34 _076_ 0.01343f
C9817 _132_ net180 0
C9818 _168_ _061_ 0.26333f
C9819 net136 _038_ 0.01137f
C9820 _203_ _199_ 0.00227f
C9821 net55 _705_/a_38_114# 0
C9822 _226_ FILLER_17_131/a_32_246# 0.01714f
C9823 FILLER_4_102/a_32_246# clkbuf_4_1_0_clk/a_27_118# 0
C9824 hold56/a_56_118# _666_/a_298_337# 0
C9825 _689_/a_38_114# clknet_4_2_0_clk 0.00288f
C9826 _103_ net101 0.0989f
C9827 hold87/a_326_118# baud_inst.counter\[15\] 0.01597f
C9828 _180_ baud_inst.counter\[29\] 0.01661f
C9829 _661_/a_1840_334# FILLER_0_128/a_40_246# 0
C9830 _064_ _282_ 0.00325f
C9831 _143_ baud_inst.counter\[6\] 0
C9832 _117_ FILLER_7_210/a_40_246# 0
C9833 net156 _096_ 0
C9834 _654_/a_741_93# net170 0
C9835 VPWR _681_/a_2250_412# 0.0061f
C9836 hold85/a_326_118# clkbuf_4_13_0_clk/a_27_118# 0.00459f
C9837 _673_/a_132_114# _655_/a_38_114# 0
C9838 _673_/a_38_114# _655_/a_132_114# 0
C9839 hold90/a_326_118# clknet_4_9_0_clk 0.04787f
C9840 _035_ net29 0.00517f
C9841 _423_/a_279_412# _241_ 0.0024f
C9842 _696_/a_2250_412# net46 0.03338f
C9843 net33 _042_ 0.0039f
C9844 _282_ net40 0.02447f
C9845 _073_ net43 0.06643f
C9846 _041_ _372_/a_120_432# 0.00478f
C9847 _643_/a_1489_191# _160_ 0.00485f
C9848 _248_ _224_ 0
C9849 _659_/a_38_114# clknet_4_1_0_clk 0.0054f
C9850 hold96/a_326_118# _183_ 0
C9851 _691_/a_38_114# _105_ 0
C9852 net39 _685_/a_843_236# 0
C9853 rx_inst.state\[1\] hold51/a_56_118# 0.04502f
C9854 hold87/a_438_182# _294_ 0
C9855 clknet_4_3_0_clk _677_/a_2250_412# 0.01518f
C9856 net39 _689_/a_843_236# 0.01065f
C9857 net109 _292_ 0.23606f
C9858 baud_inst.counter\[28\] net114 0.00139f
C9859 VPWR _649_/a_1840_334# 0.00267f
C9860 _217_ _476_/a_248_122# 0.00179f
C9861 net51 clknet_4_6_0_clk 0.16416f
C9862 _697_/a_298_337# _696_/a_1583_191# 0
C9863 _314_ _702_/a_38_114# 0
C9864 hold99/a_326_118# _698_/a_741_93# 0.00432f
C9865 hold99/a_438_182# _698_/a_324_432# 0
C9866 _155_ _128_ 0.0019f
C9867 clk _653_/a_1840_334# 0.02675f
C9868 hold154/a_56_118# VPWR 0
C9869 _113_ _115_ 0.02577f
C9870 _171_ clknet_0_clk 0.36733f
C9871 _024_ _309_ 0.10941f
C9872 FILLER_19_75/a_40_246# baud_inst.counter\[25\] 0
C9873 _073_ _664_/a_324_432# 0.00259f
C9874 _402_/a_154_118# _142_ 0
C9875 FILLER_20_57/a_32_246# _296_ 0.01363f
C9876 _643_/a_843_236# _054_ 0.00161f
C9877 _643_/a_681_505# net47 0
C9878 hold110/a_438_182# net115 0
C9879 net34 _143_ 0
C9880 _705_/a_741_93# net22 0.01994f
C9881 output19/a_40_152# _650_/a_1583_191# 0.00232f
C9882 _652_/a_298_337# _063_ 0.00318f
C9883 hold121/a_438_182# _106_ 0
C9884 _163_ _684_/a_2250_412# 0
C9885 _684_/a_741_93# _684_/a_843_236# 0
C9886 _170_ clknet_0_clk 0.10988f
C9887 _420_/a_146_122# VPWR 0
C9888 net94 hold95/a_56_118# 0.00218f
C9889 clknet_4_5_0_clk FILLER_6_191/a_32_246# 0.00388f
C9890 net92 _678_/a_550_127# 0
C9891 hold158/a_326_118# net160 0
C9892 hold158/a_56_118# _296_ 0
C9893 _168_ _433_/a_142_412# 0
C9894 net182 _035_ 0
C9895 _121_ FILLER_12_208/a_32_246# 0.00153f
C9896 hold182/a_56_118# net123 0.03367f
C9897 hold160/a_56_118# net156 0.01052f
C9898 clk net2 0.05553f
C9899 _138_ net49 0.00689f
C9900 tx_inst.bit_index\[2\] hold165/a_56_118# 0
C9901 net32 FILLER_18_158/a_40_246# 0.01717f
C9902 _305_ _304_ 0
C9903 _023_ net147 0.00183f
C9904 _023_ net46 0
C9905 _677_/a_324_432# baud_inst.counter\[5\] 0
C9906 _672_/a_38_114# FILLER_2_46/a_40_246# 0
C9907 net110 _292_ 0.0099f
C9908 hold182/a_326_118# _191_ 0.01865f
C9909 _232_ net49 0.72705f
C9910 _230_ _260_ 0.03181f
C9911 _653_/a_1489_191# net183 0
C9912 output22/a_40_152# net50 0
C9913 _293_ net40 0.01902f
C9914 _679_/a_298_337# net135 0
C9915 _171_ _077_ 0
C9916 net13 net83 0
C9917 net85 _636_/a_1583_191# 0.0013f
C9918 hold85/a_56_118# _636_/a_1489_191# 0
C9919 clknet_0_clk hold62/a_56_118# 0.00449f
C9920 net135 _683_/a_843_236# 0
C9921 net11 FILLER_7_210/a_40_246# 0
C9922 _287_ _683_/a_741_93# 0
C9923 hold117/a_326_118# _288_ 0.0085f
C9924 hold117/a_56_118# net116 0.01777f
C9925 _127_ _634_/a_1489_191# 0
C9926 _044_ FILLER_29_179/a_40_246# 0
C9927 _424_/a_142_412# clkbuf_4_14_0_clk/a_27_118# 0
C9928 _239_ _420_/a_146_122# 0.00247f
C9929 hold75/a_56_118# net120 0
C9930 _670_/a_324_432# baud_inst.counter\[4\] 0
C9931 _439_/a_150_412# _161_ 0.00872f
C9932 _699_/a_741_93# VPWR 0.0167f
C9933 _010_ _096_ 0.001f
C9934 hold166/a_326_118# net26 0.04096f
C9935 net44 baud_inst.counter\[20\] 0.26465f
C9936 _230_ _252_ 0
C9937 _030_ net38 0.13309f
C9938 _019_ _066_ 0
C9939 hold96/a_326_118# net115 0
C9940 VPWR _651_/a_1583_191# 0.01289f
C9941 net55 FILLER_0_117/a_32_246# 0.00318f
C9942 _662_/a_2250_412# clknet_4_5_0_clk 0
C9943 hold130/a_56_118# net90 0.00131f
C9944 _227_ hold166/a_56_118# 0
C9945 _125_ net30 0.50341f
C9946 _270_ _266_ 0.07475f
C9947 _637_/a_1583_191# _264_ 0
C9948 hold143/a_56_118# _635_/a_132_114# 0
C9949 _070_ _385_/a_46_156# 0
C9950 _494_/a_279_412# clknet_0_clk 0
C9951 VPWR _665_/a_612_127# 0
C9952 _246_ _450_/a_127_436# 0
C9953 _661_/a_38_114# net38 0.00123f
C9954 baud_inst.counter\[15\] _296_ 0.29635f
C9955 hold175/a_56_118# _261_ 0.0026f
C9956 _488_/a_474_130# _019_ 0.00123f
C9957 _673_/a_612_127# net38 0
C9958 _655_/a_298_337# net40 0.02771f
C9959 _686_/a_843_236# net90 0
C9960 _658_/a_741_93# _658_/a_1489_191# -0
C9961 _701_/a_843_236# net46 0
C9962 _173_ VPWR 0.1258f
C9963 _542_/a_257_140# net140 0
C9964 _542_/a_155_412# baud_inst.counter\[24\] 0.00777f
C9965 _286_ net29 0.00663f
C9966 net26 _666_/a_550_127# 0
C9967 _270_ _647_/a_741_93# 0
C9968 net177 _684_/a_324_432# 0.0045f
C9969 _048_ rx_inst.data_reg\[5\] 0.00342f
C9970 net168 _666_/a_38_114# 0.003f
C9971 FILLER_24_218/a_40_246# _273_ 0
C9972 _079_ _227_ 0
C9973 _702_/a_741_93# _700_/a_2250_412# 0.00106f
C9974 _679_/a_2250_412# baud_inst.counter\[7\] 0.02642f
C9975 _688_/a_741_93# net40 0.01317f
C9976 _295_ clknet_0_clk 0.00619f
C9977 net167 _669_/a_550_127# 0
C9978 _002_ _669_/a_1489_191# 0
C9979 net51 net29 0.02366f
C9980 net49 _442_/a_248_122# 0
C9981 _068_ _386_/a_496_118# 0
C9982 _696_/a_843_236# clknet_0_clk 0
C9983 _163_ _356_/a_350_122# 0.00264f
C9984 _081_ _650_/a_741_93# 0
C9985 _659_/a_843_236# net41 0.06033f
C9986 net67 hold58/a_326_118# 0
C9987 _029_ hold106/a_438_182# 0.00919f
C9988 _693_/a_741_93# _302_ 0
C9989 net159 net7 0
C9990 _632_/a_298_337# _273_ 0
C9991 net94 net40 0.15047f
C9992 _341_/a_308_118# tx_inst.data_reg\[0\] 0.00188f
C9993 net41 net43 0.03298f
C9994 _096_ baud_inst.counter\[11\] 0
C9995 _080_ hold122/a_56_118# 0
C9996 _100_ _687_/a_1785_429# 0
C9997 _693_/a_2002_114# net46 0
C9998 net2 _409_/a_167_412# 0.00162f
C9999 _266_ _649_/a_1840_334# 0.00531f
C10000 VPWR _471_/a_22_110# 0.00182f
C10001 net30 _649_/a_2250_412# 0
C10002 _185_ _287_ 0
C10003 tx_inst.bit_index\[1\] _652_/a_843_236# 0
C10004 _304_ _020_ 0
C10005 hold68/a_56_118# baud_inst.counter\[29\] 0.00108f
C10006 tx_inst.data_reg\[6\] _341_/a_1453_124# 0.00289f
C10007 clknet_4_0_0_clk _287_ 0.06675f
C10008 net13 _470_/a_22_110# 0.00106f
C10009 _676_/a_1583_191# baud_inst.counter\[5\] 0.00167f
C10010 net53 net36 0
C10011 _659_/a_38_114# _147_ 0.05312f
C10012 _659_/a_324_432# _068_ 0.04292f
C10013 _696_/a_298_337# baud_inst.counter\[15\] 0
C10014 net138 _047_ 0.02122f
C10015 _643_/a_843_236# _060_ 0
C10016 _698_/a_681_505# VPWR 0
C10017 hold100/a_438_182# net142 0.00117f
C10018 _392_/a_59_156# _664_/a_298_337# 0
C10019 hold96/a_438_182# net96 0
C10020 hold96/a_326_118# clknet_4_3_0_clk 0
C10021 net155 net159 0.00134f
C10022 _178_ _699_/a_1840_334# 0.00915f
C10023 baud_inst.counter\[3\] _674_/a_1785_429# 0
C10024 baud_inst.counter\[5\] _683_/a_1583_191# 0
C10025 clknet_0_clk clknet_4_2_0_clk 0.14272f
C10026 _265_ VPWR 0.20517f
C10027 baud_inst.counter\[18\] VPWR 0.17589f
C10028 _154_ _649_/a_843_236# 0.00952f
C10029 net123 net29 0
C10030 _661_/a_324_432# _383_/a_46_156# 0
C10031 net41 _664_/a_324_432# 0
C10032 _494_/a_279_412# _182_ 0
C10033 net157 _524_/a_146_122# 0
C10034 _215_ FILLER_8_191/a_32_246# 0
C10035 hold115/a_438_182# _288_ 0
C10036 hold146/a_56_118# _171_ 0
C10037 clknet_0_clk _263_ 0
C10038 tx_inst.data_reg\[7\] clknet_0_clk 0.0149f
C10039 net42 hold123/a_438_182# 0
C10040 rx_inst.data_reg\[1\] _429_/a_244_412# 0.00356f
C10041 _205_ _670_/a_1840_334# 0
C10042 _645_/a_38_114# _232_ 0
C10043 FILLER_19_75/a_40_246# baud_inst.counter\[24\] 0.01396f
C10044 hold136/a_56_118# net181 0
C10045 _041_ _224_ 0.09858f
C10046 _690_/a_324_432# _104_ 0
C10047 net120 _303_ 0.00677f
C10048 hold157/a_326_118# _688_/a_612_127# 0
C10049 _243_ _251_ 0
C10050 FILLER_13_100/a_40_246# _099_ 0
C10051 _069_ _656_/a_38_114# 0
C10052 hold52/a_326_118# _236_ 0
C10053 hold175/a_326_118# clknet_0_clk 0.0024f
C10054 _198_ net172 0.39359f
C10055 hold119/a_56_118# net51 0
C10056 _151_ tx_inst.data_reg\[1\] 0
C10057 _384_/a_382_118# net171 0.01091f
C10058 clknet_0_clk FILLER_12_208/a_32_246# 0
C10059 _180_ _190_ 0.06002f
C10060 baud_inst.counter\[17\] _300_ 0.09868f
C10061 _650_/a_324_432# _157_ 0
C10062 net145 _339_/a_382_118# 0.00276f
C10063 _690_/a_1489_191# _296_ 0
C10064 FILLER_16_154/a_32_246# _170_ 0.00219f
C10065 _341_/a_589_385# VPWR 0
C10066 _676_/a_298_337# clknet_0_clk 0.00901f
C10067 FILLER_11_123/a_40_246# net43 0
C10068 net37 _671_/a_612_127# 0
C10069 _694_/a_2002_114# clknet_4_10_0_clk 0
C10070 net182 net123 0.0183f
C10071 _155_ _463_/a_120_432# 0
C10072 net124 _463_/a_22_110# 0.0113f
C10073 fanout32/a_40_152# _671_/a_38_114# 0
C10074 rx_inst.state\[2\] fanout31/a_40_152# 0
C10075 net67 _700_/a_2002_114# 0
C10076 _448_/a_244_412# _257_ 0.01059f
C10077 baud_inst.counter\[25\] _309_ 0.09816f
C10078 FILLER_2_110/a_32_246# _661_/a_38_114# 0
C10079 _660_/a_1583_191# _392_/a_382_118# 0
C10080 _478_/a_229_118# net11 0.00125f
C10081 _222_ _142_ 0.01114f
C10082 _141_ _220_ 0.03619f
C10083 net23 _705_/a_2250_412# 0
C10084 net101 _688_/a_324_432# 0
C10085 _113_ hold105/a_56_118# 0
C10086 net13 net77 0.00113f
C10087 _653_/a_741_93# _063_ 0
C10088 _653_/a_1489_191# _652_/a_1583_191# 0
C10089 clk _169_ 0.13344f
C10090 baud_inst.counter\[27\] _698_/a_2002_114# 0
C10091 baud_inst.counter\[26\] _698_/a_1489_191# 0
C10092 _062_ _399_/a_154_118# 0
C10093 tx_start net172 0
C10094 hold122/a_56_118# _041_ 0.02133f
C10095 net146 clknet_0_clk 0.02115f
C10096 _277_ _004_ 0.20288f
C10097 _411_/a_115_308# net2 0
C10098 _182_ clknet_4_2_0_clk 0
C10099 _707_/a_681_505# rx_inst.state\[1\] 0
C10100 net51 _668_/a_1583_191# 0.01829f
C10101 _138_ _649_/a_38_114# 0
C10102 _381_/a_46_156# _381_/a_268_412# -0
C10103 net57 _651_/a_132_114# 0
C10104 FILLER_13_137/a_32_246# _205_ 0.00617f
C10105 _537_/a_192_429# _692_/a_741_93# 0.00164f
C10106 net131 _138_ 0
C10107 net47 _634_/a_38_114# 0.00723f
C10108 net55 _656_/a_741_93# 0.00104f
C10109 _008_ net38 0.03177f
C10110 net79 _085_ 0.03617f
C10111 _006_ FILLER_7_210/a_40_246# 0.00125f
C10112 baud_inst.counter\[20\] _302_ 0.34381f
C10113 _394_/a_22_110# VPWR 0
C10114 baud_inst.counter\[4\] _281_ 0.00375f
C10115 net12 _273_ 0.02394f
C10116 _160_ _649_/a_843_236# 0
C10117 _232_ _649_/a_38_114# 0
C10118 tx_inst.bit_index\[0\] _666_/a_324_432# 0
C10119 _689_/a_1840_334# clknet_4_2_0_clk 0.00341f
C10120 hold129/a_56_118# _189_ 0.00117f
C10121 _671_/a_2250_412# _650_/a_324_432# 0
C10122 _538_/a_81_118# VPWR 0.01125f
C10123 _171_ FILLER_6_189/a_40_246# 0.00127f
C10124 hold161/a_326_118# _102_ 0.00174f
C10125 _313_ _701_/a_843_236# 0
C10126 FILLER_8_92/a_32_246# VPWR 0.07775f
C10127 _360_/a_886_118# tx_inst.bit_index\[1\] 0
C10128 hold74/a_438_182# _270_ 0
C10129 hold74/a_326_118# _125_ 0
C10130 _255_ _224_ 0
C10131 rx_inst.bit_index\[1\] net24 0.76211f
C10132 _266_ _471_/a_22_110# 0.00265f
C10133 net146 _077_ 0
C10134 net31 _434_/a_354_412# 0
C10135 FILLER_18_169/a_40_246# net25 0.00698f
C10136 _659_/a_1840_334# clknet_4_1_0_clk 0
C10137 _035_ _493_/a_45_160# 0.00762f
C10138 hold131/a_326_118# net47 0
C10139 _230_ _428_/a_354_412# 0
C10140 output20/a_40_152# _705_/a_2250_412# 0.00232f
C10141 _643_/a_843_236# _649_/a_741_93# 0
C10142 _643_/a_741_93# _649_/a_843_236# 0
C10143 _517_/a_209_168# _294_ 0.0068f
C10144 FILLER_8_171/a_32_246# _274_ 0
C10145 _118_ tx_inst.state\[3\] 0
C10146 hold55/a_326_118# tx_start 0.00313f
C10147 net39 _689_/a_612_127# 0.00457f
C10148 _676_/a_298_337# _182_ 0
C10149 _704_/a_843_236# FILLER_13_228/a_40_246# 0
C10150 _002_ net62 0.01354f
C10151 net4 _390_/a_382_118# 0
C10152 _265_ _266_ 0.12176f
C10153 _129_ net30 0.00415f
C10154 _662_/a_741_93# tx_inst.data_reg\[0\] 0
C10155 _662_/a_132_114# _065_ 0
C10156 net47 _054_ 0.04181f
C10157 _656_/a_741_93# _067_ 0.00196f
C10158 _656_/a_38_114# clknet_4_4_0_clk 0
C10159 _656_/a_298_337# tx_inst.data_reg\[2\] 0
C10160 _536_/a_341_118# net120 0.0018f
C10161 _088_ hold61/a_326_118# 0
C10162 _073_ _664_/a_2250_412# 0.00659f
C10163 _663_/a_38_114# tx_inst.state\[1\] 0
C10164 _663_/a_324_432# clknet_4_7_0_clk 0.0046f
C10165 _695_/a_681_505# _108_ 0
C10166 _643_/a_612_127# _054_ 0.00483f
C10167 _643_/a_550_127# net47 0
C10168 net110 _289_ 0.00284f
C10169 _705_/a_1785_429# net22 0
C10170 clknet_4_0_0_clk clkbuf_4_0_0_clk/a_27_118# 0.0077f
C10171 _283_ net93 0.04601f
C10172 _190_ baud_inst.counter\[11\] 0
C10173 _089_ _186_ 0.00178f
C10174 _168_ _156_ 0
C10175 net54 net170 0.05991f
C10176 _044_ VPWR 0.27878f
C10177 _286_ hold95/a_438_182# 0
C10178 _039_ net38 0
C10179 hold172/a_326_118# net11 0.01596f
C10180 _430_/a_170_412# _449_/a_27_156# 0
C10181 _371_/a_170_412# _119_ 0
C10182 _651_/a_38_114# _221_ 0
C10183 _651_/a_741_93# net183 0
C10184 tx_inst.data_reg\[1\] FILLER_4_108/a_40_246# 0.00252f
C10185 _677_/a_2250_412# baud_inst.counter\[5\] 0.00399f
C10186 net35 FILLER_21_147/a_40_246# 0
C10187 hold140/a_56_118# _697_/a_741_93# 0.00324f
C10188 hold140/a_326_118# _697_/a_324_432# 0
C10189 _639_/a_1489_191# _121_ 0
C10190 baud_inst.counter\[26\] baud_inst.counter\[23\] 0
C10191 _135_ _056_ 0.00934f
C10192 hold86/a_438_182# _673_/a_741_93# 0.00168f
C10193 hold86/a_326_118# _673_/a_843_236# 0.00189f
C10194 rx_done net81 0
C10195 _170_ FILLER_26_172/a_40_246# 0.00147f
C10196 net42 FILLER_7_121/a_40_246# 0
C10197 tx_inst.bit_index\[1\] _653_/a_1583_191# 0.03483f
C10198 hold131/a_438_182# net49 0
C10199 _533_/a_248_122# _303_ 0
C10200 net135 _683_/a_612_127# 0
C10201 _007_ net183 0
C10202 tx_inst.bit_index\[0\] _168_ 0.00277f
C10203 _639_/a_324_432# hold81/a_56_118# 0
C10204 _694_/a_298_337# VPWR 0.02528f
C10205 _049_ _649_/a_1583_191# 0
C10206 _662_/a_1489_191# net54 0.00361f
C10207 net44 hold167/a_326_118# 0
C10208 _082_ hold167/a_56_118# 0
C10209 _699_/a_1785_429# VPWR 0
C10210 _639_/a_843_236# net19 0.00605f
C10211 _431_/a_81_118# _241_ 0
C10212 net37 fanout35/a_40_152# 0
C10213 _674_/a_843_236# VPWR 0.01138f
C10214 VPWR _651_/a_2002_114# 0
C10215 hold171/a_56_118# net165 0.03343f
C10216 hold177/a_56_118# clknet_4_8_0_clk 0
C10217 _231_ net166 0.14386f
C10218 net44 _696_/a_550_127# 0
C10219 hold148/a_326_118# _693_/a_741_93# 0
C10220 hold148/a_56_118# _693_/a_843_236# 0
C10221 FILLER_9_70/a_40_246# FILLER_9_72/a_32_246# 0.0524f
C10222 net2 _169_ 0.02121f
C10223 VPWR net25 0.85009f
C10224 hold52/a_56_118# _224_ 0.01289f
C10225 _008_ FILLER_0_42/a_32_246# 0.0112f
C10226 _302_ _701_/a_298_337# 0
C10227 _663_/a_681_505# _166_ 0
C10228 _246_ _161_ 0
C10229 _064_ tx_inst.data_reg\[5\] 0
C10230 hold53/a_326_118# _640_/a_324_432# 0
C10231 _655_/a_1583_191# net40 0
C10232 FILLER_21_31/a_40_246# FILLER_22_32/a_40_246# 0
C10233 _658_/a_132_114# _069_ 0
C10234 _397_/a_279_412# VPWR 0
C10235 _191_ _667_/a_132_114# 0
C10236 hold108/a_326_118# FILLER_13_68/a_40_246# 0
C10237 _695_/a_132_114# net76 0
C10238 VPWR FILLER_5_192/a_40_246# 0.1361f
C10239 _677_/a_324_432# clknet_0_clk 0.03536f
C10240 baud_inst.counter\[24\] _309_ 0.20269f
C10241 hold167/a_56_118# clknet_0_clk 0.00225f
C10242 _125_ _647_/a_2250_412# 0
C10243 _270_ _647_/a_1785_429# 0
C10244 _639_/a_741_93# hold51/a_438_182# 0
C10245 _639_/a_843_236# hold51/a_326_118# 0
C10246 hold114/a_326_118# hold105/a_56_118# 0
C10247 net44 hold140/a_326_118# 0.0054f
C10248 _200_ _666_/a_1583_191# 0
C10249 _098_ _685_/a_38_114# 0.01891f
C10250 hold104/a_326_118# _018_ 0.01738f
C10251 _678_/a_741_93# VPWR 0.01512f
C10252 _115_ _700_/a_324_432# 0.05499f
C10253 _702_/a_612_127# _700_/a_1840_334# 0
C10254 _171_ net43 0
C10255 hold146/a_56_118# net146 0.01322f
C10256 _152_ hold146/a_438_182# 0.00898f
C10257 _688_/a_1785_429# net40 0
C10258 clkload0/Y net40 0
C10259 net104 _690_/a_132_114# 0
C10260 _181_ _279_ 0.13843f
C10261 _011_ baud_inst.counter\[13\] 0
C10262 baud_inst.counter\[13\] _684_/a_298_337# 0
C10263 _188_ _684_/a_324_432# 0.00202f
C10264 _187_ _684_/a_38_114# 0
C10265 _659_/a_612_127# net41 0.00684f
C10266 _058_ hold139/a_56_118# 0.06991f
C10267 _036_ hold92/a_326_118# 0.00138f
C10268 hold64/a_438_182# VPWR 0.00506f
C10269 _632_/a_1840_334# net64 0
C10270 FILLER_13_100/a_40_246# _685_/a_843_236# 0
C10271 hold150/a_326_118# rx_inst.data_reg\[1\] 0
C10272 net35 _442_/a_146_122# 0
C10273 net31 _004_ 0.00134f
C10274 hold176/a_326_118# _261_ 0
C10275 hold176/a_56_118# _262_ 0.0098f
C10276 _424_/a_142_412# _154_ 0.00543f
C10277 net144 net25 0
C10278 net100 _026_ 0
C10279 _431_/a_175_118# net49 0
C10280 _060_ net47 0.02184f
C10281 FILLER_4_172/a_32_246# VPWR 0.07422f
C10282 net55 _658_/a_1840_334# 0
C10283 tx_inst.data_reg\[6\] _341_/a_1377_160# 0.00327f
C10284 _671_/a_741_93# clkbuf_4_6_0_clk/a_27_118# 0.00448f
C10285 _636_/a_324_432# _264_ 0.02567f
C10286 _228_ fanout25/a_40_152# 0.00111f
C10287 _133_ FILLER_22_175/a_32_246# 0.02706f
C10288 _171_ _664_/a_324_432# 0
C10289 baud_inst.counter\[12\] _514_/a_257_140# 0.00141f
C10290 net128 _514_/a_155_412# 0.00104f
C10291 FILLER_25_7/a_40_246# VPWR 0.13661f
C10292 _224_ _051_ 0
C10293 hold140/a_56_118# clknet_0_clk 0.01184f
C10294 _698_/a_550_127# VPWR 0
C10295 hold178/a_326_118# net40 0.01669f
C10296 net122 net51 0.35015f
C10297 _382_/a_382_118# _209_ 0.02537f
C10298 net158 _015_ 0.01109f
C10299 baud_inst.counter\[17\] net160 0.15423f
C10300 _044_ _266_ 0
C10301 rx_inst.data_reg\[2\] hold150/a_56_118# 0.02975f
C10302 _508_/a_380_412# net29 0
C10303 _154_ _649_/a_612_127# 0.00504f
C10304 _661_/a_741_93# _210_ 0.00456f
C10305 _016_ baud_inst.counter\[16\] 0
C10306 _170_ _436_/a_550_140# 0
C10307 _294_ hold108/a_56_118# 0
C10308 _019_ FILLER_2_79/a_40_246# 0.01175f
C10309 rx_data[7] _639_/a_741_93# 0
C10310 FILLER_1_90/a_32_246# net6 0.00299f
C10311 _077_ _706_/a_612_127# 0
C10312 _670_/a_1489_191# clknet_4_9_0_clk 0.00867f
C10313 hold124/a_56_118# net30 0
C10314 _677_/a_324_432# _182_ 0.03399f
C10315 net54 net11 0.14838f
C10316 _204_ _667_/a_1583_191# 0
C10317 _164_ _104_ 0.00904f
C10318 net99 net46 0.02319f
C10319 net2 _084_ 0
C10320 net151 fanout47/a_40_152# 0.04963f
C10321 _229_ _223_ 0
C10322 net136 net86 0.00483f
C10323 _555_/a_177_436# clknet_4_11_0_clk 0
C10324 hold76/a_326_118# _302_ 0.0053f
C10325 tx_inst.data_reg\[7\] hold155/a_438_182# 0.00238f
C10326 hold63/a_438_182# _002_ 0
C10327 hold74/a_326_118# _129_ 0
C10328 net148 _693_/a_38_114# 0
C10329 _658_/a_1840_334# _067_ 0.00656f
C10330 _062_ net56 0.00143f
C10331 FILLER_7_82/a_32_246# baud_inst.counter\[6\] 0.00101f
C10332 baud_inst.counter\[20\] hold148/a_326_118# 0
C10333 FILLER_21_194/a_32_246# VPWR 0.07083f
C10334 _656_/a_843_236# FILLER_0_163/a_32_246# 0
C10335 baud_inst.counter\[12\] net130 0
C10336 net26 _671_/a_843_236# 0.02422f
C10337 net145 _339_/a_810_118# 0
C10338 _676_/a_1583_191# clknet_0_clk 0
C10339 net177 _356_/a_350_122# 0
C10340 clknet_4_6_0_clk _459_/a_229_118# 0
C10341 _279_ _088_ 0
C10342 _341_/a_1023_118# VPWR 0
C10343 _645_/a_741_93# net47 0
C10344 net37 _191_ 0.03172f
C10345 _155_ _268_ 0.05787f
C10346 _679_/a_741_93# clknet_0_clk 0.00312f
C10347 clkbuf_4_9_0_clk/a_27_118# net46 0.03944f
C10348 hold75/a_438_182# net46 0
C10349 net111 clknet_4_15_0_clk 0
C10350 _672_/a_741_93# _085_ 0
C10351 _672_/a_843_236# net38 0
C10352 clknet_0_clk _683_/a_1583_191# 0.00462f
C10353 net121 net45 0.00296f
C10354 hold172/a_438_182# _275_ 0.00911f
C10355 _167_ net25 0.53112f
C10356 _644_/a_38_114# _255_ 0
C10357 _264_ hold81/a_56_118# 0.00536f
C10358 _548_/a_76_160# net140 0.00475f
C10359 _699_/a_324_432# net45 0.01873f
C10360 FILLER_14_70/a_40_246# clknet_0_clk 0
C10361 _060_ net70 0
C10362 hold176/a_438_182# clknet_0_clk 0.00443f
C10363 net57 _651_/a_1489_191# 0
C10364 hold57/a_56_118# clknet_4_6_0_clk 0.00186f
C10365 net51 _668_/a_2002_114# 0
C10366 _707_/a_550_127# rx_inst.state\[1\] 0
C10367 _456_/a_155_412# _157_ 0.00458f
C10368 _225_ net25 0.30963f
C10369 net75 _692_/a_843_236# 0
C10370 _305_ _692_/a_741_93# 0.00192f
C10371 net47 _634_/a_1840_334# 0
C10372 hold52/a_326_118# net2 0.02531f
C10373 _023_ _692_/a_324_432# 0
C10374 _706_/a_741_93# _120_ 0
C10375 _706_/a_843_236# net43 0.01576f
C10376 _286_ _288_ 0
C10377 _671_/a_298_337# rx_inst.state\[4\] 0.02573f
C10378 FILLER_23_204/a_40_246# _649_/a_1489_191# 0
C10379 hold144/a_438_182# _257_ 0
C10380 _065_ net170 0
C10381 _199_ _366_/a_170_412# 0
C10382 tx_busy _705_/a_843_236# 0
C10383 _474_/a_120_432# clknet_0_clk 0.00429f
C10384 baud_inst.counter\[12\] clknet_4_8_0_clk 0
C10385 net16 net30 0.01502f
C10386 _696_/a_38_114# clknet_4_8_0_clk 0.03377f
C10387 _660_/a_298_337# _175_ 0
C10388 clknet_4_1_0_clk _655_/a_324_432# 0.06115f
C10389 _660_/a_38_114# _174_ 0
C10390 hold57/a_56_118# _218_ 0
C10391 hold57/a_326_118# _217_ 0.00152f
C10392 hold57/a_438_182# _195_ 0
C10393 net48 _639_/a_38_114# 0
C10394 hold131/a_438_182# net131 0
C10395 hold137/a_326_118# VPWR 0.00441f
C10396 _645_/a_843_236# net49 0.00274f
C10397 _139_ VPWR 0.03609f
C10398 net97 _683_/a_324_432# 0.00115f
C10399 net108 _683_/a_741_93# 0.03879f
C10400 net173 hold183/a_326_118# 0
C10401 net123 _670_/a_741_93# 0.01879f
C10402 baud_inst.counter\[13\] baud_inst.counter\[16\] 0
C10403 net47 _649_/a_741_93# 0
C10404 _054_ _649_/a_324_432# 0
C10405 FILLER_0_174/a_32_246# _208_ 0
C10406 _525_/a_268_412# net157 0.00388f
C10407 _525_/a_46_156# _299_ 0.03268f
C10408 net156 net87 0
C10409 _230_ _245_ 0.02016f
C10410 net39 net130 0
C10411 _191_ _670_/a_843_236# 0.00479f
C10412 net62 FILLER_14_148/a_40_246# 0.01952f
C10413 hold77/a_326_118# _633_/a_1840_334# 0
C10414 hold77/a_438_182# _633_/a_1583_191# 0
C10415 hold77/a_56_118# _633_/a_2250_412# 0.00308f
C10416 _643_/a_1583_191# _649_/a_1583_191# 0.00145f
C10417 rx_inst.bit_index\[1\] _641_/a_324_432# 0
C10418 net39 net158 0.00921f
C10419 clknet_4_13_0_clk _240_ 0
C10420 _230_ net176 0
C10421 _388_/a_59_156# _387_/a_268_412# 0
C10422 clknet_4_8_0_clk net88 0
C10423 net105 net68 -0
C10424 rx_data[1] net82 0
C10425 VPWR _632_/a_843_236# 0.0054f
C10426 baud_inst.counter\[1\] hold79/a_438_182# 0
C10427 _679_/a_741_93# _182_ 0.00132f
C10428 _656_/a_1840_334# clknet_4_4_0_clk 0
C10429 _656_/a_1583_191# tx_inst.data_reg\[2\] 0.00519f
C10430 tx_inst.bit_index\[2\] _339_/a_886_118# 0.00363f
C10431 _283_ clknet_4_1_0_clk 0
C10432 baud_inst.counter\[8\] _506_/a_155_412# 0.03054f
C10433 _294_ baud_inst.counter\[15\] 0.01256f
C10434 _663_/a_1840_334# tx_inst.state\[1\] 0
C10435 _182_ _683_/a_1583_191# 0.00441f
C10436 _663_/a_2250_412# clknet_4_7_0_clk 0.00113f
C10437 net49 _445_/a_279_412# 0
C10438 _206_ FILLER_4_100/a_40_246# 0.00341f
C10439 _706_/a_324_432# net21 0
C10440 rx_data[7] _061_ 0
C10441 _415_/a_170_412# clknet_0_clk 0
C10442 _057_ FILLER_17_199/a_40_246# 0
C10443 _547_/a_81_118# _546_/a_155_160# 0
C10444 net43 FILLER_12_208/a_32_246# 0.01796f
C10445 VPWR _668_/a_324_432# 0.00608f
C10446 baud_inst.counter\[12\] _358_/a_72_436# 0
C10447 _004_ _404_/a_46_156# 0.0019f
C10448 _277_ _404_/a_268_412# 0
C10449 _098_ clknet_0_clk 0.02183f
C10450 clknet_0_clk hold180/a_326_118# 0.0013f
C10451 _644_/a_1840_334# _245_ 0
C10452 _139_ _239_ 0.02729f
C10453 hold171/a_326_118# _658_/a_324_432# 0
C10454 hold171/a_56_118# _658_/a_741_93# 0.00324f
C10455 net49 _188_ 0
C10456 net128 _686_/a_1583_191# 0
C10457 hold105/a_56_118# _700_/a_324_432# 0
C10458 _694_/a_324_432# _106_ 0.0012f
C10459 _696_/a_324_432# _686_/a_1583_191# 0
C10460 _696_/a_1583_191# _686_/a_324_432# 0
C10461 net45 _698_/a_843_236# 0.00779f
C10462 _111_ _698_/a_741_93# 0.00208f
C10463 baud_inst.counter\[8\] _292_ 0
C10464 baud_inst.counter\[28\] _702_/a_843_236# 0.03392f
C10465 baud_inst.counter\[30\] _702_/a_324_432# 0.01845f
C10466 hold66/a_56_118# VPWR 0.01104f
C10467 _376_/a_272_160# net27 0
C10468 net50 _704_/a_132_114# 0
C10469 net51 _667_/a_550_127# 0
C10470 _465_/a_22_110# rx_data[7] 0.00413f
C10471 VPWR _527_/a_192_429# 0.0048f
C10472 net58 _699_/a_1489_191# 0
C10473 FILLER_25_177/a_40_246# _139_ 0.00135f
C10474 baud_inst.counter\[1\] _673_/a_1583_191# 0.0078f
C10475 rx_inst.state\[3\] _002_ 0.68414f
C10476 _058_ net119 0.00115f
C10477 FILLER_21_194/a_32_246# _266_ 0
C10478 _390_/a_382_118# net40 0
C10479 net87 _180_ 0
C10480 net150 _158_ 0.06204f
C10481 VPWR _648_/a_38_114# 0.02788f
C10482 VPWR _380_/a_285_412# 0
C10483 rx_inst.state\[2\] _131_ 0.00231f
C10484 _635_/a_843_236# net64 0.01192f
C10485 net79 baud_inst.counter\[3\] 0.00512f
C10486 _073_ FILLER_5_213/a_32_246# 0
C10487 hold182/a_438_182# VPWR 0.00407f
C10488 hold116/a_326_118# clknet_4_0_0_clk 0
C10489 tx_inst.bit_index\[1\] _653_/a_2002_114# 0
C10490 net146 net43 0.1185f
C10491 _264_ hold72/a_326_118# 0
C10492 _287_ _096_ 0
C10493 hold165/a_326_118# net41 0.01444f
C10494 _657_/a_1840_334# _339_/a_71_118# 0
C10495 _020_ _692_/a_741_93# 0.00427f
C10496 net105 _701_/a_324_432# 0
C10497 _694_/a_1583_191# VPWR 0.00535f
C10498 _313_ net99 0
C10499 _040_ net54 0.17477f
C10500 _509_/a_155_412# _096_ 0.00471f
C10501 _639_/a_38_114# _707_/a_2250_412# 0
C10502 _639_/a_324_432# _707_/a_1840_334# 0
C10503 _639_/a_741_93# _707_/a_1583_191# 0
C10504 net108 _185_ 0
C10505 _639_/a_612_127# net19 0.01727f
C10506 output13/a_40_152# _123_ 0.01353f
C10507 hold111/a_438_182# _122_ 0.00943f
C10508 _382_/a_285_118# net137 0.00147f
C10509 _644_/a_741_93# _644_/a_843_236# 0
C10510 _674_/a_612_127# VPWR 0.0048f
C10511 tx_inst.data_reg\[4\] _146_ 0.05266f
C10512 _206_ net9 0.22839f
C10513 net33 input11/a_40_152# 0.00917f
C10514 rx_done hold80/a_438_182# 0.01353f
C10515 clknet_4_8_0_clk _529_/a_45_160# 0.01251f
C10516 _554_/a_248_122# baud_inst.counter\[29\] 0
C10517 hold141/a_56_118# net113 0
C10518 hold76/a_56_118# hold120/a_56_118# 0.00715f
C10519 _662_/a_132_114# VPWR 0
C10520 clknet_4_0_0_clk net181 1.14135f
C10521 clknet_4_11_0_clk _702_/a_298_337# 0.00397f
C10522 net70 _649_/a_741_93# 0
C10523 _638_/a_38_114# rx_inst.data_reg\[6\] 0
C10524 _663_/a_550_127# _166_ 0
C10525 _169_ _084_ 0.00662f
C10526 _307_ FILLER_19_75/a_40_246# 0
C10527 net7 _384_/a_382_118# 0
C10528 clknet_4_11_0_clk _640_/a_132_114# 0
C10529 net53 _640_/a_843_236# 0.00561f
C10530 hold75/a_438_182# _313_ 0
C10531 _537_/a_155_160# net148 0
C10532 net75 _534_/a_46_156# 0
C10533 _645_/a_843_236# _644_/a_324_432# 0
C10534 _645_/a_741_93# _644_/a_741_93# 0.00547f
C10535 net107 net46 0
C10536 _537_/a_192_429# _021_ 0.01192f
C10537 _087_ net61 0
C10538 _673_/a_843_236# VPWR 0.00796f
C10539 _098_ _182_ 0
C10540 net39 _358_/a_72_436# 0.01213f
C10541 net125 hold127/a_438_182# 0
C10542 baud_inst.counter\[20\] FILLER_22_32/a_40_246# 0
C10543 _200_ _666_/a_2002_114# 0
C10544 VPWR _667_/a_298_337# 0.00243f
C10545 net27 _475_/a_170_412# 0
C10546 _098_ _685_/a_1840_334# 0
C10547 hold119/a_326_118# _459_/a_27_156# 0
C10548 _692_/a_1583_191# _104_ 0
C10549 fanout46/a_40_152# net1 0.0027f
C10550 _674_/a_324_432# _181_ 0.00394f
C10551 _297_ net29 0
C10552 _115_ _700_/a_2250_412# 0
C10553 hold104/a_56_118# clknet_4_8_0_clk 0.02586f
C10554 hold104/a_438_182# _103_ 0.00651f
C10555 _022_ _108_ 0
C10556 hold108/a_438_182# _683_/a_1840_334# 0
C10557 net149 net1 0.00399f
C10558 baud_inst.counter\[13\] _684_/a_1583_191# 0.01337f
C10559 _081_ _061_ 0.00247f
C10560 net111 hold111/a_326_118# 0.00156f
C10561 _060_ _649_/a_324_432# 0.04543f
C10562 tx_inst.data_reg\[4\] _656_/a_298_337# 0.00468f
C10563 net73 _636_/a_741_93# 0.00169f
C10564 _269_ _636_/a_324_432# 0.0026f
C10565 clknet_0_clk _247_ 0.00735f
C10566 _657_/a_298_337# tx_inst.data_reg\[1\] 0
C10567 _687_/a_741_93# _296_ 0.03278f
C10568 _632_/a_681_505# net30 0
C10569 _632_/a_843_236# _266_ 0
C10570 net6 _209_ 0
C10571 _040_ _368_/a_155_412# 0
C10572 _180_ _312_ 0
C10573 _636_/a_2250_412# _264_ 0
C10574 hold168/a_326_118# _206_ 0.00301f
C10575 _343_/a_257_140# _007_ 0
C10576 _260_ net180 0.00528f
C10577 FILLER_24_218/a_40_246# _154_ 0
C10578 _678_/a_612_127# hold93/a_56_118# 0
C10579 net128 _293_ 0.06702f
C10580 FILLER_23_143/a_32_246# _253_ 0
C10581 _659_/a_1489_191# tx_inst.data_reg\[3\] 0
C10582 net112 _060_ 0
C10583 _000_ _668_/a_843_236# 0
C10584 _266_ _668_/a_324_432# 0.01062f
C10585 _017_ net102 0.4293f
C10586 _431_/a_81_118# net35 0.11364f
C10587 _166_ _665_/a_298_337# 0
C10588 net156 _689_/a_324_432# 0
C10589 FILLER_11_142/a_40_246# _667_/a_741_93# 0.0029f
C10590 output15/a_40_152# _125_ 0
C10591 _246_ FILLER_18_148/a_40_246# 0.00395f
C10592 _353_/a_146_122# net29 0
C10593 hold74/a_56_118# rx_data[4] 0.00526f
C10594 hold74/a_326_118# net16 0.00167f
C10595 _154_ net127 0.02979f
C10596 _093_ _287_ 0
C10597 _215_ _200_ 0.08271f
C10598 _170_ _249_ 0.00179f
C10599 clkbuf_4_2_0_clk/a_27_118# _683_/a_324_432# 0
C10600 hold53/a_56_118# net100 0
C10601 clknet_4_11_0_clk hold100/a_438_182# 0
C10602 hold173/a_56_118# net34 0.01355f
C10603 _090_ _282_ 0.0012f
C10604 _644_/a_2250_412# hold131/a_438_182# 0.00887f
C10605 hold114/a_56_118# baud_inst.counter\[29\] 0.01315f
C10606 _448_/a_142_412# _258_ 0.00207f
C10607 hold66/a_326_118# net30 0.03932f
C10608 hold66/a_56_118# _266_ 0
C10609 _160_ _446_/a_146_122# 0
C10610 _004_ net62 0.00666f
C10611 _277_ _168_ 0.19808f
C10612 _636_/a_38_114# _156_ 0.0017f
C10613 _680_/a_550_127# _030_ 0
C10614 tx _665_/a_2250_412# 0
C10615 baud_inst.counter\[20\] _692_/a_1489_191# 0
C10616 _077_ _119_ 0
C10617 _677_/a_2250_412# _182_ 0
C10618 net30 _648_/a_324_432# 0.00219f
C10619 _266_ _648_/a_38_114# 0.0028f
C10620 _439_/a_354_412# _236_ 0
C10621 hold181/a_56_118# hold135/a_56_118# 0
C10622 hold146/a_326_118# _200_ 0.00587f
C10623 _204_ _667_/a_2002_114# 0
C10624 _440_/a_142_412# _158_ 0.00505f
C10625 _095_ net97 0
C10626 tx_inst.data_reg\[7\] input5/a_40_152# 0.00148f
C10627 _099_ _669_/a_132_114# 0
C10628 _662_/a_681_505# net179 0
C10629 _699_/a_1489_191# _027_ 0.00867f
C10630 _658_/a_1489_191# clknet_4_4_0_clk 0.00305f
C10631 FILLER_5_84/a_40_246# VPWR 0.16828f
C10632 _230_ _255_ 0.01183f
C10633 hold86/a_438_182# net79 0.01438f
C10634 _392_/a_59_156# net54 0.01519f
C10635 hold124/a_438_182# _154_ 0
C10636 _674_/a_324_432# _088_ 0
C10637 hold97/a_438_182# hold109/a_326_118# 0
C10638 hold97/a_326_118# hold109/a_438_182# 0
C10639 _180_ _685_/a_324_432# 0.00132f
C10640 _696_/a_1583_191# clknet_4_9_0_clk 0.00128f
C10641 net12 _638_/a_741_93# 0.00244f
C10642 hold52/a_438_182# _255_ 0
C10643 hold64/a_326_118# _638_/a_1583_191# 0
C10644 hold101/a_326_118# net49 0.00138f
C10645 _228_ net166 0.00183f
C10646 hold120/a_438_182# _023_ 0.00102f
C10647 _697_/a_741_93# baud_inst.counter\[25\] 0.0058f
C10648 _214_ net41 0.87561f
C10649 _284_ net29 0
C10650 _170_ _671_/a_550_127# 0
C10651 net105 hold105/a_326_118# 0.01186f
C10652 hold106/a_56_118# _701_/a_1583_191# 0
C10653 _635_/a_298_337# VPWR 0.00273f
C10654 _679_/a_1785_429# clknet_0_clk 0
C10655 _398_/a_494_160# _216_ 0
C10656 net32 _671_/a_612_127# 0
C10657 _640_/a_741_93# net24 0
C10658 clknet_4_5_0_clk _392_/a_559_412# 0.00122f
C10659 hold128/a_56_118# _089_ 0
C10660 _482_/a_154_118# _168_ 0
C10661 net73 hold81/a_326_118# 0
C10662 _269_ hold81/a_56_118# 0
C10663 net35 _060_ 0
C10664 _356_/a_146_122# baud_inst.counter\[13\] 0.00221f
C10665 _672_/a_612_127# net38 0
C10666 clknet_0_clk _683_/a_2002_114# 0
C10667 _687_/a_324_432# net88 0
C10668 _687_/a_38_114# _014_ 0
C10669 net62 _669_/a_1583_191# 0
C10670 baud_inst.counter\[30\] _112_ 0
C10671 baud_inst.counter\[22\] _106_ 0
C10672 _095_ _689_/a_1489_191# 0
C10673 _695_/a_2250_412# _313_ 0.00436f
C10674 _256_ FILLER_25_163/a_32_246# 0
C10675 _176_ net54 0
C10676 _499_/a_209_168# net40 0.00212f
C10677 hold158/a_326_118# _102_ 0.00276f
C10678 _699_/a_2250_412# net45 0.0089f
C10679 _312_ net140 0.01956f
C10680 net41 FILLER_3_177/a_32_246# 0
C10681 net31 fanout31/a_40_152# 0.01891f
C10682 _264_ _157_ 0.09943f
C10683 _257_ net47 0.03769f
C10684 _256_ net47 0
C10685 hold153/a_56_118# net40 0
C10686 _292_ _685_/a_741_93# 0
C10687 _023_ _692_/a_2250_412# 0
C10688 net55 _067_ 0.0079f
C10689 clknet_4_5_0_clk _192_ 0.02844f
C10690 _706_/a_612_127# net43 0.02327f
C10691 _671_/a_1583_191# rx_inst.state\[4\] 0.00965f
C10692 _341_/a_886_118# net9 0
C10693 hold169/a_438_182# _007_ 0.00298f
C10694 _160_ _632_/a_298_337# 0
C10695 _705_/a_741_93# _704_/a_843_236# 0
C10696 _705_/a_843_236# _704_/a_741_93# 0
C10697 _671_/a_1583_191# net119 0
C10698 baud_inst.counter\[27\] hold100/a_56_118# 0.00283f
C10699 _207_ net6 0
C10700 _657_/a_741_93# VPWR 0.02392f
C10701 _359_/a_22_110# _196_ 0
C10702 FILLER_9_79/a_32_246# net29 0
C10703 _050_ _636_/a_38_114# 0
C10704 _122_ clknet_0_clk 0.01305f
C10705 net182 _284_ 0
C10706 net41 FILLER_3_150/a_40_246# 0.00102f
C10707 _696_/a_1840_334# clknet_4_8_0_clk 0
C10708 _044_ _138_ 0
C10709 _158_ _633_/a_132_114# 0
C10710 _649_/a_324_432# _649_/a_741_93# 0
C10711 clknet_4_1_0_clk _655_/a_2250_412# 0
C10712 net57 _219_ 0
C10713 _688_/a_38_114# clknet_4_2_0_clk 0.01549f
C10714 net90 hold91/a_438_182# 0.01175f
C10715 hold90/a_438_182# net91 0.00886f
C10716 net48 _639_/a_1840_334# 0
C10717 hold119/a_438_182# VPWR 0.01847f
C10718 _046_ _632_/a_324_432# 0
C10719 _705_/a_298_337# net43 0.03112f
C10720 net132 fanout48/a_40_152# 0
C10721 _645_/a_612_127# net49 0.01516f
C10722 net69 _048_ 0
C10723 hold170/a_326_118# net170 0.00781f
C10724 net108 _683_/a_1785_429# 0.00138f
C10725 _679_/a_132_114# net181 0
C10726 net27 _141_ 0.00362f
C10727 net123 _670_/a_1785_429# 0
C10728 _646_/a_1840_334# net85 0
C10729 _044_ _232_ 0
C10730 net47 _649_/a_1785_429# 0.00168f
C10731 net20 net22 0
C10732 _082_ _669_/a_324_432# 0.03199f
C10733 net44 _669_/a_741_93# 0.00201f
C10734 _265_ hold73/a_326_118# 0
C10735 hold139/a_438_182# _249_ 0
C10736 net16 _647_/a_2250_412# 0
C10737 _643_/a_1840_334# _649_/a_1489_191# 0
C10738 hold139/a_326_118# _136_ 0.05498f
C10739 rx_inst.bit_index\[1\] _641_/a_2250_412# 0.01307f
C10740 _388_/a_285_412# _212_ 0.0049f
C10741 _674_/a_298_337# _087_ 0.03908f
C10742 _307_ _309_ 0.00869f
C10743 FILLER_24_229/a_32_246# _128_ 0
C10744 VPWR _632_/a_612_127# 0
C10745 hold113/a_438_182# _165_ 0
C10746 _656_/a_2002_114# tx_inst.data_reg\[2\] 0
C10747 _078_ net26 0.17803f
C10748 _034_ _685_/a_843_236# 0
C10749 _135_ net32 0
C10750 baud_inst.counter\[8\] _289_ 0.05845f
C10751 net39 _688_/a_843_236# 0
C10752 _182_ _683_/a_2002_114# 0
C10753 _508_/a_380_412# _288_ 0.02672f
C10754 hold52/a_56_118# _230_ 0.04796f
C10755 hold168/a_326_118# _202_ 0
C10756 hold168/a_56_118# _201_ 0
C10757 VPWR _668_/a_2250_412# 0.00268f
C10758 net55 _389_/a_46_156# 0.00951f
C10759 net89 net49 0
C10760 baud_inst.counter\[3\] _672_/a_741_93# 0.00423f
C10761 _675_/a_843_236# clknet_4_0_0_clk 0.02825f
C10762 net92 net39 0
C10763 FILLER_0_156/a_32_246# net165 0
C10764 _041_ _651_/a_132_114# 0
C10765 net128 _686_/a_2002_114# 0
C10766 hold164/a_56_118# _104_ 0.00683f
C10767 _533_/a_146_122# net147 0.0021f
C10768 _339_/a_71_118# net41 0.01991f
C10769 FILLER_7_40/a_32_246# baud_inst.counter\[10\] 0
C10770 hold137/a_56_118# _653_/a_298_337# 0
C10771 net124 FILLER_27_210/a_40_246# 0
C10772 baud_inst.counter\[28\] _702_/a_612_127# 0.02637f
C10773 baud_inst.counter\[30\] _702_/a_2250_412# 0.01452f
C10774 _116_ hold58/a_326_118# 0
C10775 net45 _698_/a_612_127# 0.00147f
C10776 baud_inst.counter\[25\] clknet_0_clk 0.05619f
C10777 _533_/a_146_122# net46 0.00126f
C10778 clknet_0_clk _669_/a_324_432# 0.00262f
C10779 net136 net38 0.87357f
C10780 hold87/a_56_118# _544_/a_46_156# 0.01617f
C10781 tx_inst.state\[4\] _705_/a_324_432# 0
C10782 _232_ net25 0.02691f
C10783 net42 _000_ 0.00752f
C10784 hold96/a_326_118# _182_ 0.04525f
C10785 FILLER_16_221/a_32_246# _636_/a_843_236# 0
C10786 VPWR _648_/a_1840_334# 0.00161f
C10787 _698_/a_843_236# FILLER_21_96/a_40_246# 0
C10788 VPWR net170 0.05262f
C10789 baud_inst.counter\[7\] _287_ 0
C10790 net18 _634_/a_1489_191# 0
C10791 _635_/a_612_127# net64 0.00266f
C10792 _693_/a_843_236# clknet_4_10_0_clk 0.04965f
C10793 clknet_4_5_0_clk _706_/a_324_432# 0.02982f
C10794 _508_/a_209_168# _682_/a_1583_191# 0
C10795 tx_busy hold80/a_326_118# 0.00142f
C10796 rx_inst.data_reg\[4\] clknet_0_clk 0.00701f
C10797 _633_/a_38_114# net78 0.04758f
C10798 _635_/a_38_114# net30 0.05476f
C10799 _635_/a_298_337# _266_ 0.00307f
C10800 _195_ net183 0.18551f
C10801 net163 _692_/a_550_127# 0
C10802 _531_/a_209_168# net164 0
C10803 net105 _701_/a_2250_412# 0.00836f
C10804 _632_/a_741_93# _049_ 0
C10805 _290_ _096_ 0.07254f
C10806 _663_/a_298_337# clknet_4_6_0_clk 0.03008f
C10807 _012_ net130 0
C10808 net37 _459_/a_27_156# 0.09159f
C10809 net81 net19 0.0015f
C10810 net48 FILLER_16_203/a_32_246# 0
C10811 net137 _149_ 0.00335f
C10812 _677_/a_298_337# _282_ 0
C10813 _677_/a_324_432# net152 0.00381f
C10814 baud_inst.counter\[18\] _523_/a_155_412# 0
C10815 _030_ VPWR 0.33817f
C10816 _102_ _689_/a_1489_191# 0
C10817 VPWR _682_/a_298_337# 0.01647f
C10818 net32 fanout35/a_40_152# 0
C10819 _230_ _051_ 0
C10820 _662_/a_1489_191# VPWR 0.00188f
C10821 net118 hold81/a_326_118# 0
C10822 clknet_4_11_0_clk _702_/a_1583_191# 0.01572f
C10823 _155_ _429_/a_550_140# 0
C10824 _441_/a_154_118# _161_ 0.0021f
C10825 hold97/a_56_118# net29 0.00433f
C10826 input9/a_40_152# _380_/a_59_156# 0
C10827 net94 FILLER_5_59/a_40_246# 0
C10828 clknet_4_7_0_clk _166_ 0.00948f
C10829 hold102/a_438_182# _690_/a_38_114# 0
C10830 hold102/a_56_118# _690_/a_741_93# 0
C10831 hold123/a_438_182# net39 0
C10832 net156 _354_/a_170_412# 0.00105f
C10833 _043_ rx_inst.data_reg\[6\] 0
C10834 _043_ _632_/a_324_432# 0.03607f
C10835 net53 _640_/a_612_127# 0.00174f
C10836 VPWR hold90/a_56_118# 0.03635f
C10837 _697_/a_38_114# _309_ 0
C10838 _697_/a_741_93# baud_inst.counter\[24\] 0.00393f
C10839 _697_/a_843_236# net140 0
C10840 _661_/a_38_114# VPWR 0.00191f
C10841 _645_/a_2250_412# _644_/a_843_236# 0
C10842 _700_/a_38_114# baud_inst.counter\[29\] 0
C10843 _245_ _424_/a_550_140# 0
C10844 _427_/a_146_122# net24 0.00187f
C10845 _305_ _021_ 0.00187f
C10846 _673_/a_612_127# VPWR 0.00268f
C10847 hold138/a_56_118# _636_/a_741_93# 0
C10848 hold138/a_326_118# _636_/a_324_432# 0
C10849 _677_/a_38_114# _498_/a_279_412# 0
C10850 FILLER_19_178/a_40_246# hold144/a_56_118# 0
C10851 rx_inst.bit_index\[1\] FILLER_21_147/a_40_246# 0
C10852 hold118/a_56_118# rx_inst.state\[1\] 0.0011f
C10853 clknet_4_13_0_clk hold51/a_56_118# 0.00302f
C10854 _640_/a_324_432# VPWR 0.02026f
C10855 VPWR _667_/a_1583_191# 0.01245f
C10856 hold156/a_438_182# net97 0.00419f
C10857 _674_/a_2250_412# _181_ 0.03439f
C10858 _650_/a_298_337# _459_/a_27_156# 0
C10859 _691_/a_1840_334# net103 0
C10860 _117_ VPWR 0.24481f
C10861 hold108/a_56_118# _096_ 0.00389f
C10862 fanout31/a_40_152# _404_/a_46_156# 0
C10863 net30 _123_ 0
C10864 _206_ net171 1.61544f
C10865 _120_ _200_ 0.21798f
C10866 baud_inst.counter\[13\] _684_/a_2002_114# 0
C10867 hold119/a_438_182# _167_ 0.00152f
C10868 baud_inst.counter\[5\] net137 0
C10869 _269_ _636_/a_2250_412# 0.00792f
C10870 net79 _145_ 0
C10871 _678_/a_550_127# _036_ 0
C10872 net93 _499_/a_380_412# 0
C10873 _517_/a_209_168# _190_ 0
C10874 _463_/a_22_110# _264_ 0.0175f
C10875 net13 FILLER_29_198/a_40_246# 0.00375f
C10876 net94 _352_/a_268_412# 0
C10877 _657_/a_1583_191# tx_inst.data_reg\[1\] 0.0389f
C10878 fanout41/a_40_152# clknet_4_4_0_clk 0
C10879 net92 _352_/a_46_156# 0.00817f
C10880 _500_/a_257_140# baud_inst.counter\[6\] 0
C10881 _687_/a_1785_429# _296_ 0.00112f
C10882 _632_/a_550_127# net30 0
C10883 _632_/a_612_127# _266_ 0.00101f
C10884 _673_/a_324_432# _181_ 0
C10885 _673_/a_741_93# net60 0.00585f
C10886 net48 net73 0.88796f
C10887 baud_inst.counter\[21\] net45 0.03649f
C10888 hold181/a_326_118# net135 0.03419f
C10889 hold181/a_56_118# _287_ 0.00913f
C10890 _020_ clknet_4_8_0_clk 0
C10891 _671_/a_324_432# _153_ 0
C10892 _217_ _653_/a_324_432# 0
C10893 _468_/a_22_110# _125_ 0
C10894 _283_ hold94/a_438_182# 0
C10895 tx_inst.data_reg\[5\] tx_inst.data_reg\[3\] 0.56629f
C10896 hold109/a_438_182# _684_/a_38_114# 0
C10897 hold109/a_56_118# _684_/a_741_93# 0
C10898 _144_ _071_ 0.01969f
C10899 _000_ _668_/a_612_127# 0
C10900 net168 _664_/a_843_236# 0.0341f
C10901 _220_ _400_/a_435_412# 0.00397f
C10902 _401_/a_22_110# net183 0.00571f
C10903 _142_ _400_/a_192_429# 0.00337f
C10904 net156 _689_/a_2250_412# 0
C10905 _680_/a_1583_191# _288_ 0
C10906 _170_ net51 0
C10907 FILLER_20_57/a_32_246# _695_/a_1583_191# 0
C10908 _536_/a_435_412# _302_ 0
C10909 net81 _457_/a_22_110# 0.05001f
C10910 clknet_4_13_0_clk _457_/a_120_432# 0
C10911 _072_ _210_ 0.01344f
C10912 hold129/a_56_118# clknet_0_clk 0
C10913 _166_ _007_ 0.4004f
C10914 tx_busy output23/a_40_152# 0.09687f
C10915 _688_/a_1489_191# net160 0
C10916 rx_data[7] _050_ 0.00812f
C10917 _160_ _258_ 0.02824f
C10918 _636_/a_1840_334# _156_ 0
C10919 _012_ _358_/a_72_436# 0
C10920 hold154/a_438_182# hold128/a_326_118# 0
C10921 hold154/a_326_118# hold128/a_438_182# 0
C10922 _518_/a_45_160# net87 0.02562f
C10923 _414_/a_165_412# clknet_0_clk 0
C10924 net58 _555_/a_209_168# 0.00676f
C10925 _556_/a_192_429# net67 0
C10926 tx_inst.bit_index\[1\] _341_/a_805_385# 0
C10927 _266_ _648_/a_1840_334# 0.00274f
C10928 net30 _648_/a_2250_412# 0.00829f
C10929 _253_ _236_ 0.19185f
C10930 _676_/a_1583_191# net152 0
C10931 net132 net47 0
C10932 _218_ _172_ 0
C10933 _192_ _005_ 0.12563f
C10934 net27 tx_inst.state\[2\] 0
C10935 output14/a_40_152# rx_data[2] 0
C10936 _427_/a_350_122# _161_ 0
C10937 net33 _077_ 0
C10938 _679_/a_741_93# net152 0
C10939 _679_/a_38_114# _282_ 0
C10940 _679_/a_324_432# baud_inst.counter\[4\] 0
C10941 _073_ hold179/a_56_118# 0
C10942 hold174/a_438_182# net169 0
C10943 hold174/a_326_118# _007_ 0
C10944 net44 hold102/a_438_182# 0
C10945 net51 hold62/a_56_118# 0.00499f
C10946 _443_/a_252_412# _256_ 0.00177f
C10947 _443_/a_354_412# _254_ 0.0026f
C10948 net152 _683_/a_1583_191# 0
C10949 _002_ _205_ 0
C10950 _539_/a_139_160# _307_ 0
C10951 net51 _650_/a_1489_191# 0
C10952 output16/a_40_152# net2 0
C10953 _637_/a_324_432# clknet_4_15_0_clk 0.03512f
C10954 _392_/a_496_118# _214_ 0.00441f
C10955 _170_ clknet_4_12_0_clk 0.10632f
C10956 FILLER_0_35/a_40_246# _675_/a_1583_191# 0
C10957 _175_ _664_/a_132_114# 0
C10958 VPWR net11 0.06771f
C10959 _021_ _020_ 0
C10960 _154_ _648_/a_843_236# 0
C10961 net49 _439_/a_150_412# 0
C10962 hold168/a_438_182# FILLER_5_192/a_40_246# 0.00941f
C10963 net26 _191_ 0.04862f
C10964 net12 _638_/a_1785_429# 0
C10965 clknet_0_clk baud_inst.counter\[24\] 0.01536f
C10966 _697_/a_1785_429# baud_inst.counter\[25\] 0
C10967 input3/a_40_152# input9/a_40_152# 0
C10968 hold89/a_326_118# baud_inst.counter\[13\] 0
C10969 hold89/a_438_182# _187_ 0
C10970 hold106/a_326_118# _701_/a_1489_191# 0
C10971 rx_data[0] net70 0
C10972 clkbuf_4_11_0_clk/a_27_118# baud_inst.counter\[31\] 0.01017f
C10973 _635_/a_1583_191# VPWR 0.00464f
C10974 VPWR hold70/a_438_182# 0.00483f
C10975 hold103/a_438_182# _528_/a_81_118# 0
C10976 _135_ FILLER_25_150/a_32_246# 0
C10977 _138_ _139_ 0
C10978 _094_ _288_ 0
C10979 _497_/a_170_412# baud_inst.counter\[4\] 0
C10980 _095_ baud_inst.counter\[17\] 0
C10981 _269_ _157_ 0.42403f
C10982 net14 _637_/a_38_114# 0
C10983 net124 net30 0.51413f
C10984 net45 _694_/a_132_114# 0
C10985 _232_ _139_ 0.27058f
C10986 hold55/a_438_182# net21 0.01008f
C10987 _658_/a_324_432# _387_/a_46_156# 0
C10988 _686_/a_298_337# _669_/a_298_337# 0
C10989 _009_ _688_/a_1583_191# 0
C10990 hold129/a_56_118# _182_ 0
C10991 _292_ _685_/a_1785_429# 0
C10992 _404_/a_268_412# net62 0
C10993 _694_/a_1583_191# FILLER_22_43/a_40_246# 0
C10994 _119_ net43 0.0156f
C10995 net112 _257_ 0.00146f
C10996 net16 hold73/a_56_118# 0.04144f
C10997 _705_/a_1583_191# _704_/a_1583_191# 0.00152f
C10998 _008_ VPWR 0.11335f
C10999 baud_inst.counter\[26\] net100 0.1179f
C11000 _657_/a_1785_429# VPWR 0
C11001 net27 _197_ 0.23941f
C11002 clkbuf_4_7_0_clk/a_27_118# _121_ 0
C11003 hold142/a_56_118# net141 0.06709f
C11004 hold87/a_438_182# net87 0.00247f
C11005 clk _380_/a_59_156# 0.00542f
C11006 _398_/a_115_308# clknet_0_clk 0
C11007 _158_ _633_/a_1489_191# 0.00551f
C11008 _303_ _692_/a_843_236# 0
C11009 net96 _510_/a_146_122# 0
C11010 _688_/a_1840_334# clknet_4_2_0_clk 0
C11011 rx_inst.state\[3\] _669_/a_1583_191# 0.00127f
C11012 _504_/a_474_130# _038_ 0
C11013 clkbuf_4_9_0_clk/a_27_118# _686_/a_298_337# 0.00208f
C11014 VPWR _650_/a_38_114# 0.01633f
C11015 _705_/a_1583_191# net43 0
C11016 fanout31/a_40_152# net62 0
C11017 _436_/a_550_140# _247_ 0
C11018 _436_/a_244_140# _137_ 0
C11019 _136_ _433_/a_244_140# 0
C11020 _549_/a_155_412# _165_ 0.08835f
C11021 _679_/a_550_127# net86 0
C11022 net108 _096_ 0.10776f
C11023 net105 baud_inst.counter\[29\] 0.52499f
C11024 net176 _698_/a_612_127# 0
C11025 net44 _669_/a_1785_429# 0
C11026 _138_ _648_/a_38_114# 0.02009f
C11027 _643_/a_2250_412# _632_/a_38_114# 0
C11028 clk clknet_4_6_0_clk 0.00172f
C11029 _044_ hold131/a_438_182# 0
C11030 net48 net118 0
C11031 net165 _212_ 0.0994f
C11032 _376_/a_76_160# net168 0
C11033 _376_/a_170_160# net172 0.00229f
C11034 hold55/a_56_118# _478_/a_27_156# 0
C11035 _232_ _648_/a_38_114# 0.00469f
C11036 _662_/a_843_236# clk 0.00356f
C11037 _378_/a_382_118# net7 0.00305f
C11038 hold108/a_56_118# _190_ 0
C11039 hold108/a_326_118# _189_ 0.00264f
C11040 clknet_4_10_0_clk _701_/a_38_114# 0.00786f
C11041 _409_/a_73_118# net180 0
C11042 _127_ hold70/a_438_182# 0.00581f
C11043 hold96/a_56_118# _291_ 0
C11044 _097_ _513_/a_192_429# 0
C11045 FILLER_16_176/a_40_246# net37 0.0214f
C11046 clk _218_ 0
C11047 net10 _213_ 0.01376f
C11048 net8 _209_ 0.00693f
C11049 _675_/a_612_127# clknet_4_0_0_clk 0
C11050 baud_inst.counter\[8\] net135 0.05039f
C11051 hold154/a_56_118# _089_ 0.00191f
C11052 _676_/a_38_114# _280_ 0
C11053 net49 hold107/a_326_118# 0.00131f
C11054 net35 _257_ 0.02664f
C11055 VPWR _300_ 0.20205f
C11056 hold159/a_438_182# net155 0
C11057 _234_ clknet_0_clk 0.04328f
C11058 hold124/a_326_118# net47 0.02238f
C11059 net48 hold78/a_56_118# 0.0024f
C11060 net147 _304_ 0.60143f
C11061 clkbuf_0_clk/a_116_82# _667_/a_38_114# 0
C11062 _528_/a_277_118# baud_inst.counter\[16\] 0.00239f
C11063 clknet_4_12_0_clk hold139/a_438_182# 0.00312f
C11064 baud_inst.counter\[28\] net68 0
C11065 _304_ net46 0.00527f
C11066 hold99/a_438_182# hold100/a_438_182# 0.00174f
C11067 clknet_0_clk _669_/a_2250_412# 0
C11068 net46 _099_ 0.04469f
C11069 net11 FILLER_7_234/a_32_246# 0.01342f
C11070 _555_/a_209_168# _027_ 0
C11071 _378_/a_285_412# _206_ 0.00561f
C11072 _378_/a_382_118# net155 0.03094f
C11073 VPWR _039_ 0.0992f
C11074 net166 net28 0
C11075 net92 _679_/a_298_337# 0
C11076 net94 _679_/a_38_114# 0.01828f
C11077 _652_/a_38_114# _142_ 0.02814f
C11078 _642_/a_1840_334# rx_inst.state\[2\] 0.0021f
C11079 FILLER_26_227/a_40_246# net30 0
C11080 FILLER_5_164/a_40_246# clknet_4_4_0_clk 0.02022f
C11081 hold143/a_56_118# _474_/a_22_110# 0
C11082 _064_ _652_/a_298_337# 0
C11083 net42 _652_/a_38_114# 0.07563f
C11084 hold178/a_438_182# net39 0.01458f
C11085 _693_/a_612_127# clknet_4_10_0_clk 0.00353f
C11086 hold64/a_56_118# net15 0.001f
C11087 hold179/a_56_118# net41 0.0018f
C11088 _062_ hold57/a_326_118# 0.00948f
C11089 output15/a_40_152# net16 0
C11090 net51 FILLER_12_208/a_32_246# 0.00186f
C11091 _294_ _687_/a_741_93# 0
C11092 _266_ hold70/a_438_182# 0
C11093 _314_ _701_/a_1489_191# 0.00234f
C11094 _635_/a_1840_334# net30 0
C11095 FILLER_12_171/a_40_246# _277_ 0.00162f
C11096 baud_inst.counter\[12\] _515_/a_76_160# 0.02911f
C11097 net163 clknet_4_10_0_clk 0
C11098 baud_inst.counter\[28\] hold67/a_326_118# 0.00209f
C11099 _050_ _707_/a_1583_191# 0.00148f
C11100 _513_/a_341_118# net40 0.00262f
C11101 _194_ net184 0.26648f
C11102 rx_done tx_start 0
C11103 hold152/a_326_118# _676_/a_1840_334# 0.0017f
C11104 hold152/a_438_182# _676_/a_1583_191# 0
C11105 net44 _539_/a_45_160# 0.00156f
C11106 _644_/a_38_114# rx_inst.data_reg\[1\] 0
C11107 _224_ _251_ 0
C11108 _488_/a_380_412# net29 0
C11109 _093_ hold116/a_326_118# 0
C11110 _677_/a_2250_412# net152 0.01169f
C11111 baud_inst.counter\[18\] _298_ 0
C11112 _102_ baud_inst.counter\[17\] 0
C11113 hold171/a_438_182# net55 0.00553f
C11114 VPWR _682_/a_1583_191# 0.01071f
C11115 hold116/a_438_182# _183_ 0.00884f
C11116 net44 _108_ 0.01049f
C11117 hold124/a_326_118# hold126/a_438_182# 0
C11118 net35 _420_/a_350_122# 0.00293f
C11119 _040_ VPWR 0.43842f
C11120 _017_ _530_/a_257_140# 0
C11121 hold102/a_438_182# _302_ 0
C11122 net102 _530_/a_155_412# 0
C11123 clknet_4_11_0_clk _702_/a_2002_114# 0
C11124 net120 _692_/a_38_114# 0
C11125 _186_ hold95/a_56_118# 0
C11126 rx_inst.bit_index\[2\] hold175/a_56_118# 0
C11127 clknet_4_12_0_clk hold175/a_326_118# 0
C11128 tx_data[6] _380_/a_285_118# 0
C11129 tx_inst.bit_index\[1\] hold145/a_438_182# 0
C11130 _017_ _690_/a_681_505# 0
C11131 net102 _690_/a_843_236# 0
C11132 hold87/a_326_118# _109_ 0.0175f
C11133 net37 _647_/a_843_236# 0
C11134 baud_inst.counter\[28\] _701_/a_324_432# 0.02745f
C11135 _515_/a_76_160# net88 0
C11136 _554_/a_146_122# net46 0
C11137 net66 _049_ 0
C11138 clk input3/a_40_152# 0.00277f
C11139 _153_ _157_ 0.00117f
C11140 _697_/a_1785_429# baud_inst.counter\[24\] 0
C11141 _661_/a_1840_334# VPWR 0.00207f
C11142 _645_/a_741_93# _055_ 0.0368f
C11143 _645_/a_324_432# net132 0.0037f
C11144 _645_/a_1583_191# _644_/a_1489_191# 0
C11145 VPWR _702_/a_741_93# 0.01084f
C11146 baud_inst.counter\[20\] fanout44/a_40_152# 0.01952f
C11147 _093_ net181 0
C11148 net97 _183_ 0.1264f
C11149 _677_/a_324_432# _035_ 0.00392f
C11150 hold56/a_56_118# net56 0
C11151 hold65/a_56_118# clknet_4_13_0_clk 0
C11152 net62 _168_ 1.71955f
C11153 net48 hold138/a_56_118# 0
C11154 _640_/a_2250_412# VPWR 0.01072f
C11155 net74 net84 0
C11156 VPWR _006_ 0.03634f
C11157 clk net29 0
C11158 FILLER_17_81/a_32_246# _310_ 0.01946f
C11159 net49 _694_/a_741_93# 0
C11160 baud_inst.counter\[18\] _188_ 0.04325f
C11161 _536_/a_192_429# hold148/a_438_182# 0.00962f
C11162 FILLER_6_205/a_40_246# clknet_0_clk 0.01577f
C11163 _650_/a_324_432# net30 0.04279f
C11164 _650_/a_38_114# _266_ 0
C11165 hold68/a_438_182# _551_/a_76_160# 0
C11166 hold76/a_438_182# clknet_4_10_0_clk 0
C11167 _534_/a_46_156# _303_ 0
C11168 hold53/a_326_118# _242_ 0
C11169 _345_/a_252_412# baud_inst.counter\[20\] 0
C11170 baud_inst.counter\[6\] _280_ 0
C11171 _650_/a_38_114# _167_ 0
C11172 hold124/a_326_118# net70 0
C11173 FILLER_5_156/a_32_246# _218_ 0
C11174 hold171/a_56_118# clknet_4_4_0_clk 0.00236f
C11175 _657_/a_2002_114# tx_inst.data_reg\[1\] 0
C11176 _283_ _185_ 0.377f
C11177 net133 _702_/a_38_114# 0
C11178 _424_/a_244_412# FILLER_22_175/a_32_246# 0
C11179 _389_/a_268_412# _213_ 0.00371f
C11180 _673_/a_2250_412# _181_ 0
C11181 _673_/a_1785_429# net60 0.0023f
C11182 _283_ clknet_4_0_0_clk 0
C11183 _431_/a_175_118# net25 0
C11184 _207_ net8 0
C11185 _392_/a_285_118# tx_inst.data_reg\[0\] 0
C11186 clkbuf_4_7_0_clk/a_27_118# clknet_0_clk 0.09068f
C11187 _671_/a_2250_412# _153_ 0
C11188 hold65/a_56_118# net65 0
C11189 _189_ baud_inst.counter\[14\] 0
C11190 _190_ baud_inst.counter\[15\] 0
C11191 _217_ _653_/a_2250_412# 0
C11192 net2 clknet_4_6_0_clk 0
C11193 clknet_4_7_0_clk _265_ 0
C11194 hold141/a_326_118# _309_ 0
C11195 net168 _664_/a_612_127# 0.00753f
C11196 _220_ _221_ 1.00503f
C11197 hold156/a_438_182# baud_inst.counter\[17\] 0.00376f
C11198 hold170/a_56_118# _392_/a_382_118# 0
C11199 _022_ _302_ 0.08198f
C11200 _064_ net183 0
C11201 hold161/a_438_182# _690_/a_38_114# 0
C11202 _306_ hold103/a_438_182# 0
C11203 _680_/a_324_432# hold136/a_438_182# 0
C11204 _680_/a_741_93# hold136/a_326_118# 0.00768f
C11205 _680_/a_843_236# hold136/a_56_118# 0
C11206 _363_/a_22_110# _173_ 0.0104f
C11207 _363_/a_120_432# _194_ 0
C11208 hold116/a_438_182# net115 0
C11209 _194_ net169 0.02765f
C11210 output23/a_40_152# _704_/a_741_93# 0
C11211 _636_/a_843_236# _047_ 0.03097f
C11212 _056_ _252_ 0
C11213 net161 _015_ 0
C11214 hold170/a_438_182# _071_ 0.00134f
C11215 hold110/a_326_118# baud_inst.counter\[4\] 0
C11216 _083_ VPWR 0.13287f
C11217 _703_/a_1489_191# _702_/a_2250_412# 0
C11218 net59 _702_/a_843_236# 0
C11219 baud_inst.counter\[1\] _672_/a_1583_191# 0
C11220 _233_ clknet_0_clk 0.02435f
C11221 _316_ net67 0
C11222 net28 _671_/a_324_432# 0
C11223 _483_/a_22_110# _671_/a_132_114# 0
C11224 _277_ _671_/a_38_114# 0.01874f
C11225 _004_ _671_/a_298_337# 0.00273f
C11226 tx_inst.bit_index\[1\] _341_/a_308_118# 0
C11227 net184 _341_/a_886_118# 0.00529f
C11228 _360_/a_886_118# tx_inst.bit_index\[2\] 0.00156f
C11229 _676_/a_1489_191# baud_inst.counter\[4\] 0.0114f
C11230 _013_ hold129/a_438_182# 0
C11231 tx_inst.data_reg\[7\] _339_/a_71_118# 0.00371f
C11232 net97 net115 0.00703f
C11233 VPWR FILLER_10_145/a_40_246# 0.13977f
C11234 _116_ _703_/a_741_93# 0.00915f
C11235 _244_ _161_ 0
C11236 FILLER_7_7/a_40_246# net117 0
C11237 clknet_0_clk net137 0.22287f
C11238 _186_ net40 0.00951f
C11239 _514_/a_155_412# _292_ 0.00424f
C11240 _205_ FILLER_14_148/a_40_246# 0.00299f
C11241 _046_ hold85/a_326_118# 0.01009f
C11242 net115 net86 0.00154f
C11243 _254_ _256_ 0.05858f
C11244 hold102/a_438_182# hold158/a_438_182# 0
C11245 hold172/a_56_118# _705_/a_741_93# 0
C11246 net51 rx_inst.data_reg\[7\] 0
C11247 _681_/a_741_93# net117 0.00531f
C11248 baud_inst.counter\[12\] net91 0
C11249 _677_/a_741_93# _280_ 0.00373f
C11250 _152_ _199_ 0.00495f
C11251 _010_ _291_ 0.02971f
C11252 net3 tx_data[6] 0.05201f
C11253 tx_data[0] net9 0
C11254 _110_ baud_inst.counter\[25\] 0.02515f
C11255 net121 _105_ 0
C11256 net179 _275_ 0
C11257 fanout37/a_40_152# VPWR 0.07165f
C11258 FILLER_16_154/a_32_246# _234_ 0.00556f
C11259 _109_ _296_ 0
C11260 _674_/a_741_93# hold61/a_56_118# 0
C11261 clknet_4_5_0_clk net168 1.05253f
C11262 _283_ _677_/a_681_505# 0
C11263 _642_/a_741_93# _669_/a_843_236# 0
C11264 hold103/a_326_118# net103 0
C11265 _392_/a_59_156# VPWR 0.07491f
C11266 _031_ _700_/a_298_337# 0
C11267 hold68/a_438_182# _700_/a_741_93# 0.00393f
C11268 _672_/a_843_236# VPWR 0.00567f
C11269 _246_ net49 0.02015f
C11270 _536_/a_341_118# _534_/a_46_156# 0
C11271 net14 _637_/a_1840_334# 0.00198f
C11272 net2 _253_ 0.00243f
C11273 hold97/a_56_118# _288_ 0.01554f
C11274 clkbuf_4_7_0_clk/a_27_118# _704_/a_298_337# 0
C11275 rx_done tx_busy 0.0321f
C11276 _425_/a_46_156# net24 0.05152f
C11277 _658_/a_741_93# _212_ 0.0014f
C11278 _686_/a_132_114# _669_/a_38_114# 0
C11279 _686_/a_38_114# _669_/a_132_114# 0
C11280 baud_inst.counter\[28\] hold105/a_326_118# 0
C11281 _653_/a_843_236# _142_ 0.008f
C11282 hold152/a_438_182# _677_/a_2250_412# 0
C11283 _124_ hold83/a_438_182# 0.03844f
C11284 _174_ net54 0.00725f
C11285 _064_ _653_/a_741_93# 0.00164f
C11286 net42 _653_/a_843_236# 0.001f
C11287 _217_ hold169/a_326_118# 0.00859f
C11288 _295_ _520_/a_155_412# 0.00522f
C11289 hold131/a_56_118# _472_/a_22_110# 0.0413f
C11290 _176_ VPWR 0.11223f
C11291 _705_/a_1489_191# _704_/a_1840_334# 0
C11292 hold88/a_326_118# _297_ 0.01735f
C11293 _047_ hold81/a_438_182# 0.00197f
C11294 net105 FILLER_28_53/a_32_246# 0
C11295 input8/a_40_152# _213_ 0
C11296 _068_ VPWR 0.12116f
C11297 _192_ _365_/a_257_140# 0
C11298 _386_/a_59_156# net137 0.00874f
C11299 net33 net43 0
C11300 net2 net29 0.04266f
C11301 clknet_4_13_0_clk _636_/a_1489_191# 0.01575f
C11302 clknet_4_4_0_clk clkbuf_4_5_0_clk/a_27_118# 0
C11303 tx_inst.bit_index\[2\] _653_/a_1583_191# 0
C11304 _649_/a_38_114# net127 0.03722f
C11305 _556_/a_341_118# _112_ 0
C11306 _216_ clknet_0_clk 0.00603f
C11307 net46 _685_/a_843_236# 0.0039f
C11308 _099_ _685_/a_741_93# 0
C11309 _429_/a_244_140# _244_ 0
C11310 _302_ _108_ 0.00125f
C11311 _203_ _166_ 0
C11312 net116 FILLER_8_19/a_40_246# 0.00119f
C11313 VPWR net160 0.05893f
C11314 rx_inst.state\[3\] _669_/a_2002_114# 0
C11315 hold120/a_438_182# net107 0
C11316 tx_data[4] net7 0.0246f
C11317 VPWR _650_/a_1840_334# 0.00162f
C11318 _027_ _165_ 0.01541f
C11319 _249_ _247_ 0.03729f
C11320 _049_ hold70/a_326_118# 0
C11321 _019_ _673_/a_741_93# 0
C11322 hold117/a_56_118# baud_inst.counter\[10\] 0
C11323 _518_/a_45_160# _354_/a_170_412# 0
C11324 _109_ _696_/a_298_337# 0.00982f
C11325 _174_ _364_/a_257_140# 0
C11326 _173_ _341_/a_1453_124# 0
C11327 _640_/a_38_114# net45 0.03303f
C11328 _640_/a_298_337# _111_ 0
C11329 _119_ _664_/a_2250_412# 0
C11330 _138_ _648_/a_1840_334# 0
C11331 hold101/a_326_118# baud_inst.counter\[18\] 0.00652f
C11332 net15 _467_/a_22_110# 0
C11333 _634_/a_132_114# _271_ 0
C11334 _634_/a_681_505# _124_ 0
C11335 _230_ _439_/a_252_412# 0.00114f
C11336 _489_/a_115_308# _674_/a_1583_191# 0
C11337 net79 net60 0.03226f
C11338 net142 _180_ 0
C11339 FILLER_20_57/a_32_246# _548_/a_76_160# 0.01032f
C11340 _520_/a_155_412# clknet_4_2_0_clk 0
C11341 net32 _435_/a_411_436# 0.00197f
C11342 _662_/a_612_127# clk 0.00199f
C11343 hold167/a_326_118# _191_ 0.00179f
C11344 net39 net161 0
C11345 _206_ net7 0.0275f
C11346 _547_/a_81_118# _308_ 0
C11347 clknet_4_14_0_clk _161_ 0.03485f
C11348 clknet_4_3_0_clk _685_/a_1489_191# 0
C11349 net178 clknet_4_2_0_clk 0.04534f
C11350 VPWR hold84/a_438_182# 0.00407f
C11351 hold130/a_438_182# _180_ 0.0345f
C11352 _641_/a_324_432# net100 0
C11353 _660_/a_324_432# net55 0.00114f
C11354 rx_inst.data_reg\[4\] clkbuf_4_13_0_clk/a_27_118# 0
C11355 _098_ _035_ 0.00828f
C11356 net66 _643_/a_1583_191# 0
C11357 clk _667_/a_681_505# 0
C11358 tx_inst.data_reg\[6\] _379_/a_46_156# 0
C11359 _684_/a_1583_191# net29 0
C11360 _526_/a_146_122# baud_inst.counter\[16\] 0
C11361 net54 _706_/a_1489_191# 0.01663f
C11362 _280_ _683_/a_1840_334# 0
C11363 _206_ net155 0.12377f
C11364 _544_/a_268_412# _025_ 0
C11365 net94 _679_/a_1840_334# 0.00962f
C11366 net92 _679_/a_1583_191# 0.02631f
C11367 _652_/a_2250_412# _220_ 0
C11368 _652_/a_1840_334# _142_ 0.01134f
C11369 _064_ _652_/a_1583_191# 0
C11370 net42 _652_/a_1840_334# 0.00157f
C11371 net2 hold119/a_56_118# 0
C11372 net149 clknet_4_10_0_clk 0
C11373 net37 _428_/a_354_412# 0
C11374 hold120/a_326_118# net120 0.00156f
C11375 net179 _071_ 0.00142f
C11376 _508_/a_380_412# clknet_4_2_0_clk 0
C11377 _169_ clknet_4_6_0_clk 0.10055f
C11378 _704_/a_2250_412# hold80/a_438_182# 0
C11379 net147 FILLER_22_22/a_32_246# 0.01539f
C11380 _068_ _339_/a_1023_118# 0
C11381 _189_ clkbuf_4_2_0_clk/a_27_118# 0
C11382 hold147/a_326_118# _106_ 0.00123f
C11383 _673_/a_38_114# FILLER_2_79/a_40_246# 0
C11384 fanout37/a_40_152# _266_ 0.00515f
C11385 clkbuf_4_11_0_clk/a_27_118# _177_ 0
C11386 _206_ _074_ 0
C11387 fanout41/a_40_152# _386_/a_382_118# 0
C11388 hold122/a_326_118# _667_/a_741_93# 0.00316f
C11389 hold122/a_438_182# _667_/a_324_432# 0
C11390 FILLER_13_89/a_40_246# _685_/a_612_127# 0
C11391 _639_/a_1489_191# net51 0
C11392 net26 _459_/a_27_156# 0.00295f
C11393 _216_ _666_/a_1489_191# 0
C11394 _684_/a_324_432# net40 0.0039f
C11395 _244_ clkbuf_4_14_0_clk/a_27_118# 0.03723f
C11396 _698_/a_612_127# _051_ 0
C11397 tx_inst.bit_index\[1\] _217_ 0
C11398 net183 _667_/a_1785_429# 0
C11399 clk fanout42/a_40_152# 0.00541f
C11400 _294_ hold91/a_56_118# 0
C11401 _644_/a_1840_334# rx_inst.data_reg\[1\] 0
C11402 _644_/a_612_127# _055_ -0
C11403 _233_ FILLER_16_154/a_32_246# 0
C11404 _032_ _702_/a_843_236# 0.00142f
C11405 _292_ _686_/a_1583_191# 0
C11406 _398_/a_115_308# net43 0
C11407 _004_ _205_ 0
C11408 net49 _444_/a_244_412# 0.00241f
C11409 _086_ _066_ 0
C11410 net35 _238_ 0.05958f
C11411 _659_/a_38_114# _209_ 0
C11412 _180_ baud_inst.counter\[4\] 0.00287f
C11413 baud_inst.counter\[28\] _701_/a_2250_412# 0.01364f
C11414 tx_data[6] _150_ 0
C11415 net9 _208_ 0.08764f
C11416 _017_ _690_/a_550_127# 0
C11417 net102 _690_/a_612_127# 0.00113f
C11418 hold102/a_56_118# _103_ 0.00161f
C11419 net37 _647_/a_612_127# 0
C11420 clknet_4_14_0_clk _429_/a_244_140# 0
C11421 _374_/a_142_412# FILLER_14_148/a_40_246# 0
C11422 net2 _668_/a_1583_191# 0.00287f
C11423 net48 _633_/a_298_337# 0.02229f
C11424 rx_inst.bit_index\[1\] _445_/a_165_412# 0.00201f
C11425 net80 hold81/a_326_118# 0.00229f
C11426 _110_ baud_inst.counter\[24\] 0.79792f
C11427 net142 net140 0.06194f
C11428 _645_/a_1785_429# _055_ 0
C11429 rx_inst.data_reg\[2\] _644_/a_1583_191# 0.00185f
C11430 output13/a_40_152# _264_ 0
C11431 net111 hold143/a_56_118# 0.00191f
C11432 hold115/a_56_118# _183_ 0
C11433 hold115/a_326_118# baud_inst.counter\[10\] 0
C11434 _707_/a_1840_334# hold80/a_56_118# 0
C11435 _707_/a_1583_191# hold80/a_326_118# 0.0041f
C11436 net138 _636_/a_612_127# 0
C11437 _488_/a_474_130# _086_ 0.00323f
C11438 net123 _676_/a_1583_191# 0.00142f
C11439 hold127/a_56_118# _424_/a_550_140# 0
C11440 net82 hold83/a_438_182# 0.01857f
C11441 FILLER_1_173/a_32_246# tx_inst.data_reg\[2\] 0.01381f
C11442 _022_ hold148/a_326_118# 0.00664f
C11443 _660_/a_324_432# _076_ 0
C11444 _676_/a_1840_334# _191_ 0.00536f
C11445 _650_/a_2250_412# net30 0.00716f
C11446 _650_/a_1840_334# _266_ 0.01125f
C11447 _691_/a_324_432# hold163/a_438_182# 0
C11448 clknet_0_clk _666_/a_843_236# 0.00268f
C11449 hold68/a_326_118# _314_ 0
C11450 VPWR _419_/a_154_118# 0
C11451 hold155/a_326_118# net55 0.00162f
C11452 hold177/a_56_118# clkbuf_4_8_0_clk/a_27_118# 0
C11453 net48 _057_ 0.21623f
C11454 hold111/a_56_118# clknet_0_clk 0.00175f
C11455 _674_/a_324_432# _279_ 0.00121f
C11456 _679_/a_550_127# net38 0
C11457 _640_/a_1583_191# _236_ 0
C11458 _264_ net24 0
C11459 _010_ baud_inst.counter\[4\] 0
C11460 _292_ _282_ 0.02021f
C11461 net28 _157_ 0.00101f
C11462 _177_ _547_/a_81_118# 0
C11463 _055_ _256_ 0
C11464 net32 _438_/a_350_122# 0.0028f
C11465 clknet_4_12_0_clk hold176/a_438_182# 0.06366f
C11466 FILLER_18_65/a_40_246# net44 0.00136f
C11467 hold153/a_56_118# _090_ 0.00105f
C11468 hold153/a_326_118# net39 0
C11469 _179_ _346_/a_150_412# 0
C11470 net79 _488_/a_177_436# 0.00368f
C11471 _680_/a_550_127# net136 0
C11472 _665_/a_681_505# tx_inst.state\[3\] 0
C11473 _003_ clkbuf_0_clk/a_116_82# 0.00115f
C11474 net122 clk 0.03226f
C11475 _642_/a_1583_191# FILLER_17_131/a_32_246# 0
C11476 hold122/a_438_182# _142_ 0
C11477 net168 _005_ 0.03656f
C11478 clknet_4_6_0_clk _084_ 0.01577f
C11479 net42 hold122/a_438_182# 0.0124f
C11480 clkbuf_4_6_0_clk/a_27_118# VPWR 0.07827f
C11481 _239_ _419_/a_154_118# 0
C11482 _211_ _382_/a_59_156# 0.02874f
C11483 _169_ net29 0.02886f
C11484 net44 _697_/a_324_432# 0.01041f
C11485 _680_/a_681_505# net136 0
C11486 _195_ _166_ 0.00587f
C11487 net23 _704_/a_1583_191# 0.00177f
C11488 _636_/a_612_127# _047_ 0.02181f
C11489 hold149/a_438_182# net149 0
C11490 hold156/a_56_118# _688_/a_1840_334# 0
C11491 hold156/a_326_118# _688_/a_1583_191# 0.00211f
C11492 net156 _688_/a_324_432# 0.05256f
C11493 _060_ _648_/a_324_432# 0
C11494 hold86/a_56_118# clknet_4_0_0_clk 0.00292f
C11495 _407_/a_146_122# clknet_0_clk 0
C11496 clknet_4_15_0_clk hold82/a_326_118# 0.00309f
C11497 FILLER_2_46/a_40_246# hold60/a_56_118# 0.00786f
C11498 net28 _671_/a_2250_412# 0
C11499 _277_ _671_/a_1840_334# 0
C11500 clknet_4_14_0_clk clkbuf_4_14_0_clk/a_27_118# 0.01389f
C11501 clknet_4_11_0_clk FILLER_22_86/a_32_246# 0
C11502 _661_/a_843_236# _384_/a_59_156# 0
C11503 _661_/a_741_93# _384_/a_382_118# 0.00163f
C11504 net37 _133_ 0
C11505 hold115/a_56_118# net115 0.00177f
C11506 hold174/a_56_118# _217_ 0
C11507 _293_ _292_ 0.06943f
C11508 FILLER_26_229/a_32_246# _048_ 0
C11509 _693_/a_843_236# VPWR 0.01443f
C11510 _046_ _635_/a_550_127# 0
C11511 hold165/a_326_118# _656_/a_324_432# 0.00102f
C11512 _510_/a_350_122# _287_ 0
C11513 baud_inst.counter\[4\] baud_inst.counter\[11\] 0.01581f
C11514 _360_/a_71_118# net41 0.00309f
C11515 _681_/a_1840_334# baud_inst.counter\[9\] 0.00319f
C11516 _685_/a_741_93# _685_/a_843_236# 0
C11517 clknet_4_12_0_clk hold180/a_326_118# 0
C11518 rx_inst.bit_index\[2\] hold180/a_56_118# 0
C11519 _697_/a_38_114# clknet_0_clk 0.00613f
C11520 net14 hold82/a_56_118# 0.04962f
C11521 _114_ net49 1.38353f
C11522 _206_ _201_ 0.01673f
C11523 hold63/a_56_118# _079_ 0.09757f
C11524 _363_/a_22_110# FILLER_4_172/a_32_246# 0
C11525 clknet_0_clk _453_/a_170_412# 0
C11526 net23 _707_/a_843_236# 0
C11527 output23/a_40_152# _707_/a_1583_191# 0
C11528 _689_/a_741_93# _689_/a_843_236# -0
C11529 _294_ _515_/a_170_160# 0
C11530 _012_ _515_/a_76_160# 0
C11531 _072_ net159 0.00191f
C11532 _276_ VPWR 0.07653f
C11533 _642_/a_612_127# _669_/a_741_93# 0
C11534 _642_/a_1583_191# _669_/a_1583_191# 0
C11535 FILLER_4_183/a_40_246# _481_/a_22_110# 0
C11536 baud_inst.counter\[8\] hold116/a_56_118# 0.01526f
C11537 net44 FILLER_17_94/a_40_246# 0.00594f
C11538 net35 net36 0.92052f
C11539 _672_/a_612_127# VPWR 0
C11540 _227_ VPWR 0.25346f
C11541 net120 net148 0.00963f
C11542 output20/a_40_152# _704_/a_1583_191# 0
C11543 _118_ hold50/a_438_182# 0.00572f
C11544 VPWR hold94/a_326_118# 0.00543f
C11545 _304_ _692_/a_324_432# 0
C11546 net147 _692_/a_741_93# 0
C11547 _658_/a_612_127# net5 0
C11548 net128 fanout29/a_40_152# 0.00392f
C11549 FILLER_15_162/a_40_246# net49 0
C11550 _264_ FILLER_27_210/a_40_246# 0
C11551 _653_/a_612_127# _142_ 0.00174f
C11552 _637_/a_741_93# hold82/a_56_118# 0
C11553 _637_/a_324_432# hold82/a_326_118# 0
C11554 _385_/a_268_412# _209_ 0
C11555 clkbuf_4_7_0_clk/a_27_118# net43 0.08055f
C11556 _295_ _297_ 0.10897f
C11557 _555_/a_209_168# net49 0.00378f
C11558 _183_ net38 0
C11559 _080_ _667_/a_132_114# 0
C11560 net100 FILLER_20_106/a_32_246# 0
C11561 net94 _506_/a_155_412# 0.00646f
C11562 net22 _704_/a_1840_334# 0
C11563 _659_/a_38_114# clknet_4_4_0_clk 0
C11564 clknet_4_3_0_clk FILLER_8_118/a_32_246# 0
C11565 VPWR hold62/a_438_182# 0.00345f
C11566 _303_ net164 0
C11567 _215_ _666_/a_741_93# 0.00202f
C11568 net29 _084_ 0.07803f
C11569 net49 net40 0.02691f
C11570 _099_ _685_/a_1785_429# 0
C11571 _691_/a_38_114# hold104/a_438_182# 0
C11572 _691_/a_741_93# hold104/a_56_118# 0.00713f
C11573 _691_/a_324_432# hold104/a_326_118# 0
C11574 _672_/a_324_432# _181_ 0.02066f
C11575 _672_/a_741_93# net60 0.00633f
C11576 net55 FILLER_6_98/a_40_246# 0
C11577 _639_/a_324_432# net30 0
C11578 rx_inst.state\[2\] _450_/a_127_96# 0
C11579 _248_ net37 0.02309f
C11580 _637_/a_298_337# net72 0.01089f
C11581 _637_/a_38_114# _048_ 0.00823f
C11582 net37 fanout43/a_40_152# 0.03369f
C11583 hold121/a_438_182# baud_inst.counter\[23\] 0
C11584 _313_ _700_/a_298_337# 0.00236f
C11585 net41 input9/a_40_152# 0
C11586 _173_ _341_/a_1377_160# 0.00188f
C11587 net94 _292_ 0
C11588 net87 baud_inst.counter\[15\] 0.46946f
C11589 clkbuf_4_11_0_clk/a_27_118# VPWR 0.06263f
C11590 _640_/a_1840_334# net45 0
C11591 _199_ net168 0
C11592 _175_ _197_ 0.11953f
C11593 FILLER_8_63/a_40_246# _683_/a_324_432# 0
C11594 hold56/a_326_118# _274_ 0
C11595 hold131/a_56_118# _059_ 0
C11596 net41 _653_/a_38_114# 0
C11597 net48 FILLER_23_186/a_40_246# 0.01535f
C11598 _178_ _693_/a_2250_412# 0
C11599 baud_inst.counter\[21\] _699_/a_298_337# 0
C11600 net55 _387_/a_268_412# 0
C11601 _659_/a_843_236# net137 0
C11602 net44 _517_/a_380_412# 0
C11603 _230_ _251_ 0.00727f
C11604 FILLER_20_57/a_32_246# _312_ 0
C11605 hold131/a_56_118# _159_ 0.00387f
C11606 _073_ clk 0
C11607 net43 net137 0.04684f
C11608 _297_ clknet_4_2_0_clk 0
C11609 net122 net2 0.00299f
C11610 _420_/a_248_122# _238_ 0
C11611 FILLER_16_176/a_40_246# net26 0
C11612 FILLER_12_46/a_32_246# net40 0.00144f
C11613 net48 net80 0.01154f
C11614 baud_inst.counter\[12\] clkbuf_4_8_0_clk/a_27_118# 0
C11615 _159_ net47 0.0023f
C11616 _649_/a_324_432# _648_/a_741_93# 0
C11617 baud_inst.counter\[28\] baud_inst.counter\[29\] 0.21224f
C11618 _649_/a_741_93# _648_/a_324_432# 0
C11619 _660_/a_2250_412# net55 0.00128f
C11620 _358_/a_166_436# _190_ 0.00628f
C11621 clknet_4_12_0_clk _247_ 0
C11622 _164_ _690_/a_298_337# 0
C11623 _302_ _690_/a_38_114# 0
C11624 FILLER_16_176/a_40_246# net32 0
C11625 VPWR _388_/a_382_118# 0.00298f
C11626 _119_ FILLER_5_213/a_32_246# 0
C11627 _095_ _508_/a_209_168# 0
C11628 clk _667_/a_550_127# 0
C11629 _180_ _686_/a_1489_191# 0
C11630 hold114/a_326_118# clknet_0_clk 0
C11631 net35 FILLER_19_132/a_40_246# 0
C11632 _680_/a_612_127# clknet_4_0_0_clk 0.0025f
C11633 VPWR hold50/a_56_118# 0.00413f
C11634 FILLER_15_185/a_32_246# FILLER_14_185/a_32_246# 0
C11635 net54 _042_ 0.20431f
C11636 _017_ net158 0
C11637 _125_ rx_data[4] 0
C11638 net136 VPWR 0.15271f
C11639 _283_ _679_/a_1489_191# 0
C11640 net92 _679_/a_2002_114# 0
C11641 net115 net38 0.00638f
C11642 rx_inst.bit_index\[2\] _229_ 0
C11643 FILLER_8_92/a_32_246# hold92/a_438_182# 0.00985f
C11644 baud_inst.counter\[16\] _288_ 0
C11645 _691_/a_298_337# _104_ 0.03252f
C11646 _076_ _664_/a_38_114# 0.01008f
C11647 clkbuf_4_8_0_clk/a_27_118# net88 0
C11648 net37 _245_ 0.01377f
C11649 _546_/a_192_429# net46 0.00819f
C11650 _657_/a_324_432# _148_ 0
C11651 net98 VPWR 0.23777f
C11652 VPWR _547_/a_81_118# 0.01442f
C11653 _680_/a_843_236# clknet_4_0_0_clk 0.04518f
C11654 _706_/a_132_114# VPWR 0
C11655 _168_ net19 0
C11656 clknet_0_clk FILLER_18_210/a_32_246# 0
C11657 _684_/a_2250_412# net40 0.00349f
C11658 _642_/a_38_114# net46 0
C11659 hold182/a_438_182# _089_ 0
C11660 _055_ net132 0.0076f
C11661 _045_ _633_/a_843_236# 0.00152f
C11662 _660_/a_132_114# tx_inst.data_reg\[2\] 0
C11663 _556_/a_155_160# _115_ 0
C11664 hold131/a_56_118# _155_ 0
C11665 _032_ _702_/a_612_127# 0
C11666 net58 _702_/a_1489_191# 0
C11667 _143_ _659_/a_741_93# 0
C11668 hold152/a_56_118# clknet_4_3_0_clk 0.00367f
C11669 _113_ _700_/a_843_236# 0.0016f
C11670 _080_ net37 0.00518f
C11671 FILLER_4_100/a_40_246# clknet_4_1_0_clk 0.00341f
C11672 _202_ _201_ 0.04872f
C11673 hold173/a_326_118# _216_ 0.00105f
C11674 _216_ net43 0
C11675 hold166/a_56_118# clknet_0_clk 0
C11676 input6/a_40_152# net38 0
C11677 hold158/a_438_182# _689_/a_298_337# 0
C11678 hold158/a_326_118# _689_/a_38_114# 0
C11679 FILLER_18_160/a_32_246# net49 0
C11680 _155_ net47 0.15572f
C11681 _116_ _556_/a_192_429# 0
C11682 _662_/a_38_114# _206_ 0
C11683 hold96/a_326_118# _286_ 0.01089f
C11684 net46 _686_/a_38_114# 0.0338f
C11685 _099_ _686_/a_298_337# 0.02133f
C11686 net37 net139 0
C11687 _260_ net26 0
C11688 rx_inst.bit_index\[1\] _257_ 0.1457f
C11689 net36 _254_ 0.00124f
C11690 rx_inst.bit_index\[1\] _256_ 0
C11691 _699_/a_1583_191# _699_/a_2250_412# 0
C11692 _699_/a_741_93# _699_/a_1489_191# -0
C11693 rx_done rx_data[7] 0.03501f
C11694 rx_inst.data_reg\[2\] _644_/a_2002_114# 0
C11695 VPWR _115_ 0.36576f
C11696 _227_ _225_ 0
C11697 _707_/a_2250_412# net80 0.00117f
C11698 _260_ net32 0
C11699 _262_ _131_ 0.08089f
C11700 _662_/a_298_337# _074_ 0.00296f
C11701 net49 _107_ 0.37983f
C11702 _180_ _703_/a_38_114# 0
C11703 clknet_0_clk _685_/a_132_114# 0
C11704 _671_/a_38_114# net62 0
C11705 _671_/a_298_337# _168_ 0.0019f
C11706 _061_ _000_ 0.00756f
C11707 net166 _223_ 0
C11708 fanout34/a_40_152# VPWR 0.01269f
C11709 _079_ clknet_0_clk 0.00164f
C11710 _651_/a_681_505# clknet_4_6_0_clk 0
C11711 _163_ net160 0
C11712 FILLER_13_68/a_40_246# VPWR 0.14388f
C11713 fanout42/a_40_152# _169_ 0
C11714 hold54/a_56_118# net11 0
C11715 hold67/a_56_118# VPWR 0.04683f
C11716 clknet_4_3_0_clk net38 0
C11717 _676_/a_324_432# VPWR 0.00354f
C11718 _669_/a_550_127# clknet_4_9_0_clk 0
C11719 net44 _302_ 3.92716f
C11720 VPWR FILLER_8_238/a_32_246# 0.05657f
C11721 baud_inst.counter\[21\] _105_ 0
C11722 net39 _036_ 0
C11723 _062_ hold122/a_56_118# 0
C11724 hold101/a_56_118# hold157/a_56_118# 0
C11725 net44 _690_/a_1840_334# 0
C11726 _696_/a_843_236# net162 0
C11727 _242_ VPWR 0.3282f
C11728 net32 _252_ 0.06337f
C11729 baud_inst.counter\[26\] net113 0.00204f
C11730 baud_inst.counter\[13\] net29 0.33383f
C11731 _639_/a_1840_334# VPWR 0.00124f
C11732 _226_ _450_/a_127_96# 0
C11733 _118_ net172 0
C11734 _061_ _647_/a_38_114# 0
C11735 _109_ _294_ 0.00227f
C11736 rx_inst.state\[2\] _435_/a_72_436# 0
C11737 _155_ hold126/a_438_182# 0.00192f
C11738 _195_ _651_/a_1583_191# 0
C11739 VPWR _683_/a_324_432# 0
C11740 net79 _019_ 0.0516f
C11741 tx_inst.data_reg\[0\] _200_ 0
C11742 tx_data[1] tx_data[4] 0.00152f
C11743 _245_ _134_ 0
C11744 _244_ _154_ 0.03338f
C11745 net143 _057_ 0.00237f
C11746 _460_/a_22_110# _668_/a_741_93# 0
C11747 _675_/a_1840_334# _504_/a_209_168# 0
C11748 net30 _264_ 6.87603f
C11749 VPWR _701_/a_38_114# 0.00469f
C11750 _284_ _676_/a_298_337# 0
C11751 baud_inst.counter\[18\] _528_/a_81_118# 0.00662f
C11752 clk net41 0.13442f
C11753 net40 _681_/a_324_432# 0.0017f
C11754 rx_inst.bit_index\[1\] fanout24/a_40_152# 0.04759f
C11755 fanout26/a_40_152# clknet_0_clk 0
C11756 net44 _697_/a_2250_412# 0.00679f
C11757 _693_/a_132_114# _106_ 0
C11758 hold161/a_56_118# _103_ 0
C11759 net152 net137 0
C11760 _349_/a_350_122# net86 0
C11761 _173_ _195_ 0.00139f
C11762 tx_done _704_/a_1489_191# 0
C11763 _447_/a_379_118# _223_ 0.00244f
C11764 net179 _706_/a_681_505# 0
C11765 _285_ _183_ 0
C11766 net156 _688_/a_2250_412# 0.0074f
C11767 _672_/a_843_236# FILLER_0_56/a_32_246# 0
C11768 net128 _513_/a_341_118# 0
C11769 hold63/a_326_118# net166 0
C11770 _060_ _648_/a_2250_412# 0
C11771 _112_ net45 0.10624f
C11772 _395_/a_248_122# clknet_0_clk 0
C11773 _519_/a_81_118# _684_/a_324_432# 0
C11774 _264_ _647_/a_324_432# 0
C11775 net37 _041_ 0.00162f
C11776 _155_ net70 0
C11777 net182 baud_inst.counter\[13\] 0.04029f
C11778 _257_ FILLER_22_152/a_32_246# 0
C11779 _661_/a_324_432# net171 0
C11780 net129 VPWR 0.04082f
C11781 fanout30/a_40_152# net119 0
C11782 _538_/a_81_118# _538_/a_379_118# -0
C11783 _678_/a_843_236# hold92/a_326_118# 0
C11784 _678_/a_741_93# hold92/a_438_182# 0.00357f
C11785 _180_ _687_/a_1583_191# 0
C11786 _550_/a_380_412# _701_/a_741_93# 0
C11787 _693_/a_612_127# VPWR 0.0044f
C11788 net42 _075_ 0.60304f
C11789 rx_inst.state\[3\] _278_ 0.07518f
C11790 _118_ hold55/a_326_118# 0
C11791 _644_/a_741_93# _159_ 0.01276f
C11792 FILLER_21_175/a_32_246# VPWR 0.07942f
C11793 _291_ _287_ 0.03119f
C11794 net122 _169_ 0.21795f
C11795 net163 VPWR 0.3597f
C11796 _360_/a_1109_431# net41 0
C11797 _223_ _436_/a_142_412# 0.00174f
C11798 _697_/a_1840_334# clknet_0_clk 0.00687f
C11799 FILLER_22_133/a_40_246# _454_/a_155_412# 0
C11800 tx_busy _704_/a_324_432# 0.05089f
C11801 _552_/a_155_412# net105 0.02067f
C11802 hold108/a_326_118# clknet_0_clk 0.01765f
C11803 hold69/a_326_118# VPWR 0.00609f
C11804 hold140/a_56_118# hold99/a_326_118# 0.00145f
C11805 clknet_4_12_0_clk baud_inst.counter\[25\] 0.03032f
C11806 hold118/a_56_118# clknet_4_13_0_clk 0.01959f
C11807 _132_ _669_/a_741_93# 0.00218f
C11808 _312_ _546_/a_435_412# 0
C11809 net43 _666_/a_843_236# 0
C11810 clkbuf_0_clk/a_116_82# _670_/a_1489_191# 0
C11811 _645_/a_324_432# _159_ 0.03168f
C11812 _060_ net124 0
C11813 VPWR FILLER_16_203/a_32_246# 0.09186f
C11814 _424_/a_142_412# _139_ -0
C11815 net49 _441_/a_154_118# 0
C11816 tx_inst.bit_index\[1\] _657_/a_1583_191# 0
C11817 _135_ _440_/a_142_412# 0.02338f
C11818 net55 _654_/a_843_236# 0.0262f
C11819 _651_/a_324_432# _220_ 0
C11820 _651_/a_38_114# _142_ 0.00109f
C11821 _486_/a_494_160# net26 0
C11822 clknet_4_12_0_clk rx_inst.data_reg\[4\] 0
C11823 _499_/a_380_412# _185_ 0.00702f
C11824 _036_ _352_/a_46_156# 0.00145f
C11825 net147 _692_/a_1785_429# 0
C11826 _069_ _212_ 0
C11827 net42 _651_/a_38_114# 0.00138f
C11828 _139_ _649_/a_612_127# 0
C11829 _663_/a_843_236# net27 0
C11830 _227_ _486_/a_358_436# 0
C11831 _231_ _486_/a_115_308# 0.01021f
C11832 net55 _664_/a_1840_334# 0
C11833 _671_/a_324_432# _223_ 0
C11834 _170_ _236_ 0
C11835 net94 _289_ 0
C11836 FILLER_10_14/a_40_246# _689_/a_324_432# 0
C11837 net26 fanout27/a_40_152# 0.00227f
C11838 output22/a_40_152# _707_/a_741_93# 0
C11839 fanout30/a_40_152# _433_/a_244_412# 0
C11840 baud_inst.counter\[6\] hold93/a_438_182# 0
C11841 tx_busy net19 0
C11842 rx_data[4] _129_ 0
C11843 _113_ _314_ 0
C11844 _444_/a_142_412# _254_ 0
C11845 hold76/a_438_182# VPWR 0.00929f
C11846 clknet_4_13_0_clk net64 0.0351f
C11847 _659_/a_1840_334# clknet_4_4_0_clk 0.0297f
C11848 _501_/a_154_118# _289_ 0
C11849 hold141/a_326_118# clknet_0_clk 0.00107f
C11850 _383_/a_46_156# _209_ 0.02871f
C11851 _691_/a_843_236# net104 0
C11852 clknet_4_14_0_clk _154_ 0.04208f
C11853 _203_ FILLER_5_192/a_40_246# 0
C11854 _672_/a_2250_412# _181_ 0.00667f
C11855 net179 net50 0.00179f
C11856 _639_/a_1840_334# _266_ 0
C11857 _639_/a_2250_412# net30 0
C11858 hold97/a_56_118# clknet_4_2_0_clk 0
C11859 _081_ net62 0
C11860 _174_ VPWR 0.15013f
C11861 _215_ clkbuf_4_5_0_clk/a_27_118# 0
C11862 _695_/a_1489_191# clknet_4_10_0_clk 0.00797f
C11863 hold175/a_438_182# _260_ 0
C11864 _707_/a_324_432# _121_ 0.03129f
C11865 _270_ net84 0.14735f
C11866 _045_ output14/a_40_152# 0.00186f
C11867 net20 _707_/a_1840_334# 0
C11868 rx_done _707_/a_1583_191# 0.00334f
C11869 net55 FILLER_3_207/a_40_246# 0
C11870 _118_ _705_/a_843_236# 0.03146f
C11871 net140 _687_/a_1583_191# 0
C11872 _040_ hold54/a_56_118# 0.05715f
C11873 _691_/a_741_93# _020_ 0
C11874 _691_/a_681_505# net163 0
C11875 hold108/a_326_118# _182_ 0.00124f
C11876 _671_/a_324_432# _240_ 0
C11877 net73 VPWR 0.01718f
C11878 net49 FILLER_17_160/a_40_246# 0.00122f
C11879 _092_ _037_ 0.00867f
C11880 net18 hold70/a_438_182# 0
C11881 _658_/a_1583_191# FILLER_3_150/a_40_246# 0.00238f
C11882 clknet_4_4_0_clk _664_/a_132_114# 0
C11883 clknet_4_7_0_clk _668_/a_2250_412# 0
C11884 rx_inst.data_reg\[1\] _272_ 0
C11885 FILLER_5_164/a_40_246# hold173/a_438_182# 0
C11886 _205_ _168_ 0
C11887 hold74/a_56_118# _061_ 0
C11888 net65 net64 0
C11889 net122 _084_ 0
C11890 hold105/a_56_118# VPWR 0.00684f
C11891 net184 _208_ 0.00293f
C11892 _677_/a_843_236# VPWR 0.00247f
C11893 FILLER_19_77/a_32_246# net46 0.0012f
C11894 _649_/a_843_236# _648_/a_1840_334# 0
C11895 net10 net38 0.00544f
C11896 tx_inst.data_reg\[3\] _653_/a_741_93# 0
C11897 hold167/a_438_182# VPWR 0.00709f
C11898 _640_/a_38_114# _051_ 0.03906f
C11899 clknet_4_11_0_clk _180_ 0.02548f
C11900 _018_ _690_/a_681_505# 0
C11901 _164_ _690_/a_1583_191# 0.00183f
C11902 _302_ _690_/a_1840_334# 0
C11903 _686_/a_298_337# _685_/a_843_236# 0
C11904 _690_/a_1583_191# _690_/a_2250_412# 0
C11905 _341_/a_1377_160# FILLER_4_172/a_32_246# 0.01171f
C11906 baud_inst.counter\[7\] _162_ 0
C11907 FILLER_12_128/a_40_246# _670_/a_2250_412# 0
C11908 clknet_4_8_0_clk net46 1.78746f
C11909 FILLER_2_81/a_32_246# _066_ 0.00135f
C11910 _696_/a_1489_191# VPWR 0
C11911 net49 _427_/a_350_122# 0
C11912 net37 FILLER_14_185/a_32_246# 0
C11913 _013_ clknet_0_clk 0.01102f
C11914 clknet_4_14_0_clk fanout36/a_40_152# 0.00601f
C11915 net179 _367_/a_170_412# 0
C11916 hold179/a_438_182# net168 0
C11917 _285_ clknet_4_3_0_clk 0.08944f
C11918 _283_ baud_inst.counter\[7\] 0.18713f
C11919 _284_ _677_/a_324_432# 0
C11920 net29 _502_/a_279_412# 0
C11921 hold74/a_326_118# _264_ 0.00688f
C11922 _646_/a_843_236# _057_ 0.00185f
C11923 _206_ _380_/a_285_118# 0.00211f
C11924 clknet_4_4_0_clk _212_ 0.00167f
C11925 _198_ _664_/a_843_236# 0
C11926 _095_ VPWR 0.19059f
C11927 FILLER_12_0/a_32_246# _525_/a_46_156# 0.0073f
C11928 clknet_4_14_0_clk hold125/a_438_182# 0
C11929 _252_ FILLER_25_150/a_32_246# 0
C11930 baud_inst.counter\[14\] clknet_0_clk 0.11889f
C11931 hold69/a_438_182# net30 0.00487f
C11932 hold144/a_56_118# hold139/a_326_118# 0
C11933 _706_/a_1489_191# VPWR 0.00163f
C11934 _517_/a_474_130# _013_ 0
C11935 _041_ _667_/a_1489_191# 0
C11936 net26 FILLER_15_127/a_32_246# 0
C11937 _305_ _106_ 0
C11938 net79 FILLER_6_54/a_32_246# 0
C11939 _134_ _255_ 0.03486f
C11940 hold140/a_438_182# VPWR 0.0034f
C11941 hold60/a_438_182# _085_ 0
C11942 _484_/a_154_118# net43 0
C11943 FILLER_16_203/a_32_246# _266_ 0.0041f
C11944 _155_ _649_/a_324_432# 0
C11945 _045_ _633_/a_612_127# 0
C11946 net124 _649_/a_741_93# 0.00117f
C11947 _116_ FILLER_23_83/a_32_246# 0
C11948 net45 _693_/a_741_93# 0.00177f
C11949 net97 clknet_0_clk 0
C11950 _517_/a_474_130# baud_inst.counter\[14\] 0
C11951 _113_ _700_/a_612_127# 0.00146f
C11952 _542_/a_155_412# _308_ 0.09991f
C11953 clkbuf_4_12_0_clk/a_27_118# _133_ 0
C11954 net92 _351_/a_46_156# 0
C11955 _705_/a_324_432# VPWR 0
C11956 clknet_0_clk net86 0
C11957 FILLER_7_9/a_32_246# FILLER_7_7/a_40_246# 0.0524f
C11958 _116_ _316_ 0
C11959 clknet_0_clk _386_/a_496_118# 0.00128f
C11960 net46 _686_/a_1840_334# 0
C11961 _099_ _686_/a_1583_191# 0
C11962 _697_/a_38_114# _110_ 0.01783f
C11963 _697_/a_298_337# net142 0.00193f
C11964 _021_ net147 0.0183f
C11965 hold67/a_326_118# _032_ 0
C11966 _021_ net46 0.17229f
C11967 _699_/a_681_505# net114 0
C11968 _638_/a_681_505# _264_ 0
C11969 _461_/a_120_432# _264_ 0.0019f
C11970 hold113/a_438_182# net99 0.00213f
C11971 hold113/a_56_118# baud_inst.counter\[25\] 0
C11972 _449_/a_27_156# hold180/a_326_118# 0
C11973 _117_ clknet_4_7_0_clk 0.23194f
C11974 hold152/a_56_118# baud_inst.counter\[5\] 0.03983f
C11975 _671_/a_1840_334# net62 0
C11976 clknet_0_clk _685_/a_1489_191# 0.00505f
C11977 _671_/a_1583_191# _168_ 0.00757f
C11978 net106 net49 0.00186f
C11979 hold142/a_56_118# hold100/a_56_118# 0
C11980 _068_ clkbuf_4_1_0_clk/a_27_118# 0
C11981 tx_start net21 0.00345f
C11982 _651_/a_550_127# clknet_4_6_0_clk 0
C11983 _296_ _684_/a_843_236# 0
C11984 _097_ _187_ 0
C11985 _282_ net135 0
C11986 baud_inst.counter\[4\] _287_ 0.00197f
C11987 _659_/a_324_432# clknet_0_clk 0
C11988 FILLER_8_116/a_40_246# net137 0.00177f
C11989 _676_/a_2250_412# VPWR 0.00444f
C11990 _270_ _635_/a_741_93# 0.0022f
C11991 FILLER_9_70/a_40_246# hold95/a_326_118# 0
C11992 net94 hold181/a_438_182# 0
C11993 _269_ net30 0.02538f
C11994 net48 FILLER_26_141/a_40_246# 0
C11995 hold147/a_438_182# net49 0.04878f
C11996 _073_ _665_/a_324_432# 0.00541f
C11997 VPWR _683_/a_2250_412# 0.00193f
C11998 _237_ _236_ 0.85653f
C11999 hold165/a_56_118# net55 0
C12000 hold172/a_438_182# net55 0.03971f
C12001 _240_ _636_/a_2250_412# 0
C12002 _314_ hold114/a_326_118# 0
C12003 _348_/a_146_122# net86 0.0027f
C12004 hold184/a_56_118# net183 0
C12005 baud_inst.counter\[13\] _493_/a_45_160# 0
C12006 baud_inst.counter\[30\] hold68/a_438_182# 0
C12007 net49 _702_/a_132_114# 0
C12008 _675_/a_1583_191# _038_ 0
C12009 _675_/a_2250_412# net135 0
C12010 _129_ _668_/a_843_236# 0
C12011 net34 net57 0
C12012 _231_ clkbuf_0_clk/a_116_82# 0
C12013 _640_/a_550_127# net49 0
C12014 VPWR _701_/a_1840_334# 0
C12015 net97 _182_ 0
C12016 net118 VPWR 0.15356f
C12017 hold164/a_438_182# _304_ 0
C12018 clkbuf_4_12_0_clk/a_27_118# _248_ 0
C12019 _259_ _223_ 1.04159f
C12020 _182_ net86 0.70026f
C12021 _006_ _665_/a_298_337# 0
C12022 _275_ _665_/a_38_114# 0.00942f
C12023 _082_ _642_/a_741_93# 0
C12024 net44 _642_/a_843_236# 0
C12025 FILLER_26_35/a_32_246# clknet_4_10_0_clk 0
C12026 net179 _706_/a_550_127# 0
C12027 _284_ _683_/a_1583_191# 0
C12028 _234_ net51 0.00739f
C12029 _295_ _011_ 0.00132f
C12030 baud_inst.counter\[12\] _684_/a_741_93# 0
C12031 net128 _684_/a_324_432# 0
C12032 _264_ _647_/a_2250_412# 0
C12033 FILLER_24_229/a_32_246# _638_/a_843_236# 0.00105f
C12034 _206_ net3 0.4307f
C12035 hold88/a_326_118# _684_/a_1583_191# 0
C12036 net51 _669_/a_2250_412# 0
C12037 _523_/a_155_412# net160 0.05905f
C12038 FILLER_17_94/a_40_246# _686_/a_843_236# 0
C12039 _000_ _156_ 0
C12040 fanout46/a_40_152# VPWR 0.05739f
C12041 clknet_4_1_0_clk net171 0
C12042 _072_ _384_/a_382_118# 0
C12043 _661_/a_1583_191# _148_ 0.04544f
C12044 _661_/a_2250_412# net171 0.00192f
C12045 hold113/a_326_118# _180_ 0.03125f
C12046 tx_inst.data_reg\[7\] _172_ 0
C12047 VPWR _102_ 0.28836f
C12048 _538_/a_81_118# _306_ 0
C12049 hold78/a_56_118# VPWR 0.03095f
C12050 _659_/a_38_114# _386_/a_382_118# 0
C12051 _659_/a_324_432# _386_/a_59_156# 0
C12052 tx_inst.state\[4\] clknet_0_clk 0.04089f
C12053 net44 _686_/a_843_236# 0.00515f
C12054 net149 VPWR 0.03938f
C12055 hold154/a_56_118# net40 0.02562f
C12056 _546_/a_155_160# clknet_0_clk 0
C12057 hold165/a_56_118# _067_ 0
C12058 net55 _655_/a_843_236# 0.01202f
C12059 net10 _655_/a_741_93# 0.00109f
C12060 _376_/a_76_160# _198_ 0
C12061 _644_/a_1785_429# _159_ 0
C12062 _055_ _444_/a_142_412# 0
C12063 baud_inst.counter\[27\] _695_/a_1840_334# 0
C12064 baud_inst.counter\[26\] _695_/a_1583_191# 0
C12065 baud_inst.counter\[20\] net45 0.0302f
C12066 clknet_4_8_0_clk _313_ 0.23238f
C12067 _685_/a_324_432# clknet_4_9_0_clk 0.01058f
C12068 _223_ _157_ 0.00214f
C12069 FILLER_22_133/a_40_246# _263_ 0.00363f
C12070 _704_/a_324_432# _704_/a_741_93# 0
C12071 fanout32/a_40_152# _241_ 0
C12072 _156_ _647_/a_38_114# 0.00145f
C12073 net42 _206_ 0.00195f
C12074 tx_busy _704_/a_2250_412# 0.00782f
C12075 _684_/a_741_93# net88 0
C12076 rx _639_/a_298_337# 0
C12077 _642_/a_741_93# clknet_0_clk 0.00401f
C12078 _663_/a_132_114# net26 0
C12079 _315_ net105 0.56276f
C12080 _011_ clknet_4_2_0_clk 0.09834f
C12081 _671_/a_741_93# clknet_0_clk 0.00747f
C12082 _684_/a_298_337# clknet_4_2_0_clk 0.00135f
C12083 _079_ net43 0.09872f
C12084 _132_ _669_/a_1785_429# 0
C12085 _312_ _026_ 0
C12086 _645_/a_2250_412# _159_ 0.01286f
C12087 hold64/a_438_182# net12 0.00238f
C12088 net16 rx_data[4] 3.0065f
C12089 net15 hold84/a_56_118# 0.0913f
C12090 clknet_0_clk _686_/a_741_93# 0.00862f
C12091 _246_ net25 1.30824f
C12092 net34 _400_/a_341_118# 0.01475f
C12093 _229_ _449_/a_229_118# 0
C12094 _135_ _158_ 0.17994f
C12095 _447_/a_81_118# _447_/a_379_118# -0
C12096 net55 _654_/a_612_127# 0.00571f
C12097 _057_ FILLER_17_201/a_32_246# 0
C12098 net49 _693_/a_298_337# 0
C12099 _646_/a_324_432# FILLER_21_192/a_40_246# 0
C12100 net42 _651_/a_1840_334# 0
C12101 _139_ net127 0
C12102 _240_ _157_ 0.17664f
C12103 _663_/a_612_127# net27 0
C12104 baud_inst.counter\[13\] _670_/a_741_93# 0.00113f
C12105 hold56/a_438_182# net57 0
C12106 FILLER_26_88/a_40_246# hold59/a_56_118# 0.00786f
C12107 net26 _409_/a_73_118# 0.01515f
C12108 _551_/a_272_160# net105 0
C12109 tx_inst.data_reg\[6\] _146_ 0
C12110 net39 _684_/a_741_93# 0
C12111 input8/a_40_152# net38 0
C12112 VPWR _350_/a_165_412# 0
C12113 clkbuf_4_2_0_clk/a_27_118# clknet_0_clk 0.07029f
C12114 _639_/a_324_432# hold73/a_56_118# 0
C12115 _639_/a_38_114# hold73/a_326_118# 0
C12116 _159_ _254_ 0
C12117 hold148/a_326_118# _302_ 0.00796f
C12118 clkbuf_4_5_0_clk/a_27_118# _664_/a_741_93# 0
C12119 net11 _665_/a_1583_191# 0.00112f
C12120 _691_/a_612_127# net104 0.00291f
C12121 hold138/a_56_118# VPWR 0.00876f
C12122 _206_ _657_/a_681_505# 0
C12123 _678_/a_38_114# net29 0
C12124 _690_/a_324_432# baud_inst.counter\[17\] 0.01594f
C12125 net32 _442_/a_350_122# 0
C12126 _658_/a_324_432# VPWR 0.00424f
C12127 net94 net135 0.19909f
C12128 hold156/a_438_182# VPWR 0.00486f
C12129 net26 fanout43/a_40_152# 0
C12130 _288_ _681_/a_1583_191# 0
C12131 _501_/a_154_118# net135 0
C12132 net173 _396_/a_155_412# 0.01139f
C12133 net44 FILLER_22_32/a_40_246# 0
C12134 _634_/a_843_236# rx_inst.data_reg\[5\] 0
C12135 clk _706_/a_843_236# 0
C12136 hold184/a_438_182# _172_ 0
C12137 _248_ net32 0.14024f
C12138 _011_ _683_/a_298_337# 0
C12139 hold177/a_438_182# _684_/a_1840_334# 0
C12140 hold177/a_326_118# _684_/a_2250_412# 0.00119f
C12141 tx_busy net21 0
C12142 net51 clkbuf_4_7_0_clk/a_27_118# 0.00132f
C12143 _633_/a_298_337# FILLER_29_179/a_40_246# 0.00151f
C12144 _439_/a_354_412# _253_ 0
C12145 hold183/a_438_182# hold57/a_438_182# 0.00882f
C12146 _118_ _705_/a_612_127# 0.02181f
C12147 _641_/a_1583_191# hold176/a_56_118# 0
C12148 baud_inst.counter\[21\] _694_/a_843_236# 0.04338f
C12149 baud_inst.counter\[22\] _694_/a_38_114# 0
C12150 hold53/a_326_118# net52 0.0011f
C12151 net53 _455_/a_155_412# 0
C12152 rx_inst.bit_index\[1\] net36 1.30075f
C12153 _656_/a_1840_334# tx_inst.data_reg\[0\] 0.00104f
C12154 _691_/a_550_127# net163 0
C12155 _153_ net30 0.14751f
C12156 net118 _266_ 0.1021f
C12157 _697_/a_843_236# clknet_4_9_0_clk 0.02358f
C12158 hold69/a_56_118# _638_/a_1583_191# 0.00364f
C12159 _704_/a_843_236# hold51/a_56_118# 0
C12160 tx_inst.bit_index\[2\] hold145/a_438_182# 0
C12161 hold69/a_326_118# _461_/a_22_110# 0
C12162 clknet_4_4_0_clk _664_/a_1489_191# 0.0013f
C12163 _170_ net2 0
C12164 _643_/a_681_505# _264_ 0
C12165 _707_/a_298_337# net19 0
C12166 tx_inst.data_reg\[6\] _656_/a_298_337# 0
C12167 _349_/a_350_122# net38 0
C12168 rx_inst.bit_index\[0\] _224_ 0.00274f
C12169 net92 baud_inst.counter\[8\] 0.01641f
C12170 fanout39/a_40_152# _102_ 0.01371f
C12171 hold159/a_438_182# _070_ 0
C12172 tx_inst.data_reg\[7\] clk 0.36709f
C12173 _233_ net51 0
C12174 rx_data[7] _636_/a_298_337# 0
C12175 _690_/a_843_236# clknet_4_8_0_clk 0.02659f
C12176 _407_/a_146_122# _249_ 0
C12177 FILLER_18_210/a_32_246# clkbuf_4_13_0_clk/a_27_118# 0
C12178 _357_/a_252_412# VPWR 0
C12179 net87 _687_/a_741_93# 0.01066f
C12180 _045_ _637_/a_1583_191# 0
C12181 net45 _701_/a_298_337# 0.01823f
C12182 hold168/a_438_182# _276_ 0
C12183 _677_/a_132_114# _036_ 0
C12184 net129 _163_ 0
C12185 hold74/a_326_118# _269_ 0
C12186 hold74/a_438_182# net73 0.00137f
C12187 net49 _244_ 0.07628f
C12188 _295_ baud_inst.counter\[16\] 0
C12189 net2 hold62/a_56_118# 0.00982f
C12190 _545_/a_248_122# net162 0
C12191 net99 _541_/a_177_436# 0
C12192 _178_ baud_inst.counter\[25\] 0
C12193 clkbuf_4_2_0_clk/a_27_118# _182_ 0
C12194 hold81/a_56_118# hold51/a_56_118# 0
C12195 _646_/a_612_127# _057_ 0.00687f
C12196 _206_ _150_ 0.01141f
C12197 _680_/a_612_127# _093_ 0
C12198 hold51/a_438_182# net19 0.00633f
C12199 baud_inst.counter\[18\] net40 0.05723f
C12200 net32 _245_ 0.00388f
C12201 _042_ VPWR 0.10884f
C12202 FILLER_12_166/a_40_246# _671_/a_324_432# 0
C12203 clknet_4_6_0_clk _668_/a_298_337# 0.01474f
C12204 hold146/a_56_118# tx_inst.state\[4\] 0.02645f
C12205 hold149/a_56_118# net46 0.03154f
C12206 net44 FILLER_19_118/a_32_246# 0
C12207 _314_ _700_/a_324_432# 0
C12208 _655_/a_2250_412# _209_ 0.00345f
C12209 hold163/a_438_182# net49 0.06719f
C12210 _113_ net134 0.09164f
C12211 net48 clknet_0_clk 0.12283f
C12212 _656_/a_843_236# VPWR 0.00474f
C12213 _680_/a_843_236# _093_ 0
C12214 hold183/a_326_118# _400_/a_192_429# 0
C12215 _549_/a_155_412# net99 0
C12216 net55 _368_/a_257_140# 0.0013f
C12217 hold74/a_56_118# _156_ 0
C12218 _309_ _308_ 0.23285f
C12219 clknet_4_4_0_clk _364_/a_155_412# 0.00529f
C12220 net116 _505_/a_272_160# 0
C12221 _705_/a_2250_412# VPWR 0.00134f
C12222 baud_inst.counter\[16\] clknet_4_2_0_clk 0
C12223 net36 FILLER_22_152/a_32_246# 0.00569f
C12224 _228_ _486_/a_115_308# 0
C12225 _216_ _476_/a_146_122# 0
C12226 _099_ _686_/a_2002_114# 0
C12227 _697_/a_1583_191# net142 0
C12228 _697_/a_1840_334# _110_ 0
C12229 _232_ _242_ 0.42855f
C12230 hold99/a_326_118# baud_inst.counter\[25\] 0.00185f
C12231 _699_/a_550_127# net114 0
C12232 net12 _632_/a_843_236# 0.00146f
C12233 hold64/a_56_118# _632_/a_2250_412# 0
C12234 hold64/a_438_182# _632_/a_1583_191# 0
C12235 hold64/a_326_118# _632_/a_1840_334# 0
C12236 _638_/a_550_127# _264_ 0
C12237 _642_/a_1583_191# _131_ 0.00251f
C12238 _642_/a_2250_412# _261_ 0
C12239 _469_/a_22_110# net82 0.01097f
C12240 _644_/a_298_337# _170_ 0.00109f
C12241 _642_/a_1840_334# _262_ 0.0016f
C12242 rx_inst.bit_index\[1\] FILLER_19_132/a_40_246# 0.00145f
C12243 _661_/a_324_432# net155 0.00957f
C12244 _661_/a_741_93# _206_ 0
C12245 net157 net160 0.4211f
C12246 _260_ hold180/a_438_182# 0
C12247 FILLER_8_63/a_40_246# _183_ 0.00637f
C12248 hold138/a_56_118# _266_ 0
C12249 hold138/a_326_118# net30 0.00304f
C12250 hold121/a_326_118# hold147/a_326_118# 0.00171f
C12251 _008_ net61 0
C12252 clkload1/Y clknet_0_clk 0.00399f
C12253 hold63/a_56_118# _374_/a_550_140# 0
C12254 net49 _014_ 0
C12255 _184_ _683_/a_1840_334# 0.0016f
C12256 clknet_4_5_0_clk _198_ 0.05915f
C12257 net105 hold106/a_438_182# 0.01229f
C12258 _674_/a_298_337# _030_ 0.00455f
C12259 FILLER_6_189/a_40_246# _664_/a_298_337# 0
C12260 rx_data[7] net19 0.09357f
C12261 VPWR FILLER_11_125/a_32_246# 0.06985f
C12262 FILLER_8_70/a_32_246# VPWR 0.08592f
C12263 _659_/a_2250_412# clknet_0_clk 0
C12264 _695_/a_132_114# VPWR 0
C12265 net108 _291_ 0.02431f
C12266 VPWR _542_/a_155_412# -0.00187f
C12267 _032_ _701_/a_2250_412# 0
C12268 _024_ net162 0.00334f
C12269 net85 _270_ 0.04184f
C12270 FILLER_16_176/a_40_246# _137_ 0
C12271 net12 hold66/a_56_118# 0
C12272 FILLER_2_81/a_32_246# FILLER_2_79/a_40_246# 0.0524f
C12273 net31 _421_/a_150_412# 0.00218f
C12274 net54 input11/a_40_152# 0
C12275 _644_/a_1489_191# _056_ 0
C12276 hold141/a_438_182# _546_/a_341_118# 0
C12277 _500_/a_155_412# clknet_0_clk 0.00741f
C12278 _040_ _665_/a_1583_191# 0.00419f
C12279 _264_ hold73/a_56_118# 0.0112f
C12280 _663_/a_1583_191# net146 0.00411f
C12281 tx_inst.data_reg\[7\] _653_/a_1840_334# 0
C12282 _679_/a_1583_191# _036_ 0
C12283 clknet_4_14_0_clk net49 0.12236f
C12284 FILLER_8_92/a_32_246# net40 0
C12285 FILLER_21_175/a_32_246# _232_ 0.01335f
C12286 rx_data[7] hold51/a_326_118# 0
C12287 _269_ _647_/a_2250_412# 0
C12288 net31 _435_/a_72_436# 0.03246f
C12289 baud_inst.counter\[3\] hold60/a_438_182# 0
C12290 clknet_0_clk _664_/a_1583_191# 0
C12291 _217_ _219_ 0.08417f
C12292 _302_ FILLER_22_32/a_40_246# 0.00461f
C12293 _006_ _665_/a_1583_191# 0
C12294 _275_ _665_/a_1840_334# 0
C12295 net44 _642_/a_612_127# 0
C12296 clknet_0_clk _250_ 0.05408f
C12297 _442_/a_248_122# _242_ 0
C12298 net2 _263_ 0
C12299 hold174/a_56_118# FILLER_7_176/a_32_246# 0
C12300 _703_/a_741_93# net46 0
C12301 _680_/a_2250_412# _506_/a_155_412# 0
C12302 FILLER_9_72/a_32_246# _683_/a_1840_334# 0
C12303 baud_inst.counter\[13\] FILLER_14_72/a_32_246# 0
C12304 baud_inst.counter\[12\] _684_/a_1785_429# 0
C12305 _041_ net26 0.06802f
C12306 _699_/a_741_93# _165_ 0.00251f
C12307 hold88/a_438_182# _684_/a_1489_191# 0
C12308 _001_ _666_/a_324_432# 0.00115f
C12309 _298_ net160 0.01943f
C12310 _661_/a_2002_114# _148_ 0
C12311 net183 net168 0
C12312 hold108/a_56_118# baud_inst.counter\[4\] 0
C12313 baud_inst.counter\[23\] baud_inst.counter\[22\] 0.60874f
C12314 FILLER_8_63/a_40_246# net115 0.01143f
C12315 _083_ _089_ 0
C12316 net44 _686_/a_612_127# 0
C12317 net133 _701_/a_1489_191# 0
C12318 _207_ _655_/a_2250_412# 0
C12319 _678_/a_1583_191# _678_/a_2250_412# 0
C12320 _288_ _502_/a_279_412# 0
C12321 _118_ output23/a_40_152# 0
C12322 _055_ _159_ 0.48641f
C12323 rx_inst.state\[2\] _641_/a_1840_334# 0
C12324 _177_ _309_ 0.00122f
C12325 output18/a_40_152# hold71/a_56_118# 0
C12326 baud_inst.counter\[12\] hold128/a_326_118# 0
C12327 net128 hold128/a_56_118# 0.00289f
C12328 _685_/a_2250_412# clknet_4_9_0_clk 0.00234f
C12329 _103_ baud_inst.counter\[15\] 0
C12330 _193_ net41 0
C12331 _156_ _647_/a_1840_334# 0.01044f
C12332 _170_ _169_ 0.05174f
C12333 _642_/a_1785_429# clknet_0_clk 0
C12334 _455_/a_257_140# _161_ 0
C12335 _390_/a_59_156# net6 0.03051f
C12336 FILLER_19_75/a_40_246# VPWR 0.1289f
C12337 _663_/a_324_432# net168 0
C12338 rx_data[7] _457_/a_22_110# 0.006f
C12339 _427_/a_248_122# _254_ 0
C12340 _062_ _651_/a_132_114# 0
C12341 _671_/a_1785_429# clknet_0_clk 0
C12342 _188_ net160 0.00364f
C12343 _684_/a_1583_191# clknet_4_2_0_clk 0
C12344 net140 _541_/a_209_168# 0.01191f
C12345 _041_ hold62/a_326_118# 0
C12346 _178_ baud_inst.counter\[24\] 0
C12347 clknet_0_clk net38 0
C12348 net184 net27 0
C12349 _081_ net19 0.00186f
C12350 _536_/a_155_160# VPWR 0
C12351 _659_/a_324_432# net43 0
C12352 clknet_4_6_0_clk net29 0.0669f
C12353 clknet_0_clk _686_/a_1785_429# 0
C12354 output15/a_40_152# _264_ 0
C12355 hold130/a_326_118# _013_ 0
C12356 _110_ baud_inst.counter\[14\] 0
C12357 _447_/a_81_118# _259_ 0.00739f
C12358 net55 _144_ 0.02736f
C12359 _169_ hold62/a_56_118# 0.03015f
C12360 _692_/a_324_432# clknet_4_8_0_clk 0
C12361 baud_inst.counter\[28\] _552_/a_155_412# 0.02301f
C12362 _230_ _640_/a_1489_191# 0
C12363 net49 _693_/a_1583_191# 0.02945f
C12364 rx_inst.data_reg\[3\] _122_ 0.00199f
C12365 tx net146 0
C12366 _360_/a_886_118# net34 0
C12367 _360_/a_382_118# _175_ 0
C12368 VPWR _669_/a_843_236# 0.00213f
C12369 FILLER_0_35/a_40_246# _088_ 0
C12370 hold130/a_438_182# baud_inst.counter\[15\] 0
C12371 net72 hold72/a_326_118# 0.0061f
C12372 _048_ hold72/a_438_182# 0.00452f
C12373 hold68/a_56_118# _550_/a_209_168# 0.00657f
C12374 net7 tx_data[7] 0.00925f
C12375 VPWR _633_/a_298_337# 0.01914f
C12376 hold132/a_56_118# net49 0
C12377 _673_/a_324_432# net29 0
C12378 _073_ _370_/a_154_118# 0
C12379 hold182/a_56_118# net182 0.00215f
C12380 _687_/a_2250_412# net46 0.00278f
C12381 FILLER_0_130/a_32_246# _148_ 0.00204f
C12382 tx_busy _707_/a_1489_191# 0.00399f
C12383 _704_/a_1785_429# net19 0
C12384 hold77/a_56_118# FILLER_28_204/a_32_246# 0
C12385 net6 _655_/a_1489_191# 0
C12386 VPWR _183_ 0.28366f
C12387 _638_/a_324_432# net65 0.00119f
C12388 baud_inst.counter\[23\] FILLER_22_54/a_40_246# 0.03556f
C12389 _164_ baud_inst.counter\[17\] 0.01537f
C12390 _462_/a_120_432# _267_ 0.00338f
C12391 _690_/a_2250_412# baud_inst.counter\[17\] 0.0073f
C12392 net32 _255_ 0.05959f
C12393 _658_/a_2250_412# VPWR 0.00707f
C12394 hold97/a_56_118# _512_/a_279_412# 0
C12395 _707_/a_324_432# net43 0.00123f
C12396 _644_/a_324_432# clknet_4_14_0_clk 0.03643f
C12397 hold77/a_438_182# net13 0.00148f
C12398 _043_ _474_/a_120_432# 0
C12399 net116 _681_/a_1489_191# 0.00284f
C12400 net119 _140_ 0.04883f
C12401 _307_ _540_/a_139_160# 0.00482f
C12402 _634_/a_612_127# rx_inst.data_reg\[5\] 0
C12403 tx_inst.data_reg\[1\] _382_/a_382_118# 0
C12404 _171_ _665_/a_324_432# 0
C12405 tx_inst.bit_index\[2\] _217_ 0.01315f
C12406 hold88/a_326_118# baud_inst.counter\[13\] 0
C12407 _057_ VPWR 0.15369f
C12408 net39 hold128/a_326_118# 0.002f
C12409 _641_/a_1489_191# hold176/a_326_118# 0
C12410 baud_inst.counter\[23\] _694_/a_2250_412# 0.00212f
C12411 baud_inst.counter\[22\] _694_/a_1840_334# 0.00491f
C12412 baud_inst.counter\[21\] _694_/a_612_127# 0
C12413 net53 _130_ 0.01043f
C12414 _360_/a_382_118# net165 0
C12415 hold98/a_438_182# _681_/a_324_432# 0
C12416 _292_ fanout29/a_40_152# 0
C12417 baud_inst.counter\[22\] net114 0
C12418 _183_ hold93/a_326_118# 0
C12419 net35 fanout32/a_40_152# 0
C12420 _431_/a_277_118# net32 0.00486f
C12421 FILLER_20_65/a_32_246# _548_/a_76_160# 0.01038f
C12422 net69 _638_/a_1840_334# 0
C12423 tx_inst.state\[4\] net43 0.00309f
C12424 net66 _632_/a_38_114# 0.01869f
C12425 _054_ _264_ 0.02253f
C12426 _678_/a_741_93# net40 0.00144f
C12427 net27 _651_/a_324_432# 0.01454f
C12428 FILLER_10_78/a_32_246# VPWR 0.07984f
C12429 clknet_4_4_0_clk tx_inst.state\[2\] 0
C12430 _358_/a_268_436# _182_ 0.00366f
C12431 _643_/a_550_127# _264_ 0
C12432 net100 _698_/a_298_337# 0.00454f
C12433 _707_/a_1583_191# net19 0.00109f
C12434 net148 _692_/a_843_236# 0
C12435 _021_ _692_/a_324_432# 0
C12436 net69 _043_ 0
C12437 tx_inst.data_reg\[6\] _656_/a_1583_191# 0.02555f
C12438 _182_ net38 0
C12439 baud_inst.counter\[22\] FILLER_21_33/a_32_246# 0
C12440 hold174/a_438_182# _481_/a_22_110# 0
C12441 _682_/a_38_114# net117 0
C12442 net154 VPWR 0.17762f
C12443 _205_ _671_/a_38_114# 0
C12444 _374_/a_550_140# clknet_0_clk 0
C12445 _170_ _084_ 0
C12446 _528_/a_379_118# net103 0
C12447 net27 _665_/a_132_114# 0
C12448 _091_ _678_/a_324_432# 0.00394f
C12449 _241_ _433_/a_142_412# 0.00221f
C12450 _018_ clknet_4_8_0_clk 0.20433f
C12451 rx_data[7] _636_/a_1583_191# 0
C12452 net159 _381_/a_46_156# 0
C12453 _112_ _699_/a_298_337# 0.00843f
C12454 _192_ _166_ 0.00116f
C12455 _176_ _007_ 0
C12456 net27 net169 0.8511f
C12457 _189_ VPWR 0.32369f
C12458 net87 _687_/a_1785_429# 0
C12459 _206_ _070_ 0.02024f
C12460 net26 FILLER_14_185/a_32_246# 0.00234f
C12461 net45 _701_/a_1583_191# 0.03074f
C12462 rx_inst.data_reg\[3\] rx_inst.data_reg\[4\] 0.00462f
C12463 _294_ _684_/a_843_236# 0
C12464 _277_ _000_ 0
C12465 net28 net30 0.54527f
C12466 _076_ _144_ 0
C12467 net13 _633_/a_681_505# 0
C12468 rx_data[1] _633_/a_843_236# 0
C12469 _527_/a_192_429# _527_/a_341_118# -0
C12470 _344_/a_252_412# _312_ 0.00223f
C12471 _344_/a_150_412# _313_ 0
C12472 baud_inst.counter\[25\] net162 0
C12473 hold168/a_56_118# net172 0
C12474 _228_ _423_/a_279_412# 0.00704f
C12475 rx_inst.state\[2\] _423_/a_165_412# 0
C12476 hold163/a_326_118# hold121/a_326_118# 0
C12477 net126 net65 0.06796f
C12478 net97 net152 0.0011f
C12479 _503_/a_279_412# _037_ 0.00121f
C12480 _360_/a_71_118# _656_/a_324_432# 0
C12481 net108 baud_inst.counter\[4\] 0.00249f
C12482 VPWR net115 0.04088f
C12483 _017_ net161 0.00663f
C12484 net144 _057_ 0.10084f
C12485 _198_ _005_ 0.00735f
C12486 hold62/a_56_118# _084_ 0.00161f
C12487 net2 rx_inst.data_reg\[7\] 0
C12488 hold174/a_326_118# _192_ 0
C12489 _032_ baud_inst.counter\[29\] 0
C12490 _480_/a_22_110# net168 0.00132f
C12491 _386_/a_559_412# _211_ 0.00157f
C12492 net28 _647_/a_324_432# 0
C12493 _648_/a_324_432# _648_/a_741_93# -0
C12494 clknet_4_6_0_clk _668_/a_1583_191# 0.00182f
C12495 hold55/a_326_118# input2/a_40_152# 0
C12496 net9 net165 0
C12497 _401_/a_120_432# _220_ 0.00204f
C12498 hold161/a_438_182# _101_ 0
C12499 clknet_4_14_0_clk _649_/a_38_114# 0
C12500 _656_/a_612_127# VPWR 0
C12501 hold183/a_438_182# net183 0.03863f
C12502 _646_/a_741_93# _240_ 0.0056f
C12503 net131 clknet_4_14_0_clk 0.00161f
C12504 hold66/a_56_118# net84 0
C12505 _672_/a_681_505# _033_ 0
C12506 clknet_4_4_0_clk _197_ 0.0355f
C12507 hold129/a_438_182# VPWR 0.00348f
C12508 FILLER_18_160/a_32_246# net25 0.00356f
C12509 _179_ _554_/a_350_122# 0
C12510 _694_/a_298_337# _107_ 0.03906f
C12511 input6/a_40_152# VPWR 0.00317f
C12512 _216_ _274_ 0.02532f
C12513 net114 _694_/a_2250_412# 0
C12514 clknet_4_10_0_clk clknet_0_clk 0
C12515 _659_/a_298_337# _211_ 0.01137f
C12516 hold136/a_438_182# _490_/a_45_160# 0
C12517 hold172/a_326_118# _077_ 0
C12518 hold158/a_438_182# _688_/a_298_337# 0
C12519 net182 net29 0.48819f
C12520 _025_ net90 0
C12521 clknet_0_clk _687_/a_843_236# 0.00109f
C12522 net143 clknet_0_clk 0.05289f
C12523 clknet_4_12_0_clk _453_/a_170_412# 0.00171f
C12524 _644_/a_1583_191# _170_ 0
C12525 net48 FILLER_26_172/a_40_246# 0.00113f
C12526 _661_/a_1583_191# _151_ 0
C12527 _072_ _378_/a_382_118# 0
C12528 net155 clknet_4_1_0_clk 0.0011f
C12529 input5/a_40_152# FILLER_0_128/a_40_246# 0.00536f
C12530 _655_/a_741_93# clknet_0_clk 0
C12531 hold101/a_326_118# net160 0
C12532 hold101/a_56_118# _296_ 0.00506f
C12533 _696_/a_324_432# FILLER_17_81/a_32_246# 0
C12534 hold63/a_56_118# _204_ 0
C12535 hold124/a_326_118# net124 0
C12536 _388_/a_285_412# net171 0
C12537 output12/a_40_152# rx_data[6] 0.0083f
C12538 _353_/a_248_122# baud_inst.counter\[11\] 0
C12539 _656_/a_324_432# input9/a_40_152# 0
C12540 _341_/a_295_385# net41 0
C12541 _674_/a_1583_191# _030_ 0
C12542 _057_ _266_ 0.00184f
C12543 _695_/a_1489_191# VPWR 0
C12544 VPWR _309_ 0.01873f
C12545 hold115/a_438_182# net97 0
C12546 _297_ FILLER_15_42/a_40_246# 0
C12547 net73 hold73/a_326_118# 0.002f
C12548 baud_inst.counter\[15\] _687_/a_298_337# 0.00289f
C12549 clknet_4_3_0_clk VPWR 0.62444f
C12550 _057_ _167_ 0
C12551 FILLER_8_14/a_32_246# net38 0.01138f
C12552 _285_ clknet_0_clk 0.01834f
C12553 _040_ _665_/a_2002_114# 0
C12554 net36 fanout28/a_40_152# 0
C12555 _023_ net49 0.02357f
C12556 _060_ _264_ 0.01849f
C12557 _674_/a_2250_412# _673_/a_2250_412# 0.00943f
C12558 _057_ _647_/a_741_93# 0
C12559 net55 _390_/a_496_118# 0.00242f
C12560 _663_/a_1489_191# net50 0
C12561 _097_ hold109/a_438_182# 0.00145f
C12562 net44 _540_/a_45_160# 0.00131f
C12563 FILLER_17_96/a_32_246# baud_inst.counter\[24\] 0
C12564 baud_inst.counter\[7\] _499_/a_380_412# 0
C12565 rx_inst.state\[3\] hold123/a_438_182# 0
C12566 VPWR FILLER_23_186/a_40_246# 0.15315f
C12567 _064_ hold137/a_326_118# 0.00773f
C12568 hold65/a_326_118# hold72/a_56_118# 0
C12569 tx_inst.bit_index\[1\] hold184/a_326_118# 0
C12570 _534_/a_46_156# net148 0.00334f
C12571 _046_ _122_ 0
C12572 _692_/a_38_114# net164 0.01877f
C12573 _692_/a_298_337# clknet_4_10_0_clk 0.00245f
C12574 _082_ _053_ 0.00217f
C12575 net44 _132_ 0.13424f
C12576 _126_ clknet_4_13_0_clk 0
C12577 _440_/a_244_412# VPWR 0
C12578 baud_inst.counter\[1\] hold181/a_438_182# 0
C12579 _339_/a_382_118# clknet_4_4_0_clk 0.04615f
C12580 output21/a_40_152# _705_/a_843_236# 0
C12581 baud_inst.counter\[31\] clknet_0_clk 0
C12582 baud_inst.counter\[27\] net46 0.01361f
C12583 _680_/a_2250_412# _289_ 0
C12584 _689_/a_298_337# _101_ 0.02982f
C12585 VPWR net80 0.11581f
C12586 _643_/a_1583_191# _474_/a_22_110# 0
C12587 _179_ hold114/a_326_118# 0
C12588 _699_/a_1785_429# _165_ 0
C12589 _198_ _199_ 0.19962f
C12590 clknet_4_1_0_clk hold92/a_326_118# 0.00137f
C12591 _680_/a_324_432# net135 0
C12592 fanout42/a_40_152# clknet_4_6_0_clk 0
C12593 _307_ _687_/a_1489_191# 0
C12594 FILLER_27_194/a_40_246# net77 0.03686f
C12595 _114_ _694_/a_1583_191# 0.00829f
C12596 _635_/a_843_236# _632_/a_741_93# 0
C12597 _635_/a_741_93# _632_/a_843_236# 0
C12598 net43 FILLER_7_210/a_40_246# 0
C12599 _255_ FILLER_25_150/a_32_246# 0
C12600 net55 _145_ 0.05397f
C12601 _685_/a_38_114# hold91/a_326_118# 0
C12602 _685_/a_298_337# hold91/a_438_182# 0
C12603 net49 _701_/a_843_236# 0.0081f
C12604 _680_/a_1785_429# baud_inst.counter\[8\] 0
C12605 net2 _639_/a_1489_191# 0.00358f
C12606 _053_ clknet_0_clk 0.01358f
C12607 FILLER_17_79/a_40_246# net90 0
C12608 hold121/a_56_118# _693_/a_1583_191# 0
C12609 net121 _693_/a_38_114# 0
C12610 input5/a_40_152# _387_/a_46_156# 0.00211f
C12611 net50 _665_/a_38_114# 0
C12612 _663_/a_1840_334# _200_ 0
C12613 clkload1/Y net43 0.01022f
C12614 _513_/a_341_118# _292_ 0.01598f
C12615 _062_ _651_/a_1489_191# 0
C12616 _704_/a_550_127# net43 0
C12617 baud_inst.counter\[24\] net162 0.76799f
C12618 hold66/a_56_118# _635_/a_741_93# 0
C12619 hold166/a_56_118# net51 0
C12620 _285_ _182_ 0
C12621 _152_ _166_ 0.04927f
C12622 _206_ _392_/a_285_412# 0.00594f
C12623 _675_/a_298_337# net38 0.05305f
C12624 _680_/a_741_93# baud_inst.counter\[8\] 0
C12625 _464_/a_22_110# clknet_4_15_0_clk 0
C12626 _472_/a_22_110# _123_ 0.00198f
C12627 baud_inst.counter\[28\] _315_ 0.03423f
C12628 hold155/a_438_182# net38 0.00179f
C12629 _646_/a_1489_191# FILLER_17_199/a_40_246# 0
C12630 _230_ rx_inst.bit_index\[0\] 0.05226f
C12631 net49 _693_/a_2002_114# 0
C12632 baud_inst.counter\[13\] _494_/a_279_412# 0
C12633 _046_ rx_inst.data_reg\[4\] 0.05475f
C12634 VPWR _669_/a_612_127# 0
C12635 net54 _077_ 0.02474f
C12636 hold68/a_326_118# net133 0.00326f
C12637 VPWR _633_/a_1583_191# 0.00984f
C12638 _031_ _550_/a_380_412# 0.00119f
C12639 _230_ hold175/a_56_118# 0
C12640 _040_ _203_ 0
C12641 _707_/a_1840_334# _704_/a_1840_334# 0.00261f
C12642 _707_/a_1489_191# _704_/a_741_93# 0
C12643 _707_/a_741_93# _704_/a_1489_191# 0
C12644 _707_/a_2250_412# _704_/a_1583_191# 0
C12645 _707_/a_1583_191# _704_/a_2250_412# 0
C12646 _079_ net51 0.1001f
C12647 hold140/a_438_182# FILLER_20_95/a_40_246# 0.00941f
C12648 hold170/a_438_182# net55 0.01567f
C12649 _385_/a_46_156# _211_ 0
C12650 FILLER_16_166/a_32_246# _241_ 0
C12651 net6 tx_inst.data_reg\[1\] 0.00134f
C12652 VPWR FILLER_20_0/a_40_246# 0.13456f
C12653 baud_inst.counter\[14\] _686_/a_550_127# 0
C12654 _635_/a_843_236# FILLER_21_229/a_32_246# 0
C12655 net44 fanout44/a_40_152# 0.00161f
C12656 _267_ _128_ 0.53805f
C12657 hold97/a_438_182# _292_ 0.00994f
C12658 hold97/a_326_118# _010_ 0.0113f
C12659 net29 hold95/a_438_182# 0.0431f
C12660 net122 clknet_4_6_0_clk 0.161f
C12661 net46 net91 0.03312f
C12662 _644_/a_2250_412# clknet_4_14_0_clk 0.00369f
C12663 _043_ _122_ 0.05723f
C12664 net116 baud_inst.counter\[9\] 0.04265f
C12665 _143_ _339_/a_886_118# 0.0017f
C12666 _220_ _667_/a_324_432# 0
C12667 _295_ baud_inst.counter\[13\] 0.00137f
C12668 _229_ _224_ 0.12443f
C12669 hold134/a_326_118# _115_ 0
C12670 _477_/a_22_110# FILLER_5_181/a_32_246# 0
C12671 tx_inst.data_reg\[5\] FILLER_7_146/a_32_246# 0
C12672 net83 rx_inst.data_reg\[5\] 0
C12673 _203_ _006_ 0.00498f
C12674 net42 _667_/a_38_114# 0
C12675 hold156/a_56_118# baud_inst.counter\[16\] 0
C12676 _081_ _671_/a_1583_191# 0
C12677 _264_ _649_/a_741_93# 0.00267f
C12678 baud_inst.counter\[30\] _551_/a_76_160# 0
C12679 baud_inst.counter\[28\] _551_/a_272_160# 0
C12680 _673_/a_843_236# net40 0
C12681 _673_/a_741_93# _086_ 0.00766f
C12682 net142 clknet_4_9_0_clk 0
C12683 clk _656_/a_324_432# 0.06622f
C12684 _646_/a_843_236# clknet_0_clk 0.02038f
C12685 FILLER_20_65/a_32_246# _312_ 0.0022f
C12686 hold69/a_326_118# net18 0.05494f
C12687 FILLER_17_160/a_40_246# net25 0.00127f
C12688 net27 _651_/a_2250_412# 0.00485f
C12689 hold154/a_56_118# net128 0
C12690 fanout26/a_40_152# net51 0
C12691 _645_/a_1840_334# clknet_4_14_0_clk 0.00835f
C12692 VPWR net52 0.27145f
C12693 _008_ _674_/a_1583_191# 0
C12694 baud_inst.counter\[1\] net135 0.0023f
C12695 net79 _674_/a_1840_334# 0
C12696 _485_/a_22_110# _667_/a_38_114# 0.0348f
C12697 net100 _698_/a_1583_191# 0.0022f
C12698 net2 hold180/a_326_118# 0.00872f
C12699 net148 _692_/a_612_127# 0
C12700 tx_inst.data_reg\[6\] _656_/a_2002_114# 0
C12701 FILLER_26_35/a_32_246# VPWR 0.08714f
C12702 tx_data[0] net3 0.0469f
C12703 net174 _171_ 0.09243f
C12704 _191_ _685_/a_1583_191# 0
C12705 _204_ clknet_0_clk 0.00253f
C12706 net103 _301_ 0.32193f
C12707 net12 _635_/a_1583_191# 0
C12708 FILLER_7_82/a_32_246# _280_ 0
C12709 _436_/a_244_412# _249_ 0
C12710 _436_/a_142_412# _136_ 0.02081f
C12711 _436_/a_550_140# _250_ 0
C12712 _241_ _156_ 0.31015f
C12713 net10 VPWR 0.06325f
C12714 clknet_4_7_0_clk hold50/a_56_118# 0.00704f
C12715 baud_inst.counter\[13\] clknet_4_2_0_clk 0.00325f
C12716 hold182/a_326_118# _670_/a_324_432# 0
C12717 hold182/a_438_182# _670_/a_38_114# 0
C12718 hold65/a_326_118# _128_ 0
C12719 hold65/a_438_182# _267_ 0.00466f
C12720 _077_ _368_/a_155_412# 0.05443f
C12721 _686_/a_1583_191# net130 0
C12722 _059_ _648_/a_324_432# 0.03045f
C12723 net79 _673_/a_38_114# 0.00622f
C12724 _173_ tx_inst.data_reg\[3\] 0.00153f
C12725 net71 _637_/a_1489_191# 0
C12726 net45 _701_/a_2002_114# 0
C12727 FILLER_5_164/a_40_246# tx_inst.data_reg\[0\] 0
C12728 hold87/a_56_118# _696_/a_612_127# 0
C12729 _696_/a_843_236# _544_/a_46_156# 0
C12730 net48 clkbuf_4_13_0_clk/a_27_118# 0
C12731 baud_inst.counter\[26\] _312_ 0.38539f
C12732 baud_inst.counter\[27\] _313_ 0.02142f
C12733 rx_inst.state\[2\] _241_ 0.07339f
C12734 _159_ _648_/a_324_432# 0
C12735 _360_/a_886_118# _656_/a_741_93# 0
C12736 _360_/a_1453_124# _656_/a_1840_334# 0
C12737 _292_ _186_ 0.00295f
C12738 clknet_0_clk _451_/a_155_412# 0.00191f
C12739 hold87/a_438_182# _541_/a_209_168# 0
C12740 _493_/a_45_160# net29 0.03246f
C12741 net44 _687_/a_550_127# 0
C12742 hold57/a_56_118# _216_ 0
C12743 _170_ hold127/a_326_118# 0.02029f
C12744 _380_/a_559_412# _150_ 0
C12745 _380_/a_496_118# net170 0.00203f
C12746 _206_ _706_/a_38_114# 0
C12747 net32 hold127/a_56_118# 0
C12748 _440_/a_142_412# _252_ 0.00159f
C12749 _256_ _425_/a_46_156# 0
C12750 _220_ _142_ 0.35205f
C12751 _002_ net49 0.00174f
C12752 hold112/a_56_118# _259_ 0
C12753 _640_/a_843_236# FILLER_22_118/a_32_246# 0
C12754 hold183/a_438_182# hold122/a_326_118# 0
C12755 net44 hold91/a_438_182# 0
C12756 net42 _220_ 0.00304f
C12757 _676_/a_298_337# baud_inst.counter\[13\] 0
C12758 _641_/a_550_127# baud_inst.counter\[25\] 0
C12759 rx_inst.state\[3\] _450_/a_127_96# 0
C12760 _646_/a_1785_429# _240_ 0
C12761 _470_/a_22_110# rx_inst.data_reg\[5\] 0
C12762 _086_ net95 0
C12763 net142 _026_ 0.00216f
C12764 _672_/a_550_127# _033_ 0
C12765 _672_/a_612_127# net61 0
C12766 fanout41/a_40_152# tx_inst.data_reg\[1\] 0
C12767 hold65/a_326_118# hold65/a_438_182# 0
C12768 _074_ _706_/a_298_337# 0.00346f
C12769 net122 net29 0
C12770 clknet_4_8_0_clk _686_/a_1583_191# 0
C12771 _223_ net24 0.05326f
C12772 hold169/a_438_182# net168 0.00794f
C12773 hold154/a_326_118# net39 0
C12774 FILLER_12_89/a_40_246# hold154/a_326_118# 0
C12775 _514_/a_257_140# _293_ 0
C12776 _518_/a_139_160# _297_ 0
C12777 _248_ _137_ 0.01957f
C12778 _633_/a_1840_334# net30 0
C12779 _633_/a_1583_191# _266_ 0
C12780 _390_/a_59_156# net8 0
C12781 FILLER_5_84/a_40_246# net40 0.02546f
C12782 _132_ _697_/a_2250_412# 0.00166f
C12783 clknet_4_12_0_clk _697_/a_1840_334# 0
C12784 _171_ _370_/a_154_118# 0
C12785 _072_ _206_ 0.00469f
C12786 _655_/a_1785_429# clknet_0_clk 0
C12787 net182 _493_/a_45_160# 0
C12788 VPWR _149_ 0.13948f
C12789 _374_/a_244_412# _205_ 0
C12790 hold64/a_56_118# hold84/a_56_118# 0
C12791 net165 net171 0.0287f
C12792 clknet_0_clk hold91/a_326_118# 0.00222f
C12793 net87 _109_ 0.00869f
C12794 hold121/a_326_118# _305_ 0.00583f
C12795 hold121/a_56_118# _023_ 0
C12796 hold121/a_438_182# net75 0.00154f
C12797 _155_ _648_/a_324_432# 0.00686f
C12798 net124 _648_/a_741_93# 0.00101f
C12799 net145 _070_ 0.01002f
C12800 net156 _684_/a_38_114# 0.04583f
C12801 clkbuf_0_clk/a_116_82# net28 0
C12802 _656_/a_681_505# net9 0
C12803 _660_/a_741_93# net54 0.00162f
C12804 _660_/a_38_114# _214_ 0.0428f
C12805 _111_ baud_inst.counter\[25\] 0.00285f
C12806 net45 _311_ 0
C12807 tx_data[1] tx_data[7] 0.4666f
C12808 _371_/a_170_412# VPWR 0
C12809 hold120/a_56_118# clknet_4_10_0_clk 0
C12810 _198_ _365_/a_257_140# 0
C12811 fanout24/a_40_152# _425_/a_46_156# 0.00189f
C12812 _240_ net24 0
C12813 baud_inst.counter\[15\] _687_/a_1583_191# 0.00105f
C12814 net27 _201_ 0.02476f
C12815 net179 net55 0.02423f
C12816 FILLER_15_17/a_40_246# _017_ 0.03076f
C12817 _341_/a_1377_160# _176_ 0
C12818 VPWR _389_/a_268_412# -0
C12819 _089_ _676_/a_324_432# 0.03959f
C12820 _293_ net130 0.00652f
C12821 tx_inst.state\[1\] net50 0.36227f
C12822 baud_inst.counter\[28\] hold106/a_438_182# 0.00641f
C12823 clknet_4_11_0_clk _700_/a_38_114# 0.00166f
C12824 _193_ hold184/a_438_182# 0
C12825 rx _705_/a_1840_334# 0
C12826 net2 _705_/a_1583_191# 0
C12827 fanout44/a_40_152# _302_ 0.01618f
C12828 _489_/a_494_160# clknet_4_0_0_clk 0
C12829 input11/a_40_152# VPWR 0.00212f
C12830 fanout34/a_40_152# _651_/a_741_93# 0.00309f
C12831 _692_/a_1583_191# clknet_4_10_0_clk 0.00277f
C12832 _670_/a_741_93# net29 0
C12833 _206_ _393_/a_170_412# 0
C12834 hold172/a_326_118# net43 0.04441f
C12835 _270_ FILLER_19_228/a_40_246# 0.00103f
C12836 net14 VPWR 0.33256f
C12837 rx_inst.data_reg\[0\] _273_ 0
C12838 _655_/a_132_114# net181 0
C12839 tx _705_/a_1583_191# 0.00298f
C12840 clknet_4_0_0_clk _681_/a_843_236# 0.01374f
C12841 baud_inst.counter\[5\] VPWR 0.15185f
C12842 _689_/a_1583_191# _101_ 0
C12843 _163_ _189_ 0.38377f
C12844 _643_/a_2250_412# net65 0.06125f
C12845 hold78/a_438_182# net47 0.01366f
C12846 _678_/a_681_505# clknet_4_1_0_clk 0
C12847 net32 _424_/a_244_412# 0.00112f
C12848 FILLER_0_40/a_40_246# _033_ 0.00136f
C12849 fanout34/a_40_152# _007_ 0
C12850 _635_/a_1583_191# _632_/a_1583_191# 0.00109f
C12851 _680_/a_1840_334# _287_ 0
C12852 _680_/a_2250_412# net135 0
C12853 _114_ _694_/a_2002_114# 0
C12854 hold148/a_438_182# clknet_4_10_0_clk 0.00994f
C12855 net3 _208_ 0.00675f
C12856 _036_ _351_/a_46_156# 0
C12857 _004_ _372_/a_22_110# 0.05056f
C12858 _541_/a_380_412# net46 0
C12859 baud_inst.counter\[20\] _105_ 0.03789f
C12860 clknet_0_clk _308_ 0
C12861 clkbuf_4_4_0_clk/a_27_118# clknet_0_clk 0.03018f
C12862 FILLER_17_201/a_32_246# clknet_0_clk 0
C12863 net111 _133_ 0
C12864 clk _658_/a_1583_191# 0.02152f
C12865 _283_ _291_ 0.00118f
C12866 _288_ net29 0.31325f
C12867 baud_inst.counter\[18\] _014_ 0
C12868 baud_inst.counter\[26\] _697_/a_843_236# 0
C12869 rx_data[5] output18/a_40_152# 0.00284f
C12870 _138_ _633_/a_298_337# 0
C12871 _286_ net97 0.01689f
C12872 _226_ _241_ 0.04831f
C12873 _685_/a_741_93# net91 0
C12874 net49 _701_/a_612_127# 0.00759f
C12875 baud_inst.counter\[5\] hold93/a_326_118# 0
C12876 _137_ net139 0.00268f
C12877 _468_/a_22_110# _269_ 0
C12878 _314_ clknet_4_10_0_clk 0
C12879 _286_ net86 0
C12880 hold121/a_326_118# _693_/a_1489_191# 0
C12881 clknet_4_14_0_clk _471_/a_22_110# 0.00581f
C12882 _637_/a_741_93# VPWR 0.00964f
C12883 _232_ _633_/a_298_337# 0
C12884 net121 _693_/a_1840_334# 0
C12885 _292_ _684_/a_324_432# 0.05254f
C12886 hold126/a_56_118# net65 0
C12887 hold178/a_56_118# net108 0
C12888 net48 _249_ 0.04469f
C12889 net66 _635_/a_843_236# 0
C12890 hold129/a_438_182# _163_ 0
C12891 _643_/a_1583_191# net111 0
C12892 baud_inst.counter\[17\] _688_/a_38_114# 0
C12893 _675_/a_1583_191# net38 0.03237f
C12894 net179 _076_ 0.00205f
C12895 _706_/a_298_337# _201_ 0
C12896 _556_/a_192_429# _313_ 0.00229f
C12897 _429_/a_244_412# net78 0
C12898 _131_ net175 0
C12899 _257_ _264_ 0
C12900 _261_ net24 0.17515f
C12901 net184 _175_ 0
C12902 hold97/a_438_182# _289_ 0.00147f
C12903 hold143/a_438_182# _157_ 0
C12904 clknet_4_8_0_clk _687_/a_38_114# 0.01454f
C12905 net41 _380_/a_59_156# 0.0014f
C12906 _173_ hold184/a_56_118# 0.00326f
C12907 hold86/a_326_118# _182_ 0
C12908 _650_/a_741_93# _668_/a_741_93# 0.00129f
C12909 _650_/a_843_236# _668_/a_324_432# 0
C12910 net84 _635_/a_1583_191# 0.00278f
C12911 FILLER_0_35/a_40_246# hold61/a_326_118# 0
C12912 net62 _000_ 0
C12913 _129_ _639_/a_741_93# 0.00268f
C12914 _265_ _639_/a_843_236# 0.0221f
C12915 _059_ _123_ 0.00113f
C12916 net40 _682_/a_298_337# 0.00305f
C12917 hold99/a_56_118# _697_/a_324_432# 0
C12918 input8/a_40_152# VPWR 0.00389f
C12919 hold54/a_56_118# _042_ 0
C12920 _676_/a_2250_412# _063_ 0.00158f
C12921 _398_/a_115_308# _172_ 0
C12922 clknet_4_3_0_clk _652_/a_741_93# 0.03202f
C12923 baud_inst.counter\[18\] _529_/a_139_160# 0
C12924 _674_/a_1840_334# _672_/a_741_93# 0
C12925 _674_/a_2250_412# _672_/a_324_432# 0
C12926 _168_ _458_/a_279_412# 0.00491f
C12927 _646_/a_324_432# _058_ 0
C12928 _159_ _123_ 0.07004f
C12929 _259_ _136_ 0
C12930 hold184/a_438_182# net174 0
C12931 net42 _667_/a_1840_334# 0
C12932 _264_ _649_/a_1785_429# 0.00185f
C12933 net121 FILLER_24_19/a_40_246# 0.03101f
C12934 _200_ _665_/a_741_93# 0.00269f
C12935 input11/a_40_152# FILLER_7_234/a_32_246# 0.01048f
C12936 _662_/a_843_236# net41 0
C12937 hold140/a_438_182# hold142/a_438_182# 0.00174f
C12938 clk _656_/a_2250_412# 0.00516f
C12939 FILLER_8_116/a_40_246# FILLER_8_118/a_32_246# 0.0524f
C12940 _166_ net168 0.06f
C12941 _230_ hold176/a_326_118# 0
C12942 _646_/a_612_127# clknet_0_clk 0.00733f
C12943 VPWR FILLER_26_141/a_40_246# 0.1427f
C12944 _550_/a_380_412# _313_ 0.00735f
C12945 net122 _667_/a_681_505# 0
C12946 net37 _667_/a_843_236# 0.00423f
C12947 clknet_0_clk _435_/a_268_436# 0.00216f
C12948 net71 hold72/a_56_118# 0.0296f
C12949 _664_/a_1583_191# _664_/a_2250_412# -0
C12950 _707_/a_324_432# net51 0.01314f
C12951 _127_ _637_/a_741_93# 0
C12952 rx_data[2] net30 0
C12953 FILLER_16_70/a_40_246# FILLER_14_70/a_40_246# 0
C12954 rx_inst.data_reg\[6\] rx_inst.data_reg\[5\] 0
C12955 _177_ clknet_0_clk 0.06508f
C12956 _682_/a_1489_191# baud_inst.counter\[9\] 0
C12957 VPWR _349_/a_350_122# 0
C12958 _102_ net157 0.00451f
C12959 _526_/a_248_122# net101 0.00297f
C12960 _301_ net101 0
C12961 _157_ _136_ 0.12173f
C12962 _250_ _249_ 0.78502f
C12963 _169_ _247_ 0
C12964 hold174/a_326_118# net168 0
C12965 net54 net43 0.0683f
C12966 net34 _651_/a_843_236# 0.00142f
C12967 _339_/a_589_385# clknet_0_clk 0
C12968 _192_ FILLER_5_192/a_40_246# 0.02335f
C12969 VPWR _685_/a_38_114# 0
C12970 _686_/a_1489_191# clknet_4_9_0_clk 0.0052f
C12971 hold63/a_56_118# VPWR 0
C12972 _527_/a_341_118# _300_ 0.01604f
C12973 _464_/a_120_432# clknet_0_clk 0
C12974 net79 _673_/a_1840_334# 0
C12975 VPWR _666_/a_132_114# 0
C12976 _677_/a_843_236# _089_ 0
C12977 VPWR _689_/a_38_114# 0.00399f
C12978 hold141/a_56_118# hold113/a_326_118# 0
C12979 hold158/a_438_182# _101_ 0.01027f
C12980 _696_/a_1583_191# net141 0
C12981 rx_data[1] net78 0
C12982 hold111/a_438_182# VPWR 0.00698f
C12983 _092_ _185_ 0.00121f
C12984 net122 fanout42/a_40_152# 0.00346f
C12985 fanout30/a_40_152# _168_ 0
C12986 FILLER_3_207/a_40_246# _664_/a_1840_334# 0
C12987 net44 hold99/a_56_118# 0.01085f
C12988 tx_inst.bit_index\[1\] _656_/a_38_114# 0
C12989 _363_/a_22_110# _174_ 0
C12990 _155_ _123_ 0
C12991 _092_ clknet_4_0_0_clk 0.00804f
C12992 _175_ net169 0.00144f
C12993 hold55/a_438_182# _665_/a_843_236# 0
C12994 _637_/a_741_93# _266_ 0
C12995 _637_/a_843_236# net30 0
C12996 VPWR _121_ 0.12147f
C12997 rx_data[3] clknet_4_13_0_clk 0
C12998 net54 _664_/a_324_432# 0
C12999 _547_/a_81_118# _310_ 0
C13000 net147 _106_ 0
C13001 hold55/a_438_182# _166_ 0
C13002 net151 net48 0.0206f
C13003 _106_ net46 0.1883f
C13004 clknet_4_5_0_clk _654_/a_38_114# 0.00332f
C13005 _658_/a_38_114# _148_ 0.01632f
C13006 _658_/a_741_93# net171 0.0021f
C13007 _208_ _150_ 0.07133f
C13008 _660_/a_298_337# tx_inst.data_reg\[0\] 0
C13009 _660_/a_324_432# _144_ 0.00799f
C13010 _660_/a_741_93# _065_ 0
C13011 output23/a_40_152# input2/a_40_152# 0.00944f
C13012 net51 _671_/a_741_93# 0
C13013 _292_ _511_/a_252_412# 0
C13014 hold173/a_438_182# _141_ 0
C13015 _430_/a_170_412# _170_ 0
C13016 net31 _423_/a_165_412# 0
C13017 _158_ _252_ 0.021f
C13018 _316_ net46 0
C13019 _345_/a_150_412# hold120/a_56_118# 0
C13020 _075_ tx_inst.bit_index\[0\] 0
C13021 clknet_4_5_0_clk _664_/a_681_505# 0
C13022 tx_inst.state\[1\] _705_/a_38_114# 0.0022f
C13023 clknet_4_7_0_clk _705_/a_324_432# 0.02155f
C13024 VPWR _496_/a_170_412# 0
C13025 rx_data[4] _650_/a_2250_412# 0
C13026 net16 _650_/a_1785_429# 0
C13027 _655_/a_1583_191# _385_/a_46_156# 0
C13028 clkbuf_4_8_0_clk/a_27_118# net46 0
C13029 hold164/a_326_118# net164 0
C13030 clknet_4_0_0_clk _033_ 0.00572f
C13031 _059_ net124 0.00165f
C13032 _074_ _706_/a_1583_191# 0
C13033 FILLER_14_72/a_32_246# net29 0
C13034 _690_/a_324_432# VPWR 0.00952f
C13035 hold68/a_438_182# net45 0
C13036 net106 _694_/a_1583_191# 0
C13037 net49 _434_/a_354_412# 0
C13038 _642_/a_843_236# _132_ 0.02619f
C13039 _642_/a_741_93# clknet_4_12_0_clk 0.03447f
C13040 _642_/a_324_432# rx_inst.bit_index\[2\] 0
C13041 _113_ net133 0.11601f
C13042 _549_/a_257_140# _313_ 0.00277f
C13043 clkload2/Y _546_/a_192_429# 0
C13044 net43 _368_/a_155_412# 0.00152f
C13045 _102_ _298_ 0
C13046 _044_ clknet_4_14_0_clk 0.00187f
C13047 baud_inst.counter\[4\] _162_ 0.23037f
C13048 net42 _003_ 0
C13049 net156 _525_/a_46_156# 0.00206f
C13050 baud_inst.counter\[13\] FILLER_14_70/a_40_246# 0.00118f
C13051 clkbuf_4_11_0_clk/a_27_118# _698_/a_1840_334# 0.0015f
C13052 net45 _022_ 0
C13053 clk _398_/a_115_308# 0
C13054 _129_ _061_ 0
C13055 hold139/a_56_118# net25 0.00231f
C13056 hold69/a_326_118# hold71/a_326_118# 0
C13057 net85 _635_/a_298_337# 0.00186f
C13058 _223_ net30 0.00201f
C13059 _662_/a_298_337# _706_/a_38_114# 0
C13060 _662_/a_38_114# _706_/a_298_337# 0
C13061 rx_data[4] _456_/a_155_412# 0
C13062 _155_ _648_/a_2250_412# 0
C13063 net124 _648_/a_1785_429# 0
C13064 net60 hold60/a_438_182# 0.01092f
C13065 _181_ hold60/a_326_118# 0.04942f
C13066 _285_ net152 0
C13067 net92 _282_ 1.96442f
C13068 _283_ baud_inst.counter\[4\] 0.12696f
C13069 _645_/a_298_337# FILLER_29_145/a_40_246# 0.00151f
C13070 rx_data[0] _264_ 0
C13071 _660_/a_1840_334# _214_ 0
C13072 _018_ FILLER_17_0/a_40_246# 0
C13073 _307_ net162 0
C13074 _697_/a_741_93# VPWR 0.01522f
C13075 hold56/a_438_182# _651_/a_843_236# 0
C13076 _204_ net43 0.00111f
C13077 _299_ FILLER_15_0/a_40_246# 0.01103f
C13078 baud_inst.counter\[21\] _693_/a_38_114# 0
C13079 _232_ _440_/a_244_412# 0
C13080 _223_ _647_/a_324_432# 0
C13081 _643_/a_843_236# clkbuf_4_15_0_clk/a_27_118# 0.00135f
C13082 _643_/a_298_337# clknet_4_15_0_clk 0
C13083 _641_/a_1840_334# _130_ 0
C13084 net35 rx_inst.state\[2\] 0.01223f
C13085 _662_/a_2250_412# _040_ 0.00135f
C13086 _660_/a_1489_191# clknet_4_5_0_clk 0.00271f
C13087 _283_ _498_/a_279_412# 0.00517f
C13088 hold58/a_326_118# _703_/a_324_432# 0
C13089 hold58/a_56_118# _703_/a_741_93# 0
C13090 net79 _086_ 0.25002f
C13091 _705_/a_681_505# _166_ 0
C13092 _240_ net30 0.02971f
C13093 clknet_4_11_0_clk _700_/a_1840_334# 0.01422f
C13094 tx net33 0.03307f
C13095 hold102/a_326_118# baud_inst.counter\[16\] 0.00332f
C13096 hold118/a_56_118# hold81/a_56_118# 0.06338f
C13097 _447_/a_81_118# net24 0
C13098 FILLER_8_63/a_40_246# _182_ 0.00178f
C13099 _653_/a_38_114# net137 0
C13100 fanout39/a_40_152# _689_/a_38_114# 0
C13101 _670_/a_1785_429# net29 0
C13102 _047_ hold73/a_438_182# 0.00749f
C13103 net124 _155_ 0.11596f
C13104 _673_/a_132_114# clknet_4_1_0_clk 0
C13105 tx _705_/a_2002_114# 0
C13106 hold118/a_438_182# net19 0.00204f
C13107 clknet_4_0_0_clk _681_/a_612_127# 0.00107f
C13108 _657_/a_38_114# net41 0.02828f
C13109 _240_ _647_/a_324_432# 0.00793f
C13110 net71 _128_ 0.05646f
C13111 hold111/a_438_182# _266_ 0.0055f
C13112 _691_/a_843_236# _690_/a_741_93# 0
C13113 _691_/a_741_93# _690_/a_843_236# 0
C13114 hold143/a_326_118# net143 0
C13115 _098_ baud_inst.counter\[13\] 0.03099f
C13116 _690_/a_1583_191# baud_inst.counter\[19\] 0.00268f
C13117 baud_inst.counter\[21\] _535_/a_146_122# 0
C13118 hold150/a_326_118# net78 0
C13119 _635_/a_1840_334# _632_/a_1489_191# 0
C13120 FILLER_16_70/a_40_246# _024_ 0
C13121 net15 rx_inst.data_reg\[4\] 0
C13122 hold140/a_56_118# _698_/a_741_93# 0.00125f
C13123 hold140/a_326_118# _698_/a_324_432# 0
C13124 net173 hold57/a_438_182# 0
C13125 hold88/a_326_118# net29 0
C13126 _403_/a_120_432# net56 0.00454f
C13127 baud_inst.counter\[14\] _520_/a_155_412# 0.0043f
C13128 _082_ VPWR 0.13722f
C13129 clkbuf_4_12_0_clk/a_27_118# FILLER_19_178/a_40_246# 0.01205f
C13130 clk _658_/a_2002_114# 0
C13131 _678_/a_741_93# _090_ 0.00312f
C13132 _049_ clknet_4_15_0_clk 0.00204f
C13133 _286_ hold115/a_56_118# 0
C13134 net37 _670_/a_324_432# 0
C13135 net178 baud_inst.counter\[14\] 0
C13136 baud_inst.counter\[22\] _296_ 0
C13137 net49 net107 0.02921f
C13138 _536_/a_192_429# fanout45/a_40_152# 0
C13139 _341_/a_71_118# net165 0
C13140 _230_ _229_ 0
C13141 baud_inst.counter\[16\] FILLER_15_42/a_40_246# 0
C13142 _697_/a_38_114# net162 0
C13143 net45 _108_ 0
C13144 _292_ _684_/a_2250_412# 0
C13145 VPWR _452_/a_155_412# 0.05813f
C13146 hold156/a_438_182# _188_ 0
C13147 net178 net97 0.0034f
C13148 net156 _356_/a_248_122# 0
C13149 _694_/a_298_337# _693_/a_1583_191# 0
C13150 net66 _635_/a_612_127# 0
C13151 _638_/a_1583_191# clknet_4_15_0_clk 0.00297f
C13152 _659_/a_1583_191# tx_inst.data_reg\[5\] 0
C13153 hold131/a_326_118# _633_/a_38_114# 0
C13154 hold131/a_56_118# _633_/a_324_432# 0
C13155 _039_ net40 0.00342f
C13156 baud_inst.counter\[17\] _688_/a_1840_334# 0.03068f
C13157 _448_/a_244_140# _223_ 0
C13158 _675_/a_2002_114# net38 0
C13159 net16 _639_/a_741_93# 0
C13160 fanout40/a_40_152# _690_/a_1583_191# 0.00211f
C13161 rx_data[4] _639_/a_324_432# 0
C13162 _244_ _139_ 0.01135f
C13163 _206_ net172 0.08112f
C13164 _118_ _704_/a_324_432# 0
C13165 VPWR clknet_0_clk 4.97433f
C13166 hold65/a_438_182# net71 0
C13167 _316_ _313_ 0.04282f
C13168 _143_ _653_/a_298_337# 0.00392f
C13169 _492_/a_170_412# _162_ 0
C13170 net47 _633_/a_324_432# 0.00112f
C13171 hold157/a_56_118# _015_ 0
C13172 hold157/a_438_182# net160 0.00854f
C13173 hold157/a_326_118# _296_ 0.0098f
C13174 net6 _066_ 0.00741f
C13175 _092_ _679_/a_132_114# 0
C13176 _283_ _492_/a_170_412# 0.00206f
C13177 _677_/a_298_337# FILLER_8_92/a_32_246# 0
C13178 clknet_4_8_0_clk _687_/a_1840_334# 0.03951f
C13179 FILLER_24_133/a_32_246# _161_ 0
C13180 _125_ _156_ 0.16893f
C13181 net51 _704_/a_550_127# 0
C13182 hold79/a_438_182# _672_/a_843_236# 0
C13183 _657_/a_843_236# _070_ 0
C13184 tx_inst.bit_index\[2\] FILLER_7_176/a_32_246# 0
C13185 net97 _508_/a_380_412# 0
C13186 _650_/a_2250_412# _668_/a_843_236# 0
C13187 net177 _189_ 0.01529f
C13188 net48 clknet_4_12_0_clk 0.13766f
C13189 _232_ net52 0
C13190 net36 _425_/a_46_156# 0.0257f
C13191 rx_inst.bit_index\[1\] _425_/a_268_412# 0
C13192 hold97/a_326_118# _509_/a_155_412# 0
C13193 _667_/a_741_93# FILLER_10_145/a_40_246# 0
C13194 _129_ _639_/a_1785_429# 0.00104f
C13195 _265_ _639_/a_612_127# 0.00249f
C13196 net94 net92 0.08591f
C13197 net40 _682_/a_1583_191# 0
C13198 net92 _501_/a_154_118# 0.00197f
C13199 clknet_0_clk hold93/a_326_118# 0
C13200 _120_ tx_inst.state\[2\] 0.00348f
C13201 _077_ VPWR 0.05414f
C13202 _651_/a_1583_191# net168 0
C13203 rx_data[7] hold118/a_326_118# 0.00105f
C13204 _216_ _172_ 0
C13205 clknet_4_3_0_clk _652_/a_1785_429# 0
C13206 _527_/a_341_118# net160 0
C13207 _674_/a_1583_191# _672_/a_612_127# 0
C13208 _670_/a_324_432# _670_/a_843_236# -0
C13209 _661_/a_298_337# net55 0.0068f
C13210 hold54/a_438_182# net33 0.05485f
C13211 clknet_4_3_0_clk clkbuf_4_1_0_clk/a_27_118# 0.00119f
C13212 hold152/a_326_118# _280_ 0
C13213 net44 _691_/a_132_114# 0
C13214 _384_/a_285_412# _209_ 0
C13215 _662_/a_612_127# net41 0
C13216 _217_ net26 0.04728f
C13217 hold166/a_438_182# VPWR 0.00373f
C13218 _460_/a_22_110# _153_ 0.00308f
C13219 net35 _226_ 0.03475f
C13220 FILLER_25_177/a_40_246# clknet_0_clk 0.02043f
C13221 _144_ _664_/a_38_114# 0
C13222 _065_ _664_/a_324_432# 0
C13223 _132_ FILLER_19_118/a_32_246# 0
C13224 VPWR _348_/a_146_122# 0
C13225 net80 hold73/a_326_118# 0.00203f
C13226 net144 clknet_0_clk 0.00955f
C13227 hold173/a_326_118# clkbuf_4_4_0_clk/a_27_118# 0.00403f
C13228 hold128/a_326_118# _034_ 0.00246f
C13229 _673_/a_324_432# _672_/a_2250_412# 0
C13230 _673_/a_1583_191# _672_/a_843_236# 0
C13231 _673_/a_2250_412# _672_/a_324_432# 0
C13232 _673_/a_843_236# _672_/a_1583_191# 0
C13233 VPWR _386_/a_59_156# 0.00143f
C13234 net183 FILLER_9_169/a_32_246# 0
C13235 net122 _667_/a_550_127# 0
C13236 net37 _667_/a_612_127# 0.00124f
C13237 _668_/a_1840_334# rx_inst.state\[1\] 0.00124f
C13238 _100_ net88 0.00168f
C13239 _692_/a_298_337# VPWR 0.00421f
C13240 _664_/a_681_505# _005_ 0
C13241 _664_/a_741_93# tx_inst.state\[2\] 0.00534f
C13242 FILLER_0_161/a_40_246# net9 0.02461f
C13243 _678_/a_298_337# baud_inst.counter\[6\] 0.01181f
C13244 _046_ hold111/a_56_118# 0.00711f
C13245 VPWR _182_ 0.5932f
C13246 _234_ net2 0.01588f
C13247 output12/a_40_152# net69 0
C13248 _346_/a_252_412# baud_inst.counter\[30\] 0
C13249 _346_/a_354_412# baud_inst.counter\[31\] 0
C13250 _663_/a_38_114# _666_/a_741_93# 0.00135f
C13251 _663_/a_324_432# _666_/a_324_432# 0
C13252 net2 _669_/a_2250_412# 0
C13253 _538_/a_277_118# net75 0
C13254 baud_inst.counter\[31\] _347_/a_248_122# 0
C13255 _339_/a_1023_118# clknet_0_clk 0
C13256 _143_ _652_/a_843_236# 0
C13257 _704_/a_298_337# VPWR 0.00306f
C13258 VPWR _685_/a_1840_334# 0.00167f
C13259 _686_/a_298_337# net91 0.00584f
C13260 hold124/a_326_118# _264_ 0
C13261 VPWR _666_/a_1489_191# 0
C13262 _127_ clknet_0_clk 0
C13263 _009_ hold109/a_438_182# 0
C13264 clknet_4_4_0_clk _221_ 0.00121f
C13265 VPWR _689_/a_1840_334# 0.02254f
C13266 _405_/a_229_118# net62 0
C13267 rx_inst.data_reg\[3\] FILLER_18_210/a_32_246# 0
C13268 _442_/a_248_122# net52 0
C13269 hold123/a_438_182# FILLER_12_117/a_40_246# 0.00941f
C13270 fanout49/a_40_152# _106_ 0
C13271 _360_/a_886_118# _067_ 0
C13272 _360_/a_295_385# tx_inst.data_reg\[2\] 0.00339f
C13273 _360_/a_382_118# clknet_4_4_0_clk 0.03215f
C13274 _663_/a_1583_191# clkbuf_4_7_0_clk/a_27_118# 0.00579f
C13275 hold74/a_326_118# _240_ 0
C13276 _637_/a_612_127# net30 0
C13277 baud_inst.counter\[20\] _694_/a_843_236# 0.01598f
C13278 _182_ hold93/a_326_118# 0
C13279 clknet_4_14_0_clk _139_ 0.02746f
C13280 net60 _349_/a_248_122# 0
C13281 clknet_4_12_0_clk _250_ 0.15494f
C13282 net84 hold84/a_438_182# 0.02911f
C13283 clknet_4_11_0_clk hold58/a_438_182# 0.05759f
C13284 clknet_4_5_0_clk _654_/a_1840_334# 0.00162f
C13285 _660_/a_1785_429# _065_ 0
C13286 _660_/a_1583_191# tx_inst.data_reg\[0\] 0
C13287 FILLER_8_21/a_32_246# FILLER_8_19/a_40_246# 0.0524f
C13288 tx_done rx 0.02761f
C13289 net23 net2 0.01328f
C13290 _170_ _253_ 0
C13291 net32 _251_ 0
C13292 net31 _241_ 0.78857f
C13293 net31 FILLER_25_163/a_32_246# 0
C13294 _641_/a_741_93# clknet_0_clk 0.00491f
C13295 hold152/a_56_118# net123 0
C13296 hold118/a_326_118# _636_/a_1840_334# 0
C13297 hold118/a_438_182# _636_/a_1583_191# 0
C13298 clknet_4_5_0_clk _664_/a_550_127# 0
C13299 clknet_4_7_0_clk _705_/a_2250_412# 0
C13300 _493_/a_139_160# _281_ 0
C13301 hold140/a_326_118# _025_ 0
C13302 hold140/a_438_182# _310_ 0
C13303 net16 _061_ 0
C13304 _266_ clknet_0_clk 0.0913f
C13305 hold170/a_56_118# _660_/a_843_236# 0
C13306 hold170/a_326_118# _660_/a_741_93# 0.00219f
C13307 hold152/a_326_118# _191_ 0
C13308 _529_/a_45_160# _100_ 0.02078f
C13309 _164_ VPWR 0.10674f
C13310 _039_ _682_/a_741_93# 0
C13311 net116 _682_/a_843_236# 0
C13312 _167_ clknet_0_clk 0.08388f
C13313 _690_/a_2250_412# VPWR 0.00778f
C13314 _246_ _227_ 0
C13315 _225_ _452_/a_155_412# 0.01359f
C13316 _170_ net29 1.18922f
C13317 net105 _550_/a_209_168# 0.01947f
C13318 _691_/a_741_93# _692_/a_324_432# 0
C13319 _642_/a_612_127# _132_ 0.00979f
C13320 _642_/a_1785_429# clknet_4_12_0_clk 0.00157f
C13321 _642_/a_2250_412# rx_inst.bit_index\[2\] 0.00155f
C13322 clknet_0_clk _647_/a_741_93# 0.00163f
C13323 hold107/a_56_118# _701_/a_324_432# 0
C13324 hold107/a_326_118# _701_/a_38_114# 0
C13325 clknet_4_11_0_clk _026_ 0
C13326 _678_/a_741_93# _677_/a_298_337# 0
C13327 net16 _465_/a_22_110# 0
C13328 rx_data[4] _465_/a_120_432# 0.00201f
C13329 _181_ _038_ 0.02868f
C13330 hold159/a_326_118# _382_/a_59_156# 0
C13331 _202_ net172 0.07824f
C13332 _225_ clknet_0_clk 0.04291f
C13333 clk _216_ 0.07226f
C13334 hold146/a_56_118# VPWR 0.03584f
C13335 net35 _434_/a_252_412# 0
C13336 net55 _384_/a_285_118# 0
C13337 _662_/a_843_236# _706_/a_843_236# 0
C13338 rx_data[4] _264_ 2.71577f
C13339 _379_/a_46_156# net170 0
C13340 net125 _158_ 0
C13341 tx_inst.data_reg\[6\] FILLER_1_173/a_32_246# 0
C13342 clknet_4_4_0_clk net9 0.05774f
C13343 _042_ _665_/a_1583_191# 0
C13344 clknet_4_14_0_clk _648_/a_38_114# 0.05673f
C13345 _680_/a_1840_334# net181 0.00115f
C13346 _680_/a_1583_191# net86 0.0035f
C13347 _672_/a_843_236# net40 0
C13348 tx_inst.bit_index\[0\] _651_/a_1840_334# 0.00671f
C13349 _305_ _694_/a_38_114# 0.00169f
C13350 baud_inst.counter\[21\] _693_/a_1840_334# 0
C13351 net33 _665_/a_324_432# 0.00132f
C13352 _355_/a_150_412# baud_inst.counter\[17\] 0.00141f
C13353 net29 hold62/a_56_118# 0.01906f
C13354 FILLER_16_154/a_32_246# VPWR 0.0748f
C13355 net47 clkbuf_4_15_0_clk/a_27_118# 0.00712f
C13356 net27 _142_ 0
C13357 _659_/a_2250_412# _339_/a_71_118# 0
C13358 hold59/a_326_118# _180_ 0
C13359 net153 _280_ 0.50182f
C13360 hold111/a_56_118# _043_ 0.01382f
C13361 _643_/a_1583_191# clknet_4_15_0_clk 0
C13362 rx_done input2/a_40_152# 0.00184f
C13363 net42 net27 0.00501f
C13364 _064_ _068_ 0
C13365 _339_/a_589_385# net43 0
C13366 _660_/a_741_93# VPWR 0.03541f
C13367 net72 FILLER_27_210/a_40_246# 0.03327f
C13368 VPWR FILLER_8_14/a_32_246# 0.08398f
C13369 _646_/a_1583_191# _157_ 0.04481f
C13370 _083_ _670_/a_38_114# 0.03736f
C13371 net65 _649_/a_1583_191# 0.00364f
C13372 _394_/a_120_432# _200_ 0.00127f
C13373 _494_/a_279_412# net29 0.00288f
C13374 _374_/a_550_140# net51 0
C13375 _174_ _341_/a_1377_160# 0.00135f
C13376 net160 net40 0.16522f
C13377 baud_inst.counter\[28\] _703_/a_38_114# 0.01425f
C13378 baud_inst.counter\[31\] _703_/a_298_337# 0.00297f
C13379 FILLER_21_192/a_40_246# net47 0.03483f
C13380 net79 _672_/a_38_114# 0.00355f
C13381 _008_ _672_/a_298_337# 0.03274f
C13382 VPWR _700_/a_843_236# 0.00228f
C13383 _661_/a_741_93# clknet_4_1_0_clk 0.02449f
C13384 baud_inst.counter\[4\] clkbuf_4_3_0_clk/a_27_118# 0.00787f
C13385 _233_ net2 0
C13386 _657_/a_1840_334# net41 0.00223f
C13387 clknet_4_0_0_clk net117 0.01207f
C13388 _643_/a_612_127# FILLER_21_192/a_40_246# 0
C13389 _691_/a_741_93# _018_ 0.00195f
C13390 _170_ hold119/a_56_118# 0
C13391 _240_ _647_/a_2250_412# 0.00309f
C13392 _013_ _297_ 0
C13393 _195_ fanout34/a_40_152# 0
C13394 _694_/a_741_93# _701_/a_38_114# 0
C13395 _505_/a_76_160# _096_ 0
C13396 _101_ _688_/a_298_337# 0.03613f
C13397 _667_/a_132_114# net63 0
C13398 VPWR hold82/a_438_182# 0.00262f
C13399 _128_ _273_ 0.001f
C13400 hold168/a_326_118# clknet_4_4_0_clk 0.0012f
C13401 _093_ _681_/a_843_236# 0.00169f
C13402 net56 _141_ 0.16177f
C13403 baud_inst.counter\[14\] _297_ 0.43617f
C13404 VPWR FILLER_6_189/a_40_246# 0.13172f
C13405 baud_inst.counter\[26\] net142 0.00241f
C13406 FILLER_29_221/a_32_246# clknet_4_15_0_clk 0
C13407 _003_ _670_/a_1583_191# 0.00122f
C13408 net37 _670_/a_2250_412# 0.01646f
C13409 _378_/a_382_118# _381_/a_46_156# 0
C13410 clk FILLER_0_163/a_32_246# 0
C13411 net146 clknet_4_6_0_clk 0
C13412 net133 _700_/a_324_432# 0.03724f
C13413 _028_ _700_/a_298_337# 0
C13414 net182 _494_/a_279_412# 0
C13415 hold176/a_56_118# net25 0
C13416 net35 FILLER_19_149/a_40_246# 0.02309f
C13417 _659_/a_38_114# tx_inst.data_reg\[1\] 0
C13418 hold106/a_326_118# VPWR 0.0069f
C13419 _048_ VPWR 0.13654f
C13420 _412_/a_22_110# fanout28/a_40_152# 0
C13421 _234_ _169_ 0.14779f
C13422 _276_ FILLER_6_191/a_32_246# 0.00161f
C13423 _191_ net153 0
C13424 _638_/a_2002_114# clknet_4_15_0_clk 0
C13425 _257_ FILLER_20_177/a_32_246# 0
C13426 _170_ _444_/a_550_140# 0
C13427 baud_inst.counter\[3\] _085_ 0.00658f
C13428 net29 clknet_4_2_0_clk 0
C13429 hold161/a_326_118# baud_inst.counter\[16\] 0.00559f
C13430 _675_/a_298_337# VPWR 0.01763f
C13431 hold54/a_326_118# net55 0
C13432 _143_ _653_/a_1583_191# 0.00716f
C13433 net47 _633_/a_2250_412# 0.0042f
C13434 hold113/a_438_182# clknet_4_8_0_clk 0
C13435 hold65/a_438_182# _273_ 0.00317f
C13436 hold165/a_326_118# net54 0
C13437 hold155/a_438_182# VPWR 0.0146f
C13438 _046_ FILLER_18_210/a_32_246# 0.00185f
C13439 hold63/a_326_118# clkbuf_0_clk/a_116_82# 0
C13440 _668_/a_324_432# rx_inst.state\[4\] 0.00197f
C13441 _019_ hold60/a_438_182# 0
C13442 _660_/a_324_432# net179 0.02541f
C13443 _641_/a_2250_412# _261_ 0.00205f
C13444 _641_/a_1840_334# _262_ 0.01564f
C13445 _641_/a_1583_191# _131_ 0.00142f
C13446 clkbuf_4_1_0_clk/a_27_118# _149_ 0
C13447 net30 hold51/a_56_118# 0
C13448 FILLER_8_35/a_32_246# _039_ 0.02849f
C13449 net108 _353_/a_248_122# 0.00216f
C13450 _650_/a_1583_191# _668_/a_1489_191# 0
C13451 _061_ _668_/a_741_93# 0
C13452 VPWR FILLER_26_172/a_40_246# 0.16162f
C13453 _680_/a_298_337# net38 0.00544f
C13454 _265_ net81 0.61107f
C13455 _129_ _050_ 0.0062f
C13456 net178 baud_inst.counter\[17\] 0.00798f
C13457 _300_ _522_/a_380_412# 0
C13458 hold120/a_56_118# VPWR 0.03527f
C13459 _285_ _286_ 0
C13460 net67 _702_/a_843_236# 0.03195f
C13461 FILLER_29_221/a_32_246# _637_/a_324_432# 0
C13462 net173 net183 0.03205f
C13463 _651_/a_2002_114# net168 0
C13464 VPWR FILLER_10_110/a_40_246# 0.14317f
C13465 net48 _429_/a_142_412# 0.00336f
C13466 clknet_4_3_0_clk _063_ 0.0233f
C13467 _189_ _188_ 0
C13468 net155 _658_/a_741_93# 0
C13469 _206_ _658_/a_843_236# 0
C13470 fanout34/a_40_152# _401_/a_22_110# 0
C13471 hold102/a_438_182# _299_ 0
C13472 _632_/a_132_114# _264_ 0
C13473 _087_ net135 0.00142f
C13474 net44 _691_/a_1489_191# 0.00338f
C13475 net171 _209_ 0
C13476 _654_/a_681_505# _065_ 0
C13477 _654_/a_324_432# tx_inst.data_reg\[0\] 0.00125f
C13478 _245_ _158_ 0.01963f
C13479 hold112/a_56_118# net24 0.01193f
C13480 clknet_4_12_0_clk net143 0.01739f
C13481 _073_ net41 0.02945f
C13482 baud_inst.counter\[14\] FILLER_17_96/a_32_246# 0
C13483 hold76/a_438_182# _694_/a_741_93# 0
C13484 hold76/a_326_118# _694_/a_843_236# 0
C13485 net168 FILLER_5_192/a_40_246# 0.02518f
C13486 rx_inst.data_reg\[0\] _160_ 0.0013f
C13487 _683_/a_298_337# net29 0
C13488 fanout31/a_40_152# _140_ 0
C13489 net37 net63 0.08865f
C13490 _692_/a_1583_191# VPWR 0.02779f
C13491 _664_/a_1785_429# tx_inst.state\[2\] 0
C13492 _183_ _505_/a_170_160# 0
C13493 _127_ _048_ 0
C13494 _703_/a_324_432# _703_/a_741_93# 0
C13495 _678_/a_1583_191# baud_inst.counter\[6\] 0.03843f
C13496 net87 _684_/a_843_236# 0
C13497 _118_ net21 0.02258f
C13498 net12 hold69/a_326_118# 0.0268f
C13499 net30 _457_/a_120_432# 0
C13500 tx_data[5] FILLER_0_103/a_32_246# 0
C13501 baud_inst.counter\[31\] _179_ 1.40723f
C13502 hold66/a_438_182# _264_ 0
C13503 _663_/a_741_93# _666_/a_1840_334# 0.00142f
C13504 _663_/a_324_432# _666_/a_2250_412# 0
C13505 _663_/a_843_236# _666_/a_1583_191# 0
C13506 baud_inst.counter\[22\] net75 0.13954f
C13507 _704_/a_1583_191# VPWR 0.00326f
C13508 _686_/a_1583_191# net91 0
C13509 _234_ _084_ 0
C13510 _032_ _551_/a_272_160# 0
C13511 _556_/a_155_160# _314_ 0
C13512 _378_/a_59_156# _377_/a_268_412# 0
C13513 hold129/a_56_118# baud_inst.counter\[13\] 0.01538f
C13514 _264_ _648_/a_741_93# 0.0221f
C13515 net154 _089_ 0.00518f
C13516 _191_ _280_ 0.01295f
C13517 hold132/a_438_182# _253_ 0
C13518 hold148/a_438_182# VPWR 0.00641f
C13519 _180_ _544_/a_268_412# 0
C13520 hold100/a_56_118# net100 0.00234f
C13521 _659_/a_843_236# VPWR 0.00333f
C13522 FILLER_4_172/a_32_246# net168 0
C13523 hold173/a_326_118# VPWR 0.00579f
C13524 _216_ hold169/a_56_118# 0.00586f
C13525 VPWR net43 1.90322f
C13526 _360_/a_500_118# tx_inst.data_reg\[2\] 0.00508f
C13527 _360_/a_810_118# clknet_4_4_0_clk 0.00194f
C13528 net34 _217_ 0.30247f
C13529 net6 FILLER_2_79/a_40_246# 0
C13530 hold55/a_56_118# tx_inst.state\[3\] 0
C13531 fanout31/a_40_152# net49 0.00228f
C13532 _045_ output13/a_40_152# 0
C13533 _314_ VPWR 0.10588f
C13534 net72 net30 0
C13535 _048_ _266_ 0.00539f
C13536 baud_inst.counter\[20\] _694_/a_612_127# 0.0265f
C13537 _511_/a_150_412# _287_ 0
C13538 _170_ FILLER_24_156/a_32_246# 0.00107f
C13539 _069_ net171 0
C13540 _641_/a_1785_429# clknet_0_clk 0
C13541 _698_/a_741_93# baud_inst.counter\[25\] 0
C13542 net142 _109_ 0
C13543 _233_ _169_ 0.01605f
C13544 hold54/a_56_118# input11/a_40_152# 0
C13545 net48 net13 0
C13546 baud_inst.counter\[28\] clknet_4_11_0_clk 0.16795f
C13547 net44 net45 0.01138f
C13548 _634_/a_741_93# clknet_4_15_0_clk 0.02371f
C13549 tx_inst.data_reg\[6\] _660_/a_132_114# 0
C13550 tx_inst.data_reg\[1\] _385_/a_268_412# 0
C13551 _058_ _647_/a_38_114# 0.01256f
C13552 VPWR _664_/a_324_432# 0.01838f
C13553 _707_/a_843_236# VPWR 0.00185f
C13554 _163_ clknet_0_clk 0.31251f
C13555 net55 _665_/a_38_114# 0.02709f
C13556 hold122/a_438_182# net62 0
C13557 VPWR _436_/a_550_140# 0
C13558 _288_ _682_/a_550_127# 0
C13559 net71 _268_ 0.08561f
C13560 baud_inst.counter\[22\] _701_/a_324_432# 0.00377f
C13561 hold136/a_438_182# _030_ 0.00209f
C13562 _680_/a_1489_191# hold115/a_326_118# 0
C13563 net115 _505_/a_170_160# 0.00189f
C13564 _553_/a_170_412# _029_ 0
C13565 clknet_4_1_0_clk _070_ 0.01755f
C13566 _678_/a_1840_334# _677_/a_324_432# 0
C13567 _678_/a_1583_191# _677_/a_741_93# 0
C13568 hold88/a_56_118# net90 0
C13569 clknet_0_clk _647_/a_1785_429# 0
C13570 _691_/a_843_236# _692_/a_1840_334# 0
C13571 _053_ clknet_4_12_0_clk 0.03388f
C13572 rx_data[4] _269_ 0.0176f
C13573 hold98/a_56_118# _682_/a_324_432# 0.00131f
C13574 hold154/a_326_118# _034_ 0
C13575 net14 _634_/a_324_432# 0.0035f
C13576 _345_/a_354_412# clknet_4_10_0_clk 0.00137f
C13577 net79 FILLER_2_81/a_32_246# 0
C13578 net54 _214_ 1.07042f
C13579 output22/a_40_152# rx 0
C13580 _662_/a_1840_334# _706_/a_1583_191# 0
C13581 _662_/a_1583_191# _706_/a_1840_334# 0.00123f
C13582 clkbuf_4_15_0_clk/a_27_118# _649_/a_324_432# 0.00409f
C13583 net55 _148_ 0.01805f
C13584 hold74/a_56_118# net19 0.00195f
C13585 _110_ VPWR 0.13524f
C13586 clknet_4_14_0_clk _648_/a_1840_334# 0
C13587 net45 hold114/a_438_182# 0
C13588 hold171/a_326_118# clk 0
C13589 hold56/a_326_118# clknet_4_6_0_clk 0.00242f
C13590 hold151/a_438_182# _161_ 0
C13591 _023_ _694_/a_1583_191# 0
C13592 _305_ _694_/a_1840_334# 0
C13593 fanout33/a_40_152# _665_/a_1489_191# 0
C13594 net33 _665_/a_2250_412# 0.04642f
C13595 baud_inst.counter\[19\] baud_inst.counter\[17\] 0.02582f
C13596 clknet_4_4_0_clk _653_/a_550_127# 0
C13597 _544_/a_46_156# baud_inst.counter\[24\] 0
C13598 _444_/a_244_412# _242_ 0.00158f
C13599 net54 FILLER_3_177/a_32_246# 0
C13600 hold130/a_326_118# VPWR 0.00468f
C13601 _168_ _140_ 0.02002f
C13602 net40 hold94/a_326_118# 0.00167f
C13603 _671_/a_681_505# VPWR 0
C13604 fanout25/a_40_152# _224_ 0.05391f
C13605 net58 _700_/a_1583_191# 0
C13606 _705_/a_741_93# tx_inst.state\[3\] 0
C13607 _660_/a_1785_429# VPWR 0
C13608 net16 _156_ 0
C13609 hold56/a_438_182# _217_ 0
C13610 hold182/a_56_118# _676_/a_1583_191# 0
C13611 _646_/a_2002_114# _157_ 0
C13612 _637_/a_324_432# _634_/a_741_93# 0.00512f
C13613 _637_/a_741_93# _634_/a_324_432# 0.00304f
C13614 _091_ hold94/a_56_118# 0.0239f
C13615 _083_ _670_/a_1840_334# 0
C13616 net65 _649_/a_2002_114# 0
C13617 clknet_4_3_0_clk _089_ 0.26899f
C13618 _249_ _435_/a_268_436# 0.00266f
C13619 net35 net31 3.02786f
C13620 _204_ net51 0.02652f
C13621 _364_/a_155_412# _196_ 0.00254f
C13622 net94 _680_/a_1785_429# 0
C13623 net39 _682_/a_38_114# 0.00408f
C13624 _163_ _182_ 0
C13625 baud_inst.counter\[30\] _703_/a_132_114# 0
C13626 baud_inst.counter\[31\] _703_/a_1583_191# 0.04835f
C13627 net79 _672_/a_1840_334# 0.00796f
C13628 _661_/a_324_432# _072_ 0.03557f
C13629 hold97/a_56_118# hold116/a_438_182# 0.00122f
C13630 hold97/a_438_182# hold116/a_56_118# 0.00122f
C13631 _177_ _347_/a_248_122# 0.00377f
C13632 tx_data[0] _388_/a_559_412# 0
C13633 hold117/a_326_118# VPWR 0.03023f
C13634 tx_data[4] _381_/a_46_156# 0
C13635 _677_/a_324_432# net29 0
C13636 tx_inst.data_reg\[4\] _360_/a_295_385# 0.00561f
C13637 tx_inst.bit_index\[1\] fanout41/a_40_152# 0
C13638 hold167/a_56_118# net29 0.01827f
C13639 _233_ _084_ 0
C13640 _691_/a_1489_191# _690_/a_1840_334# 0
C13641 _691_/a_843_236# _103_ 0
C13642 _691_/a_324_432# clknet_4_8_0_clk 0.0283f
C13643 hold99/a_438_182# clknet_4_9_0_clk 0
C13644 fanout40/a_40_152# baud_inst.counter\[17\] 0.02716f
C13645 net180 hold180/a_56_118# 0
C13646 _640_/a_324_432# clknet_4_14_0_clk 0.01782f
C13647 hold179/a_326_118# _654_/a_324_432# 0
C13648 hold179/a_56_118# _654_/a_741_93# 0.00214f
C13649 net94 _680_/a_741_93# 0
C13650 _138_ clknet_0_clk 0.00757f
C13651 tx_inst.data_reg\[5\] FILLER_7_121/a_40_246# 0.00114f
C13652 hold97/a_326_118# net108 0.0012f
C13653 hold97/a_56_118# net97 0
C13654 clknet_4_8_0_clk _541_/a_177_436# 0.003f
C13655 net69 rx_inst.data_reg\[6\] 0
C13656 hold69/a_326_118# _632_/a_1583_191# 0
C13657 _646_/a_843_236# clknet_4_12_0_clk 0.05312f
C13658 hold169/a_438_182# _666_/a_324_432# 0
C13659 _359_/a_120_432# _176_ 0.005f
C13660 _232_ clknet_0_clk 0.0719f
C13661 _136_ net24 0
C13662 net36 _228_ 0.00169f
C13663 VPWR clkbuf_4_13_0_clk/a_27_118# 0.01958f
C13664 _045_ FILLER_27_210/a_40_246# 0.00597f
C13665 rx_inst.bit_index\[1\] rx_inst.state\[2\] 0.67293f
C13666 _255_ _158_ 0
C13667 _635_/a_324_432# _264_ 0.0514f
C13668 _378_/a_285_412# _209_ 0.00136f
C13669 _206_ _381_/a_46_156# 0.01916f
C13670 VPWR net152 0.4357f
C13671 net163 _527_/a_341_118# 0
C13672 hold133/a_56_118# _700_/a_1840_334# 0
C13673 hold133/a_326_118# _700_/a_1583_191# 0
C13674 hold135/a_438_182# FILLER_6_54/a_32_246# 0
C13675 _659_/a_1840_334# tx_inst.data_reg\[1\] 0.03419f
C13676 _290_ _684_/a_38_114# 0
C13677 _522_/a_177_436# _296_ 0
C13678 _522_/a_209_168# _015_ 0.02801f
C13679 clknet_4_11_0_clk _703_/a_843_236# 0.03737f
C13680 hold119/a_438_182# net119 0.0294f
C13681 FILLER_19_75/a_40_246# _310_ 0
C13682 hold150/a_56_118# net48 0.00718f
C13683 FILLER_26_88/a_40_246# _702_/a_1840_334# 0
C13684 _462_/a_22_110# net126 0
C13685 _107_ _693_/a_843_236# 0.00582f
C13686 clknet_4_8_0_clk _549_/a_155_412# 0.00429f
C13687 hold164/a_56_118# VPWR 0.04987f
C13688 _499_/a_177_436# _282_ 0.00122f
C13689 _499_/a_380_412# baud_inst.counter\[4\] 0
C13690 net45 _551_/a_76_160# 0
C13691 _042_ _203_ 0
C13692 _167_ _436_/a_550_140# 0
C13693 net16 _050_ 0.00378f
C13694 _675_/a_1583_191# VPWR 0.00988f
C13695 _143_ _653_/a_2002_114# 0
C13696 _498_/a_165_412# VPWR 0
C13697 hold56/a_326_118# net29 0
C13698 hold153/a_438_182# baud_inst.counter\[4\] 0.00449f
C13699 clknet_4_12_0_clk _451_/a_155_412# 0.01172f
C13700 _688_/a_741_93# net161 0
C13701 baud_inst.counter\[31\] hold113/a_56_118# 0
C13702 input5/a_40_152# VPWR 0.01461f
C13703 _680_/a_2002_114# net38 0
C13704 fanout33/a_40_152# _201_ 0
C13705 net152 hold93/a_326_118# 0.00627f
C13706 _117_ _152_ 0.04685f
C13707 net98 net40 0.02392f
C13708 tx_inst.data_reg\[4\] tx_data[6] 0.00155f
C13709 _092_ baud_inst.counter\[7\] 0
C13710 _466_/a_22_110# FILLER_17_199/a_40_246# 0
C13711 _698_/a_843_236# net140 0
C13712 net176 _697_/a_324_432# 0
C13713 net121 net120 0.02448f
C13714 _641_/a_324_432# net142 0
C13715 _079_ clk 0.05555f
C13716 net14 net18 0.05271f
C13717 _642_/a_843_236# _641_/a_843_236# 0
C13718 hold65/a_56_118# net30 0
C13719 _660_/a_2250_412# net179 0.00275f
C13720 _641_/a_2002_114# _131_ 0
C13721 _054_ _223_ 0
C13722 rx_data[4] _153_ 0
C13723 _650_/a_741_93# _456_/a_155_412# 0
C13724 _224_ FILLER_17_162/a_32_246# 0
C13725 net45 _302_ 0.02207f
C13726 hold79/a_56_118# baud_inst.counter\[0\] 0.02604f
C13727 _147_ _070_ 0.16736f
C13728 rx_inst.data_reg\[7\] _668_/a_1583_191# 0
C13729 _680_/a_1583_191# net38 0.01085f
C13730 hold167/a_438_182# FILLER_15_116/a_40_246# 0.00941f
C13731 _555_/a_209_168# _115_ 0
C13732 net67 _702_/a_612_127# 0.0012f
C13733 _073_ _171_ 0.00327f
C13734 _671_/a_1583_191# _000_ 0.00937f
C13735 clkbuf_4_10_0_clk/a_27_118# net45 0.01444f
C13736 _699_/a_1583_191# _311_ 0
C13737 hold64/a_56_118# _122_ 0
C13738 _699_/a_1840_334# baud_inst.counter\[25\] 0
C13739 _674_/a_1489_191# clknet_4_0_0_clk 0.00628f
C13740 _114_ _701_/a_38_114# 0.0062f
C13741 _632_/a_1489_191# _264_ 0.00867f
C13742 _654_/a_2250_412# tx_inst.data_reg\[0\] 0.00792f
C13743 _361_/a_146_122# tx_inst.bit_index\[1\] 0.00535f
C13744 _254_ FILLER_26_151/a_32_246# 0
C13745 _489_/a_115_308# net135 0
C13746 _289_ _681_/a_2250_412# 0
C13747 hold115/a_438_182# VPWR 0.00208f
C13748 _679_/a_324_432# net95 0.01127f
C13749 _679_/a_741_93# net29 0.03485f
C13750 _679_/a_298_337# _037_ 0.0138f
C13751 _642_/a_843_236# _260_ 0
C13752 FILLER_18_169/a_40_246# _249_ 0.01927f
C13753 net18 _637_/a_741_93# 0.00235f
C13754 _683_/a_1583_191# net29 0.00944f
C13755 _461_/a_22_110# _048_ 0
C13756 _059_ _264_ 0.02763f
C13757 _240_ _054_ 0
C13758 hold170/a_56_118# _654_/a_132_114# 0
C13759 tx_inst.data_reg\[6\] _654_/a_38_114# 0.00635f
C13760 net42 _676_/a_741_93# 0
C13761 _661_/a_1489_191# net41 0
C13762 hold162/a_326_118# _309_ 0
C13763 _692_/a_2002_114# VPWR 0
C13764 _177_ _703_/a_298_337# 0
C13765 FILLER_13_68/a_40_246# net40 0
C13766 net87 _684_/a_612_127# 0
C13767 baud_inst.counter\[6\] hold95/a_326_118# 0.00113f
C13768 net93 _352_/a_46_156# 0.01425f
C13769 _678_/a_2002_114# baud_inst.counter\[6\] 0
C13770 _697_/a_741_93# FILLER_20_95/a_40_246# 0.00392f
C13771 hold143/a_326_118# VPWR 0.00626f
C13772 _697_/a_324_432# FILLER_21_96/a_40_246# 0
C13773 _063_ baud_inst.counter\[5\] 0.07943f
C13774 rx_inst.state\[3\] _652_/a_1840_334# 0
C13775 FILLER_14_70/a_40_246# net29 0.00221f
C13776 _229_ net180 0.01725f
C13777 hold74/a_56_118# _636_/a_1583_191# 0.00308f
C13778 net74 _636_/a_38_114# 0.02268f
C13779 hold142/a_56_118# net46 0
C13780 net44 net176 0.42485f
C13781 net31 _254_ 0.01866f
C13782 _378_/a_285_412# _207_ 0.00415f
C13783 net159 _211_ 0
C13784 _264_ _648_/a_1785_429# 0.00232f
C13785 tx_inst.data_reg\[7\] _657_/a_1840_334# 0.0012f
C13786 _489_/a_358_436# baud_inst.counter\[8\] 0.00182f
C13787 _094_ net38 0.92095f
C13788 _152_ net11 0
C13789 hold160/a_438_182# baud_inst.counter\[18\] 0
C13790 _431_/a_81_118# _223_ 0
C13791 _181_ net86 0.24531f
C13792 _266_ clkbuf_4_13_0_clk/a_27_118# 0.0145f
C13793 baud_inst.counter\[17\] FILLER_17_24/a_32_246# 0
C13794 _646_/a_1840_334# _473_/a_22_110# 0
C13795 net58 hold58/a_326_118# 0
C13796 net114 hold105/a_438_182# 0
C13797 _214_ _065_ 0
C13798 net184 clknet_4_4_0_clk 0.03189f
C13799 hold57/a_56_118# _403_/a_22_110# 0
C13800 VPWR _688_/a_38_114# 0.00627f
C13801 baud_inst.counter\[23\] _695_/a_38_114# 0.03731f
C13802 baud_inst.counter\[21\] _695_/a_741_93# 0
C13803 baud_inst.counter\[22\] _695_/a_298_337# 0.01412f
C13804 rx_inst.data_reg\[3\] net48 0
C13805 _540_/a_139_160# _308_ 0
C13806 hold98/a_438_182# _039_ 0
C13807 rx_inst.bit_index\[1\] _226_ 0.00161f
C13808 _633_/a_741_93# _471_/a_22_110# 0
C13809 _699_/a_2250_412# _180_ 0.02366f
C13810 _660_/a_38_114# clk 0.01607f
C13811 _698_/a_2250_412# _311_ 0
C13812 _052_ clknet_0_clk 0.01101f
C13813 _062_ net26 0
C13814 tx_inst.data_reg\[6\] _660_/a_1489_191# 0.00876f
C13815 VPWR _664_/a_2250_412# 0.00468f
C13816 net92 _499_/a_209_168# 0.01882f
C13817 _058_ _647_/a_1840_334# 0
C13818 _646_/a_1489_191# net143 0
C13819 _663_/a_843_236# _215_ 0
C13820 net129 net40 0.00272f
C13821 net55 _665_/a_1840_334# 0
C13822 hold177/a_56_118# _296_ 0
C13823 _155_ _264_ 0.1754f
C13824 VPWR _249_ 0.1554f
C13825 clkbuf_4_1_0_clk/a_27_118# clknet_0_clk 0.12048f
C13826 FILLER_5_164/a_40_246# tx_inst.bit_index\[1\] 0
C13827 _288_ clknet_4_2_0_clk 0.01833f
C13828 _346_/a_354_412# VPWR 0
C13829 net44 FILLER_21_96/a_40_246# 0
C13830 hold152/a_438_182# VPWR 0.00462f
C13831 _415_/a_170_412# net29 0
C13832 VPWR _347_/a_248_122# 0
C13833 _098_ net29 0.02834f
C13834 net29 hold180/a_326_118# 0
C13835 _434_/a_354_412# net25 0
C13836 net45 hold106/a_56_118# 0.0563f
C13837 _678_/a_2250_412# _677_/a_1840_334# 0
C13838 _690_/a_1583_191# baud_inst.counter\[16\] 0
C13839 _696_/a_741_93# net90 0.00111f
C13840 _268_ _273_ 0.00182f
C13841 _022_ _105_ 0
C13842 _166_ _666_/a_324_432# 0.07288f
C13843 _060_ _223_ 0
C13844 net98 _682_/a_741_93# 0.0051f
C13845 _009_ _682_/a_843_236# 0.03229f
C13846 _676_/a_741_93# _670_/a_298_337# 0
C13847 hold89/a_438_182# _518_/a_45_160# 0
C13848 net14 _634_/a_2250_412# 0.01984f
C13849 _045_ net30 0.20811f
C13850 _178_ clknet_4_10_0_clk 0.08467f
C13851 clknet_4_13_0_clk _632_/a_741_93# 0.02254f
C13852 _079_ net2 0
C13853 _073_ _706_/a_843_236# 0
C13854 _040_ _706_/a_324_432# 0.00108f
C13855 hold121/a_326_118# net46 0
C13856 _473_/a_22_110# _273_ 0.00315f
C13857 _279_ _504_/a_177_436# 0.00216f
C13858 baud_inst.counter\[14\] _684_/a_298_337# 0
C13859 hold152/a_56_118# _284_ 0.001f
C13860 _543_/a_146_122# _309_ 0.00102f
C13861 FILLER_19_178/a_40_246# _137_ 0
C13862 _636_/a_1489_191# net30 0.01244f
C13863 hold109/a_56_118# _096_ 0.01213f
C13864 _684_/a_38_114# FILLER_12_42/a_32_246# 0
C13865 baud_inst.counter\[28\] _550_/a_209_168# 0
C13866 _682_/a_681_505# clknet_4_2_0_clk 0
C13867 fanout33/a_40_152# tx_inst.state\[3\] 0
C13868 hold122/a_438_182# rx_inst.state\[3\] 0.0099f
C13869 clknet_0_clk FILLER_20_95/a_40_246# 0.00233f
C13870 _171_ net41 0.0019f
C13871 _310_ _309_ 0.13479f
C13872 _091_ baud_inst.counter\[6\] 0.01949f
C13873 net22 FILLER_8_236/a_40_246# 0.00185f
C13874 net97 _684_/a_298_337# 0
C13875 hold112/a_326_118# _448_/a_244_412# 0
C13876 _392_/a_496_118# net41 0
C13877 _671_/a_550_127# VPWR 0
C13878 clkbuf_4_11_0_clk/a_27_118# hold100/a_326_118# 0
C13879 net182 _098_ 0.00906f
C13880 hold87/a_326_118# baud_inst.counter\[12\] 0
C13881 _406_/a_154_118# clknet_0_clk 0
C13882 _128_ _638_/a_741_93# 0
C13883 _267_ _638_/a_843_236# 0
C13884 _635_/a_1583_191# FILLER_19_228/a_40_246# 0
C13885 _390_/a_382_118# _655_/a_1840_334# 0
C13886 _390_/a_59_156# _655_/a_2250_412# 0
C13887 _363_/a_120_432# clknet_4_4_0_clk 0.00115f
C13888 hold182/a_326_118# _676_/a_1489_191# 0
C13889 _637_/a_843_236# _634_/a_1840_334# 0
C13890 net2 fanout26/a_40_152# 0
C13891 _153_ _668_/a_843_236# 0
C13892 net48 _647_/a_681_505# 0
C13893 _632_/a_324_432# _122_ 0.00446f
C13894 _632_/a_741_93# net65 0
C13895 _481_/a_22_110# net27 0.00667f
C13896 hold143/a_326_118# _266_ 0.01465f
C13897 hold143/a_438_182# net30 0
C13898 net181 _066_ 0.00291f
C13899 _699_/a_1840_334# baud_inst.counter\[24\] 0
C13900 _196_ _197_ 0.87009f
C13901 net39 _682_/a_1840_334# 0
C13902 _177_ _179_ 0.01466f
C13903 net49 FILLER_22_22/a_32_246# 0.00138f
C13904 _689_/a_38_114# net157 0
C13905 baud_inst.counter\[30\] _703_/a_1489_191# 0
C13906 baud_inst.counter\[31\] _703_/a_2002_114# 0
C13907 net3 net165 0
C13908 _661_/a_132_114# tx_inst.data_reg\[7\] 0
C13909 net26 _650_/a_681_505# 0
C13910 VPWR net134 0.19449f
C13911 FILLER_8_116/a_40_246# VPWR 0.13619f
C13912 _547_/a_81_118# _165_ 0
C13913 _072_ clknet_4_1_0_clk 0.01017f
C13914 net177 clknet_0_clk 0.10897f
C13915 _640_/a_1583_191# _263_ 0.00187f
C13916 net7 _209_ 0.05445f
C13917 fanout27/a_40_152# _671_/a_843_236# 0
C13918 hold104/a_326_118# _300_ 0
C13919 tx_inst.data_reg\[4\] _360_/a_500_118# 0.00217f
C13920 _083_ net128 0
C13921 net36 _434_/a_150_412# 0
C13922 _691_/a_612_127# _103_ 0
C13923 _695_/a_38_114# FILLER_21_33/a_32_246# 0
C13924 _488_/a_380_412# net86 0.00153f
C13925 net179 _654_/a_843_236# 0
C13926 _640_/a_1840_334# rx_inst.bit_index\[0\] 0
C13927 _640_/a_2250_412# clknet_4_14_0_clk 0.01469f
C13928 _491_/a_192_429# net38 0
C13929 hold86/a_438_182# baud_inst.counter\[3\] 0
C13930 net39 clknet_4_1_0_clk 0
C13931 _178_ baud_inst.counter\[31\] 0.01437f
C13932 _107_ _701_/a_38_114# 0
C13933 hold54/a_56_118# _077_ 0
C13934 hold97/a_56_118# hold115/a_56_118# 0
C13935 _646_/a_612_127# clknet_4_12_0_clk 0.00474f
C13936 _555_/a_209_168# hold105/a_56_118# 0.00174f
C13937 _176_ _192_ 0.00587f
C13938 _652_/a_741_93# net43 0.00303f
C13939 _093_ net117 0
C13940 _089_ baud_inst.counter\[5\] 0
C13941 clknet_4_12_0_clk _435_/a_268_436# 0.00324f
C13942 _655_/a_843_236# _145_ 0.00746f
C13943 _198_ _166_ 0
C13944 rx_inst.data_reg\[1\] net150 0
C13945 net26 _670_/a_2250_412# 0
C13946 _531_/a_380_412# _300_ 0
C13947 _068_ tx_inst.data_reg\[3\] 0
C13948 hold65/a_438_182# _638_/a_741_93# 0.00404f
C13949 baud_inst.counter\[10\] baud_inst.counter\[9\] 0.00174f
C13950 hold128/a_326_118# _685_/a_741_93# 0.00367f
C13951 hold128/a_438_182# _685_/a_324_432# 0
C13952 hold128/a_56_118# _685_/a_843_236# 0
C13953 net166 _224_ 0
C13954 hold132/a_326_118# _134_ 0.00684f
C13955 _635_/a_2250_412# _264_ 0.00206f
C13956 net155 _209_ 0.16619f
C13957 _677_/a_843_236# net40 0
C13958 hold183/a_56_118# FILLER_10_147/a_32_246# 0
C13959 _286_ FILLER_8_63/a_40_246# 0.02416f
C13960 hold158/a_326_118# baud_inst.counter\[16\] 0
C13961 hold131/a_438_182# clknet_0_clk 0
C13962 _138_ FILLER_26_172/a_40_246# 0.01157f
C13963 _073_ net146 0.00235f
C13964 baud_inst.counter\[26\] clknet_4_11_0_clk 0
C13965 baud_inst.counter\[27\] clkload2/Y 0.0136f
C13966 hold75/a_326_118# baud_inst.counter\[23\] 0.03007f
C13967 _679_/a_843_236# hold95/a_326_118# 0
C13968 _679_/a_741_93# hold95/a_438_182# 0.00108f
C13969 _690_/a_324_432# net157 0
C13970 _690_/a_38_114# _299_ 0
C13971 _296_ _015_ 0.11657f
C13972 clknet_4_11_0_clk _703_/a_612_127# 0.00196f
C13973 _091_ _677_/a_741_93# 0
C13974 _650_/a_38_114# net119 0.01835f
C13975 _650_/a_324_432# _061_ 0.04399f
C13976 clknet_4_8_0_clk _027_ 0.28338f
C13977 net74 rx_data[7] 0.00362f
C13978 net151 VPWR 0.08746f
C13979 _128_ _154_ 0
C13980 _468_/a_22_110# _240_ 0
C13981 _467_/a_22_110# _122_ 0
C13982 net179 FILLER_3_207/a_40_246# 0
C13983 _036_ _282_ 0.01887f
C13984 VPWR _703_/a_298_337# 0.00346f
C13985 _643_/a_1489_191# clknet_0_clk 0.01924f
C13986 _167_ _249_ 0.88289f
C13987 _152_ _006_ 0
C13988 net48 hold125/a_56_118# 0.00723f
C13989 _035_ VPWR 0.18507f
C13990 _687_/a_843_236# _297_ 0
C13991 rx_inst.bit_index\[2\] net24 0.11567f
C13992 hold179/a_56_118# net54 0
C13993 _095_ net40 0.0111f
C13994 _136_ _647_/a_324_432# 0
C13995 net176 _697_/a_2250_412# 0.01522f
C13996 _225_ _249_ 0.02896f
C13997 hold147/a_438_182# _693_/a_843_236# 0.00148f
C13998 _642_/a_1840_334# _641_/a_1583_191# 0
C13999 _294_ hold90/a_438_182# 0
C14000 _650_/a_741_93# _264_ 0.001f
C14001 _341_/a_71_118# clknet_4_4_0_clk 0.03278f
C14002 net156 _528_/a_379_118# 0.0016f
C14003 _046_ net48 0.0123f
C14004 hold165/a_326_118# VPWR 0.00452f
C14005 _687_/a_1489_191# _308_ 0
C14006 hold127/a_56_118# clknet_4_15_0_clk 0
C14007 net153 hold93/a_438_182# 0
C14008 hold110/a_438_182# net29 0.0059f
C14009 _035_ hold93/a_326_118# 0.00312f
C14010 _671_/a_2002_114# _000_ 0
C14011 baud_inst.counter\[12\] _296_ 0
C14012 net67 net68 0.00137f
C14013 rx_inst.bit_index\[1\] FILLER_19_149/a_40_246# 0.01105f
C14014 net174 _216_ 0
C14015 net155 _069_ 0
C14016 baud_inst.counter\[14\] baud_inst.counter\[16\] 0
C14017 baud_inst.counter\[2\] clknet_4_0_0_clk 0.10354f
C14018 _511_/a_150_412# net108 0
C14019 hold65/a_438_182# _154_ 0
C14020 _242_ _441_/a_154_118# 0.00129f
C14021 _643_/a_38_114# net48 0.00477f
C14022 FILLER_4_102/a_32_246# _385_/a_46_156# 0.0073f
C14023 hold183/a_326_118# _220_ 0.02921f
C14024 hold183/a_56_118# _142_ 0.01765f
C14025 hold75/a_56_118# FILLER_22_54/a_40_246# 0.00786f
C14026 hold171/a_438_182# _148_ 0
C14027 net42 hold183/a_56_118# 0.0029f
C14028 hold167/a_326_118# _670_/a_324_432# 0
C14029 clknet_0_clk _665_/a_298_337# 0
C14030 _207_ net7 0.06385f
C14031 _676_/a_38_114# _281_ 0
C14032 net97 baud_inst.counter\[16\] 0
C14033 _690_/a_324_432# _298_ 0
C14034 rx_data[4] net28 0
C14035 net18 _637_/a_1785_429# 0.00115f
C14036 hold67/a_326_118# net67 0
C14037 hold77/a_438_182# net77 0
C14038 _683_/a_2002_114# net29 0
C14039 net42 _676_/a_1785_429# 0
C14040 net26 net63 0.02307f
C14041 _431_/a_175_118# clknet_0_clk 0.00115f
C14042 _243_ net24 0.0165f
C14043 hold173/a_438_182# _221_ 0
C14044 tx_inst.data_reg\[7\] net41 0.73285f
C14045 _673_/a_1489_191# clknet_4_0_0_clk 0
C14046 _079_ _169_ 0.03102f
C14047 _479_/a_22_110# net172 0.00808f
C14048 net44 FILLER_17_22/a_40_246# 0
C14049 _296_ net88 0.10082f
C14050 _703_/a_38_114# net59 0.01421f
C14051 tx_inst.data_reg\[0\] FILLER_0_174/a_32_246# 0
C14052 net84 hold138/a_56_118# 0
C14053 net48 _236_ 0
C14054 FILLER_5_74/a_32_246# _086_ 0
C14055 _126_ _636_/a_2250_412# 0.03535f
C14056 net74 _636_/a_1840_334# 0.01666f
C14057 _655_/a_681_505# VPWR 0
C14058 _075_ _666_/a_1840_334# 0
C14059 _011_ clkbuf_4_2_0_clk/a_27_118# 0.00566f
C14060 tx_inst.state\[1\] output22/a_40_152# 0.01153f
C14061 net44 _299_ 0.00539f
C14062 net122 _676_/a_1583_191# 0
C14063 _151_ net55 0
C14064 net155 _207_ 0.08822f
C14065 clknet_4_12_0_clk FILLER_18_169/a_40_246# 0
C14066 clknet_4_15_0_clk hold71/a_438_182# 0.00152f
C14067 _447_/a_81_118# _054_ 0
C14068 _072_ _147_ 0
C14069 _077_ _665_/a_298_337# 0.00493f
C14070 hold96/a_56_118# net95 0.06697f
C14071 _683_/a_2250_412# net40 0
C14072 hold88/a_326_118# _295_ 0
C14073 _663_/a_681_505# net43 0
C14074 _644_/a_1489_191# _158_ 0.00247f
C14075 hold112/a_438_182# _154_ 0
C14076 clknet_4_7_0_clk _121_ 0.05473f
C14077 _345_/a_150_412# _178_ 0
C14078 hold144/a_56_118# _259_ 0
C14079 hold57/a_438_182# _222_ 0
C14080 hold57/a_326_118# _141_ 0.05805f
C14081 VPWR _688_/a_1840_334# 0.00535f
C14082 _652_/a_324_432# baud_inst.counter\[4\] 0
C14083 rx_inst.state\[2\] fanout28/a_40_152# 0
C14084 baud_inst.counter\[22\] _695_/a_1583_191# 0.00103f
C14085 baud_inst.counter\[23\] _695_/a_1840_334# 0.02955f
C14086 VPWR _476_/a_146_122# 0
C14087 net49 _692_/a_741_93# 0.00534f
C14088 baud_inst.counter\[30\] _556_/a_341_118# 0
C14089 hold170/a_326_118# _214_ 0
C14090 _633_/a_843_236# _272_ 0
C14091 net14 hold71/a_326_118# 0
C14092 _286_ VPWR 0.09461f
C14093 _660_/a_1840_334# clk 0.0079f
C14094 net79 _679_/a_324_432# 0
C14095 _230_ fanout25/a_40_152# 0
C14096 _396_/a_257_140# net183 0.00437f
C14097 _646_/a_324_432# _647_/a_298_337# 0
C14098 _646_/a_298_337# _647_/a_324_432# 0
C14099 net94 _036_ 0
C14100 net51 VPWR 0.63036f
C14101 rx_inst.data_reg\[3\] net143 0
C14102 _280_ hold93/a_438_182# 0
C14103 _663_/a_612_127# _215_ 0
C14104 _102_ net40 0.02939f
C14105 _206_ tx_inst.data_reg\[2\] 0.00775f
C14106 _179_ VPWR 0.05783f
C14107 net48 _043_ 0
C14108 _529_/a_45_160# _296_ 0.02994f
C14109 _177_ hold113/a_56_118# 0
C14110 baud_inst.counter\[27\] hold113/a_438_182# 0.0058f
C14111 baud_inst.counter\[26\] hold113/a_326_118# 0
C14112 _656_/a_2250_412# _380_/a_59_156# 0.00168f
C14113 _095_ _682_/a_741_93# 0
C14114 _663_/a_1583_191# tx_inst.state\[4\] 0
C14115 net49 FILLER_24_133/a_32_246# 0
C14116 _009_ _682_/a_612_127# 0
C14117 _166_ _666_/a_2250_412# 0.01463f
C14118 _676_/a_1583_191# _670_/a_741_93# 0
C14119 _661_/a_741_93# FILLER_3_123/a_32_246# 0
C14120 net44 _051_ 0
C14121 net69 hold70/a_56_118# 0
C14122 _674_/a_741_93# _504_/a_209_168# 0.00101f
C14123 _669_/a_324_432# net29 0.00369f
C14124 clknet_4_15_0_clk _649_/a_550_127# 0
C14125 _662_/a_2250_412# _042_ 0.00277f
C14126 _040_ _706_/a_2250_412# 0.04648f
C14127 _279_ _038_ 0.27064f
C14128 _118_ _199_ 0
C14129 _358_/a_72_436# _186_ 0.01794f
C14130 input7/a_40_152# _213_ 0.00136f
C14131 _126_ _157_ 0.09684f
C14132 _135_ _252_ 0.2264f
C14133 _634_/a_324_432# hold82/a_438_182# 0
C14134 _634_/a_741_93# hold82/a_326_118# 0.00171f
C14135 VPWR FILLER_5_213/a_32_246# 0.07482f
C14136 clknet_4_13_0_clk _668_/a_1840_334# 0
C14137 _639_/a_1583_191# rx_inst.state\[1\] 0.00295f
C14138 FILLER_23_186/a_40_246# net127 0.00242f
C14139 clknet_4_12_0_clk VPWR 1.06426f
C14140 _062_ net34 0
C14141 _699_/a_843_236# net46 0.00146f
C14142 _214_ VPWR 0.14132f
C14143 net26 FILLER_8_191/a_32_246# 0.00226f
C14144 net123 VPWR 0.24195f
C14145 baud_inst.counter\[28\] hold133/a_56_118# 0.03885f
C14146 _695_/a_1583_191# FILLER_22_54/a_40_246# 0.00119f
C14147 hold112/a_438_182# _160_ 0
C14148 _073_ _705_/a_298_337# 0
C14149 hold98/a_56_118# net39 0
C14150 _412_/a_22_110# _231_ 0.00452f
C14151 net66 clknet_4_13_0_clk 0.00102f
C14152 _671_/a_324_432# _235_ 0
C14153 hold78/a_438_182# _123_ 0.00348f
C14154 net159 _655_/a_1583_191# 0.00129f
C14155 net72 _634_/a_38_114# 0
C14156 _048_ _634_/a_324_432# 0.03986f
C14157 net2 hold81/a_326_118# 0
C14158 net48 _647_/a_550_127# 0
C14159 _276_ _192_ 0.01477f
C14160 net2 _707_/a_324_432# 0.00873f
C14161 rx _707_/a_741_93# 0
C14162 _305_ hold147/a_56_118# 0.0172f
C14163 net75 hold147/a_326_118# 0
C14164 hold138/a_326_118# _635_/a_324_432# 0
C14165 VPWR FILLER_3_177/a_32_246# 0.0965f
C14166 net114 _695_/a_1840_334# 0
C14167 hold138/a_56_118# _635_/a_741_93# 0
C14168 net55 FILLER_4_108/a_40_246# 0.01762f
C14169 _365_/a_155_412# _197_ 0.00359f
C14170 baud_inst.counter\[21\] net120 0.17431f
C14171 _454_/a_155_412# _263_ 0.0029f
C14172 _675_/a_741_93# _087_ 0.01109f
C14173 _063_ _182_ 0
C14174 hold156/a_438_182# net40 0.0129f
C14175 hold142/a_438_182# clknet_0_clk 0.00302f
C14176 _661_/a_1489_191# tx_inst.data_reg\[7\] 0.01546f
C14177 hold145/a_56_118# clknet_4_4_0_clk 0.0108f
C14178 hold55/a_438_182# net11 0
C14179 _445_/a_279_412# clknet_0_clk 0
C14180 _057_ _258_ 0
C14181 _702_/a_132_114# _115_ 0
C14182 net87 net141 0
C14183 rx_inst.bit_index\[0\] _454_/a_257_140# 0
C14184 _170_ hold62/a_56_118# 0.00313f
C14185 _646_/a_1489_191# FILLER_17_201/a_32_246# 0
C14186 hold144/a_326_118# hold112/a_438_182# 0
C14187 FILLER_16_203/a_32_246# _650_/a_843_236# 0.00105f
C14188 _116_ _702_/a_843_236# 0
C14189 hold179/a_56_118# _065_ 0
C14190 net60 _085_ 0.0161f
C14191 _181_ net38 0.02233f
C14192 FILLER_3_150/a_40_246# VPWR 0.16671f
C14193 _694_/a_1583_191# net107 0
C14194 net66 net65 0.01286f
C14195 net67 hold105/a_326_118# 0
C14196 _029_ _701_/a_298_337# 0
C14197 net106 _701_/a_38_114# 0.00167f
C14198 _703_/a_324_432# FILLER_23_83/a_32_246# 0
C14199 baud_inst.counter\[20\] _693_/a_38_114# 0
C14200 net144 clknet_4_12_0_clk 0.01632f
C14201 _652_/a_1785_429# net43 0.00115f
C14202 _058_ _241_ 0
C14203 hold78/a_326_118# _159_ 0
C14204 hold168/a_56_118# _664_/a_843_236# 0
C14205 hold168/a_326_118# _664_/a_741_93# 0.00299f
C14206 hold67/a_438_182# _702_/a_843_236# 0
C14207 net35 _262_ 0.0159f
C14208 _655_/a_2250_412# tx_inst.data_reg\[1\] 0.00577f
C14209 net43 clkbuf_4_1_0_clk/a_27_118# 0
C14210 _678_/a_38_114# net137 0
C14211 output21/a_40_152# net21 0.03664f
C14212 clknet_4_14_0_clk _419_/a_154_118# 0
C14213 _302_ FILLER_17_22/a_40_246# 0.00206f
C14214 net58 _703_/a_741_93# 0.00235f
C14215 _032_ _703_/a_38_114# 0.03928f
C14216 _257_ _223_ 0.20903f
C14217 clknet_0_clk _649_/a_843_236# 0.03838f
C14218 net34 _359_/a_22_110# 0.00466f
C14219 _184_ net153 0.00805f
C14220 net2 _671_/a_741_93# 0
C14221 FILLER_16_56/a_32_246# baud_inst.counter\[14\] 0
C14222 _302_ _299_ 0
C14223 _226_ fanout28/a_40_152# 0.00704f
C14224 _107_ fanout46/a_40_152# 0.0096f
C14225 _646_/a_132_114# VPWR 0
C14226 baud_inst.counter\[7\] _678_/a_681_505# 0
C14227 net51 _266_ 0.32086f
C14228 clknet_4_11_0_clk net59 0
C14229 _357_/a_252_412# net40 0.0026f
C14230 hold101/a_326_118# _690_/a_324_432# 0
C14231 hold101/a_56_118# _690_/a_741_93# 0
C14232 _402_/a_154_118# net183 0
C14233 _639_/a_741_93# FILLER_13_228/a_40_246# 0.00392f
C14234 _107_ net149 0
C14235 _062_ hold56/a_438_182# 0
C14236 clknet_4_7_0_clk clknet_0_clk 0.35284f
C14237 _432_/a_146_122# rx_inst.state\[2\] 0
C14238 net31 rx_inst.bit_index\[1\] 0.41195f
C14239 net51 _167_ 0
C14240 VPWR _703_/a_1583_191# 0.01379f
C14241 net48 FILLER_28_176/a_32_246# 0
C14242 net4 input6/a_40_152# 0.10272f
C14243 input4/a_40_152# net6 0
C14244 _635_/a_1840_334# _156_ 0
C14245 _339_/a_71_118# VPWR 0.04146f
C14246 hold129/a_56_118# net29 0.00134f
C14247 FILLER_19_228/a_40_246# hold84/a_438_182# 0.00941f
C14248 _689_/a_1840_334# _298_ 0
C14249 _355_/a_150_412# VPWR 0
C14250 _157_ _647_/a_1489_191# 0.01771f
C14251 _257_ _240_ 0
C14252 baud_inst.counter\[20\] _535_/a_146_122# 0
C14253 _345_/a_354_412# VPWR 0
C14254 _414_/a_165_412# net29 0
C14255 _398_/a_358_436# _217_ 0
C14256 _398_/a_115_308# _218_ 0.00137f
C14257 _053_ _641_/a_681_505# 0
C14258 _642_/a_843_236# net176 0
C14259 _259_ _224_ 0
C14260 clknet_4_12_0_clk _641_/a_741_93# 0.02543f
C14261 _132_ _641_/a_843_236# 0
C14262 _089_ clknet_0_clk 0.16114f
C14263 FILLER_2_79/a_40_246# net181 0.01906f
C14264 _061_ _456_/a_155_412# 0
C14265 _341_/a_886_118# tx_inst.data_reg\[2\] 0.00448f
C14266 clk _659_/a_2250_412# 0
C14267 _341_/a_1109_431# clknet_4_4_0_clk 0.00161f
C14268 _265_ _168_ 0
C14269 clknet_4_12_0_clk _266_ 0.0016f
C14270 net156 _301_ 0
C14271 _229_ net37 0
C14272 _633_/a_741_93# _648_/a_38_114# 0
C14273 hold53/a_438_182# _641_/a_843_236# 0
C14274 net53 _641_/a_298_337# 0
C14275 hold87/a_56_118# baud_inst.counter\[14\] 0
C14276 _680_/a_298_337# VPWR 0.01026f
C14277 clknet_4_12_0_clk _167_ 0.16294f
C14278 _088_ net38 0.2556f
C14279 hold182/a_438_182# FILLER_12_106/a_40_246# 0.00941f
C14280 baud_inst.counter\[13\] _685_/a_132_114# 0
C14281 _699_/a_298_337# hold114/a_438_182# 0
C14282 _699_/a_324_432# hold114/a_56_118# 0
C14283 _675_/a_1489_191# net60 0
C14284 _646_/a_132_114# net144 0
C14285 _651_/a_741_93# clknet_0_clk 0
C14286 _487_/a_248_122# net50 0
C14287 hold122/a_438_182# _205_ 0
C14288 clknet_4_12_0_clk _647_/a_741_93# 0.03359f
C14289 net101 FILLER_15_0/a_40_246# 0
C14290 _650_/a_324_432# _156_ 0
C14291 _224_ _157_ 0
C14292 clk _654_/a_741_93# 0.00271f
C14293 FILLER_8_189/a_40_246# net27 0.0017f
C14294 _663_/a_38_114# _475_/a_170_412# 0
C14295 _468_/a_120_432# net19 0
C14296 hold103/a_438_182# clknet_4_8_0_clk 0
C14297 _132_ _260_ 0.31126f
C14298 _046_ net143 0
C14299 clknet_4_12_0_clk _225_ 1.48239f
C14300 _699_/a_681_505# _312_ 0
C14301 _699_/a_843_236# _313_ 0.00158f
C14302 clkbuf_4_8_0_clk/a_27_118# _687_/a_1840_334# 0.00137f
C14303 net18 _048_ 0.00689f
C14304 FILLER_5_164/a_40_246# _341_/a_382_118# 0
C14305 hold177/a_56_118# _294_ 0
C14306 hold170/a_56_118# tx_inst.data_reg\[0\] 0
C14307 clknet_4_1_0_clk baud_inst.counter\[0\] 0
C14308 _006_ net168 0
C14309 _275_ _200_ 0.36294f
C14310 _643_/a_1583_191# hold143/a_56_118# 0
C14311 hold113/a_56_118# VPWR 0.01193f
C14312 _110_ FILLER_20_95/a_40_246# 0
C14313 VPWR _687_/a_1489_191# 0.00107f
C14314 net179 _368_/a_257_140# 0
C14315 clknet_4_7_0_clk _704_/a_298_337# 0.01745f
C14316 net31 FILLER_22_152/a_32_246# 0.01521f
C14317 net44 _698_/a_324_432# 0.00308f
C14318 _184_ _280_ 0.00157f
C14319 _223_ _416_/a_248_122# 0
C14320 output13/a_40_152# rx_data[1] 0
C14321 _655_/a_550_127# VPWR 0
C14322 hold156/a_326_118# _682_/a_843_236# 0
C14323 clkbuf_4_2_0_clk/a_27_118# _684_/a_1583_191# 0
C14324 hold85/a_438_182# clknet_4_13_0_clk 0
C14325 _170_ _237_ 0
C14326 _488_/a_380_412# net38 0.00284f
C14327 net34 FILLER_7_176/a_32_246# 0
C14328 net122 _676_/a_2002_114# 0
C14329 baud_inst.counter\[26\] _541_/a_209_168# 0
C14330 _178_ _177_ 2.48451f
C14331 hold158/a_326_118# _016_ 0.0083f
C14332 net44 hold101/a_438_182# 0
C14333 tx_data[2] _384_/a_59_156# 0
C14334 hold159/a_56_118# _659_/a_38_114# 0
C14335 net92 _186_ 0.0011f
C14336 rx_inst.data_reg\[1\] _158_ 0.11508f
C14337 _089_ _182_ 0.01423f
C14338 baud_inst.counter\[17\] baud_inst.counter\[16\] 0.7977f
C14339 FILLER_26_35/a_32_246# _694_/a_741_93# 0
C14340 _267_ net47 0
C14341 _183_ hold95/a_56_118# 0
C14342 clkbuf_0_clk/a_116_82# hold123/a_56_118# 0
C14343 _171_ net146 0
C14344 _646_/a_1583_191# net30 0
C14345 VPWR _274_ 0.04703f
C14346 FILLER_10_222/a_32_246# _705_/a_741_93# 0.00112f
C14347 FILLER_14_70/a_40_246# FILLER_14_72/a_32_246# 0.0524f
C14348 net49 _692_/a_1785_429# 0.00189f
C14349 hold136/a_438_182# net136 0.01678f
C14350 _698_/a_38_114# clknet_0_clk 0.00175f
C14351 net44 _105_ 0.14144f
C14352 _633_/a_612_127# _272_ 0
C14353 net48 net2 0
C14354 _505_/a_170_160# _182_ 0
C14355 _240_ _416_/a_248_122# 0
C14356 net177 hold130/a_326_118# 0
C14357 net42 net28 0
C14358 hold108/a_326_118# baud_inst.counter\[13\] 0
C14359 VPWR _520_/a_155_412# 0.00107f
C14360 hold118/a_56_118# net30 0.02273f
C14361 baud_inst.counter\[26\] hold99/a_438_182# 0.01694f
C14362 _662_/a_741_93# net55 0.00557f
C14363 hold98/a_438_182# net98 0.00117f
C14364 _295_ clknet_4_2_0_clk 0.00422f
C14365 clknet_4_13_0_clk _650_/a_298_337# 0
C14366 hold184/a_438_182# _171_ 0
C14367 FILLER_4_183/a_40_246# _005_ 0.03431f
C14368 net173 _173_ 0.02364f
C14369 _512_/a_279_412# _288_ 0.00376f
C14370 net178 VPWR 0.12996f
C14371 net167 net90 0
C14372 _157_ _235_ 0
C14373 _244_ _242_ 0.15981f
C14374 hold163/a_326_118# net75 0
C14375 baud_inst.counter\[20\] _537_/a_155_160# 0
C14376 hold163/a_56_118# _305_ 0
C14377 net48 clkload3/Y 0.002f
C14378 _661_/a_1785_429# net165 0
C14379 _656_/a_1583_191# net170 0.00146f
C14380 clkload2/Y FILLER_23_83/a_32_246# 0.00135f
C14381 _653_/a_1489_191# net43 0.01759f
C14382 _486_/a_358_436# net51 0
C14383 _515_/a_76_160# fanout29/a_40_152# 0.07213f
C14384 hold126/a_438_182# _267_ 0.00431f
C14385 hold126/a_326_118# _128_ 0.05341f
C14386 _390_/a_382_118# net159 0.0092f
C14387 clkbuf_4_6_0_clk/a_27_118# rx_inst.state\[4\] 0.00871f
C14388 _234_ net29 0.61958f
C14389 rx _704_/a_1489_191# 0
C14390 clkbuf_4_7_0_clk/a_27_118# clknet_4_6_0_clk 0
C14391 _515_/a_272_160# _297_ 0
C14392 _153_ _650_/a_741_93# 0.0111f
C14393 net118 _650_/a_843_236# 0
C14394 _170_ hold132/a_438_182# 0.03286f
C14395 net143 _043_ 0
C14396 _674_/a_843_236# net135 0.00516f
C14397 _674_/a_741_93# _287_ 0.00187f
C14398 _674_/a_324_432# _038_ 0
C14399 FILLER_16_70/a_40_246# _013_ 0.02783f
C14400 _669_/a_2250_412# net29 0
C14401 hold132/a_326_118# net32 0
C14402 _073_ _119_ 0.00174f
C14403 _032_ clknet_4_11_0_clk 0.03961f
C14404 _339_/a_382_118# tx_inst.data_reg\[1\] 0.00545f
C14405 _097_ net156 0.15803f
C14406 _639_/a_741_93# _264_ 0
C14407 hold162/a_326_118# clknet_0_clk 0
C14408 net30 net64 0.04889f
C14409 hold58/a_326_118# net49 0.0057f
C14410 _674_/a_2250_412# hold60/a_326_118# 0
C14411 hold110/a_438_182# _288_ 0.00286f
C14412 _639_/a_2002_114# rx_inst.state\[1\] 0
C14413 FILLER_16_70/a_40_246# baud_inst.counter\[14\] 0.0049f
C14414 _694_/a_38_114# net46 0.00435f
C14415 _646_/a_324_432# FILLER_20_198/a_40_246# 0
C14416 VPWR _508_/a_380_412# 0
C14417 _697_/a_324_432# _025_ 0.00564f
C14418 _699_/a_612_127# net46 0
C14419 _392_/a_59_156# net168 0
C14420 _693_/a_741_93# FILLER_24_19/a_40_246# 0
C14421 _222_ net183 1.10265f
C14422 net56 _221_ 0.02371f
C14423 _268_ _154_ 0.00295f
C14424 clkbuf_4_10_0_clk/a_27_118# _699_/a_298_337# 0.00247f
C14425 net49 clknet_4_8_0_clk 0.08013f
C14426 _429_/a_142_412# VPWR 0.00281f
C14427 _267_ net70 0.25831f
C14428 net159 _655_/a_2002_114# 0
C14429 _048_ _634_/a_2250_412# 0
C14430 _183_ net40 0
C14431 hold59/a_326_118# net105 0
C14432 net176 FILLER_19_118/a_32_246# 0.01417f
C14433 _056_ FILLER_29_145/a_40_246# 0
C14434 net138 _635_/a_843_236# 0
C14435 _176_ net168 0
C14436 net27 net172 0.62456f
C14437 _215_ net169 0
C14438 net102 _527_/a_192_429# 0.01162f
C14439 hold85/a_326_118# rx_inst.data_reg\[4\] 0.01615f
C14440 _537_/a_192_429# net75 0.0099f
C14441 _644_/a_298_337# net48 0
C14442 net158 _525_/a_268_412# 0
C14443 net10 net4 0.00409f
C14444 _175_ _481_/a_22_110# 0
C14445 _124_ clknet_4_15_0_clk 0
C14446 _646_/a_324_432# _160_ 0.00161f
C14447 net179 _144_ 0.0603f
C14448 _658_/a_298_337# net41 0.0028f
C14449 _655_/a_324_432# _066_ 0.00916f
C14450 hold122/a_326_118# _374_/a_244_412# 0
C14451 hold122/a_438_182# _374_/a_142_412# 0
C14452 _637_/a_38_114# rx_inst.data_reg\[6\] 0
C14453 baud_inst.counter\[20\] _693_/a_1840_334# 0.0136f
C14454 _063_ net43 0.00742f
C14455 _096_ _682_/a_324_432# 0.00232f
C14456 _683_/a_298_337# clknet_4_2_0_clk 0
C14457 _163_ _688_/a_1840_334# 0
C14458 net128 net129 0
C14459 baud_inst.counter\[12\] _294_ 0.21451f
C14460 FILLER_17_94/a_40_246# _025_ 0.00211f
C14461 _198_ FILLER_5_192/a_40_246# 0.01705f
C14462 _125_ _636_/a_298_337# 0
C14463 FILLER_10_78/a_32_246# net40 0
C14464 _696_/a_38_114# _294_ 0
C14465 _109_ _541_/a_209_168# 0.00128f
C14466 baud_inst.counter\[22\] _548_/a_76_160# 0
C14467 baud_inst.counter\[23\] _548_/a_170_160# 0
C14468 net69 rx_data[6] 0
C14469 net44 _025_ 0.03576f
C14470 hold163/a_438_182# net163 0
C14471 _045_ _634_/a_38_114# 0.00768f
C14472 net162 _308_ 0.01698f
C14473 _158_ _124_ 0
C14474 hold65/a_326_118# net70 0
C14475 _013_ baud_inst.counter\[13\] 0
C14476 hold77/a_56_118# _648_/a_1840_334# 0
C14477 hold77/a_326_118# _648_/a_1583_191# 0
C14478 net14 _271_ 0
C14479 _032_ _703_/a_1840_334# 0
C14480 _021_ net49 0.01112f
C14481 net154 net40 0
C14482 hold89/a_326_118# baud_inst.counter\[14\] 0.00503f
C14483 hold89/a_438_182# baud_inst.counter\[15\] 0.00633f
C14484 hold151/a_326_118# net47 0.00198f
C14485 _633_/a_324_432# _123_ 0.01548f
C14486 clknet_4_14_0_clk _242_ 0.01215f
C14487 clknet_0_clk _649_/a_612_127# 0
C14488 tx_inst.data_reg\[4\] _206_ 0
C14489 _090_ _676_/a_324_432# 0
C14490 net39 _676_/a_741_93# 0.0172f
C14491 _646_/a_38_114# hold144/a_438_182# 0
C14492 baud_inst.counter\[13\] baud_inst.counter\[14\] 0.0041f
C14493 _460_/a_120_432# net19 0.00414f
C14494 clknet_4_3_0_clk hold95/a_56_118# 0.02117f
C14495 clknet_4_3_0_clk _678_/a_1489_191# 0.01277f
C14496 hold101/a_438_182# _302_ 0
C14497 hold101/a_326_118# _164_ 0
C14498 _189_ net40 0.22784f
C14499 _671_/a_741_93# _084_ 0
C14500 _294_ net88 0.37215f
C14501 net39 _683_/a_741_93# 0
C14502 hold85/a_56_118# _047_ 0
C14503 _216_ clknet_4_6_0_clk 0.00135f
C14504 output21/a_40_152# clknet_4_5_0_clk 0
C14505 net13 VPWR 0.28486f
C14506 _059_ _633_/a_38_114# 0
C14507 _360_/a_886_118# hold165/a_56_118# 0
C14508 _160_ _473_/a_22_110# 0.00624f
C14509 _691_/a_298_337# VPWR 0.00482f
C14510 rx_inst.bit_index\[2\] _428_/a_150_412# 0.00336f
C14511 _310_ clknet_0_clk 0.00213f
C14512 fanout29/a_40_152# net91 0
C14513 baud_inst.counter\[19\] VPWR 0.20237f
C14514 _637_/a_324_432# _124_ 0
C14515 hold136/a_326_118# clknet_4_0_0_clk 0.00134f
C14516 FILLER_8_171/a_32_246# _216_ 0.02012f
C14517 _170_ _433_/a_550_140# 0
C14518 _178_ VPWR 0.20298f
C14519 tx _478_/a_229_118# 0.00117f
C14520 _233_ net29 1.93596f
C14521 _302_ _105_ 0.18795f
C14522 _159_ _633_/a_38_114# 0.01984f
C14523 _216_ _218_ 0.0694f
C14524 _642_/a_612_127# net176 0
C14525 clknet_4_12_0_clk _641_/a_1785_429# 0
C14526 clknet_4_5_0_clk hold168/a_56_118# 0.00429f
C14527 _539_/a_139_160# _306_ 0.00456f
C14528 net67 baud_inst.counter\[29\] 0.00109f
C14529 _706_/a_298_337# net172 0
C14530 hold98/a_326_118# clknet_4_0_0_clk 0
C14531 _061_ _264_ 0.08154f
C14532 _023_ _693_/a_843_236# 0
C14533 _410_/a_155_412# net26 0.02576f
C14534 _230_ _642_/a_324_432# 0.00139f
C14535 baud_inst.counter\[31\] _111_ 0
C14536 baud_inst.counter\[30\] net45 0
C14537 hold179/a_56_118# VPWR 0.02761f
C14538 _119_ net41 0.00204f
C14539 _633_/a_1840_334# _648_/a_741_93# 0
C14540 _633_/a_1583_191# _648_/a_843_236# 0
C14541 FILLER_22_118/a_32_246# _130_ 0
C14542 _143_ _678_/a_1583_191# 0
C14543 hold151/a_438_182# net49 0.0021f
C14544 _680_/a_1583_191# VPWR 0.00756f
C14545 fanout38/a_40_152# net117 0.01069f
C14546 _294_ net39 0
C14547 hold129/a_438_182# net40 0
C14548 baud_inst.counter\[14\] _544_/a_46_156# 0.0019f
C14549 _412_/a_22_110# _228_ 0
C14550 _412_/a_120_432# rx_inst.state\[2\] 0
C14551 _643_/a_741_93# _473_/a_22_110# 0
C14552 baud_inst.counter\[13\] _685_/a_1489_191# 0.00319f
C14553 net28 _667_/a_2250_412# 0
C14554 _447_/a_81_118# _257_ 0.02922f
C14555 baud_inst.counter\[3\] net60 0.14331f
C14556 _191_ FILLER_15_127/a_32_246# 0.02272f
C14557 net49 _374_/a_244_412# 0
C14558 input6/a_40_152# net40 0
C14559 _191_ _652_/a_843_236# 0
C14560 _316_ hold113/a_438_182# 0
C14561 _465_/a_22_110# _264_ 0.00252f
C14562 _656_/a_324_432# net41 0.00192f
C14563 clknet_4_12_0_clk _647_/a_1785_429# 0
C14564 clk _654_/a_1785_429# 0
C14565 VPWR _459_/a_229_118# 0
C14566 _418_/a_46_156# net24 0.00203f
C14567 _089_ FILLER_10_110/a_40_246# 0
C14568 _414_/a_165_412# net122 0
C14569 fanout40/a_40_152# VPWR 0.06609f
C14570 _699_/a_612_127# _313_ 0.01156f
C14571 FILLER_0_163/a_32_246# _380_/a_59_156# 0.01108f
C14572 hold143/a_438_182# _054_ 0
C14573 hold99/a_326_118# VPWR 0.0085f
C14574 _428_/a_150_412# _243_ 0.00213f
C14575 _384_/a_59_156# _210_ 0.07654f
C14576 hold132/a_56_118# _242_ 0
C14577 tx_inst.bit_index\[1\] _659_/a_1840_334# 0
C14578 net108 FILLER_9_70/a_40_246# 0.0019f
C14579 _064_ clknet_4_3_0_clk 0.00341f
C14580 tx_inst.bit_index\[0\] net27 0.0764f
C14581 _646_/a_843_236# _043_ 0
C14582 hold111/a_56_118# _632_/a_324_432# 0
C14583 _643_/a_1840_334# net143 0
C14584 hold111/a_326_118# _632_/a_38_114# 0
C14585 hold165/a_438_182# net9 0
C14586 net44 FILLER_17_79/a_40_246# 0.00386f
C14587 clknet_0_clk hold92/a_438_182# 0.01647f
C14588 hold53/a_438_182# net45 0
C14589 FILLER_6_23/a_32_246# FILLER_6_21/a_40_246# 0.0524f
C14590 clknet_4_7_0_clk _704_/a_1583_191# 0
C14591 _539_/a_45_160# net103 0
C14592 _388_/a_382_118# _388_/a_285_118# -0
C14593 _449_/a_27_156# VPWR 0.02315f
C14594 baud_inst.counter\[23\] net46 0
C14595 hold145/a_326_118# clknet_0_clk 0
C14596 hold57/a_56_118# VPWR 0.00774f
C14597 clknet_4_3_0_clk net40 0.02295f
C14598 hold104/a_56_118# net104 0
C14599 _177_ net162 0
C14600 hold121/a_438_182# _692_/a_1840_334# 0
C14601 net121 _692_/a_843_236# 0.00114f
C14602 net82 clknet_4_15_0_clk 0.0039f
C14603 _291_ _505_/a_76_160# 0.00515f
C14604 clknet_4_7_0_clk net43 0.38793f
C14605 _094_ VPWR 0.12164f
C14606 _658_/a_843_236# clknet_4_1_0_clk 0
C14607 _541_/a_209_168# _541_/a_474_130# 0
C14608 hold53/a_56_118# _224_ 0
C14609 clkbuf_4_7_0_clk/a_27_118# _668_/a_1583_191# 0
C14610 hold142/a_438_182# _110_ 0.00165f
C14611 hold142/a_326_118# net142 0.01594f
C14612 clk net54 0.08863f
C14613 _279_ net86 0.00314f
C14614 _283_ _511_/a_150_412# 0
C14615 _063_ net152 0.00464f
C14616 _516_/a_279_412# net129 0.00569f
C14617 hold104/a_326_118# net163 0
C14618 _431_/a_379_118# net48 0
C14619 _646_/a_1489_191# _266_ 0
C14620 net48 _466_/a_22_110# 0.00196f
C14621 _693_/a_298_337# net149 0.00881f
C14622 _698_/a_1840_334# clknet_0_clk 0.01995f
C14623 baud_inst.counter\[27\] _027_ 0.00106f
C14624 fanout32/a_40_152# _153_ 0
C14625 _638_/a_843_236# _273_ 0.00863f
C14626 rx_inst.bit_index\[2\] FILLER_21_147/a_40_246# 0.02399f
C14627 clknet_4_7_0_clk _707_/a_843_236# 0.01159f
C14628 net13 _266_ 0.0099f
C14629 rx_data[1] net30 0
C14630 clknet_4_6_0_clk _666_/a_843_236# 0.00622f
C14631 VPWR _297_ 0.0153f
C14632 net31 fanout28/a_40_152# 0
C14633 _646_/a_1840_334# _647_/a_1840_334# 0.00131f
C14634 _646_/a_1583_191# _647_/a_2250_412# 0
C14635 _646_/a_2250_412# _647_/a_1583_191# 0
C14636 clknet_4_13_0_clk _650_/a_1583_191# 0.01598f
C14637 _531_/a_380_412# net163 0.00469f
C14638 _531_/a_209_168# _020_ 0.02024f
C14639 _547_/a_81_118# _547_/a_379_118# -0
C14640 FILLER_24_229/a_32_246# _264_ 0
C14641 net38 _681_/a_298_337# 0.03553f
C14642 _010_ net116 0
C14643 FILLER_14_202/a_40_246# _668_/a_741_93# 0.00392f
C14644 hold150/a_56_118# VPWR 0.0108f
C14645 clknet_4_12_0_clk _232_ 0
C14646 _675_/a_298_337# net61 0.00165f
C14647 _675_/a_843_236# hold61/a_438_182# 0
C14648 tx_inst.data_reg\[4\] _341_/a_886_118# 0
C14649 _651_/a_741_93# net43 0
C14650 _072_ net165 0
C14651 tx_inst.data_reg\[5\] _653_/a_843_236# 0
C14652 _670_/a_1840_334# FILLER_11_125/a_32_246# 0
C14653 net49 _688_/a_843_236# 0
C14654 _180_ net90 0.4945f
C14655 _641_/a_1840_334# net175 0
C14656 _090_ _677_/a_843_236# 0.01769f
C14657 _556_/a_192_429# net58 0.02096f
C14658 net82 _637_/a_324_432# 0
C14659 FILLER_2_46/a_40_246# _033_ 0.00162f
C14660 _072_ FILLER_3_123/a_32_246# 0
C14661 net43 _665_/a_1583_191# 0
C14662 _269_ _639_/a_741_93# 0
C14663 net73 _639_/a_843_236# 0
C14664 net72 hold71/a_56_118# 0
C14665 _048_ hold71/a_326_118# 0.00297f
C14666 net36 _223_ 0
C14667 FILLER_4_102/a_32_246# _655_/a_1840_334# 0
C14668 _153_ _650_/a_1785_429# 0.00133f
C14669 hold117/a_438_182# _681_/a_843_236# 0
C14670 clknet_4_3_0_clk _670_/a_38_114# 0
C14671 net3 FILLER_0_161/a_40_246# 0.00134f
C14672 net4 input8/a_40_152# 0.00954f
C14673 input4/a_40_152# net8 0
C14674 _007_ net43 0
C14675 rx_data[4] _240_ 0.003f
C14676 _168_ _668_/a_324_432# 0
C14677 net79 FILLER_1_67/a_40_246# 0.01452f
C14678 _276_ net168 0.07762f
C14679 net26 _200_ 0
C14680 net109 _682_/a_1840_334# 0.00649f
C14681 _292_ _682_/a_1583_191# 0.00166f
C14682 _634_/a_1489_191# hold72/a_56_118# 0
C14683 _694_/a_1840_334# net46 0
C14684 _352_/a_46_156# _185_ 0
C14685 baud_inst.counter\[13\] clkbuf_4_2_0_clk/a_27_118# 0
C14686 _459_/a_229_118# _266_ 0.00346f
C14687 net26 hold180/a_56_118# 0
C14688 net114 net46 0.02846f
C14689 _345_/a_252_412# net45 0
C14690 hold86/a_326_118# _181_ 0.01654f
C14691 hold86/a_438_182# net60 0.01285f
C14692 FILLER_1_28/a_40_246# _033_ 0
C14693 _673_/a_741_93# _287_ 0.00799f
C14694 _415_/a_170_412# _170_ 0.00162f
C14695 hold184/a_326_118# net34 0.01452f
C14696 hold64/a_438_182# rx_inst.data_reg\[0\] 0
C14697 _672_/a_1489_191# clknet_4_0_0_clk 0.00326f
C14698 _000_ _458_/a_279_412# 0
C14699 net32 hold180/a_56_118# 0
C14700 net28 _650_/a_741_93# 0
C14701 VPWR FILLER_23_143/a_32_246# 0.08039f
C14702 FILLER_26_35/a_32_246# _114_ 0
C14703 net97 _502_/a_279_412# 0
C14704 net102 _526_/a_350_122# 0
C14705 hold102/a_438_182# net101 0
C14706 FILLER_7_40/a_32_246# baud_inst.counter\[9\] 0.04293f
C14707 VPWR FILLER_17_24/a_32_246# 0.06636f
C14708 net75 _305_ 1.67521f
C14709 _644_/a_1583_191# net48 0
C14710 _705_/a_1489_191# _275_ 0
C14711 clknet_4_8_0_clk FILLER_17_81/a_32_246# 0
C14712 baud_inst.counter\[17\] _016_ 0
C14713 _432_/a_350_122# _247_ 0.00107f
C14714 _444_/a_244_140# _158_ 0
C14715 net85 _057_ 0
C14716 net49 hold149/a_56_118# 0.01069f
C14717 hold147/a_326_118# _303_ 0
C14718 _646_/a_2250_412# _160_ 0
C14719 rx_inst.state\[2\] _425_/a_46_156# 0.00165f
C14720 _688_/a_38_114# net157 0.00231f
C14721 _692_/a_132_114# _105_ 0
C14722 VPWR FILLER_17_96/a_32_246# 0.06297f
C14723 hold135/a_326_118# _673_/a_2250_412# 0
C14724 _131_ net25 0.00346f
C14725 _658_/a_1583_191# net41 0.01835f
C14726 tx_inst.data_reg\[5\] _652_/a_1840_334# 0
C14727 _284_ VPWR 0.14505f
C14728 hold141/a_438_182# _025_ 0.01197f
C14729 VPWR _491_/a_192_429# 0.00492f
C14730 _183_ FILLER_8_35/a_32_246# 0.00163f
C14731 _499_/a_209_168# _036_ 0.00236f
C14732 _096_ _682_/a_2250_412# 0.00489f
C14733 _683_/a_1583_191# clknet_4_2_0_clk 0
C14734 net133 VPWR 0.34851f
C14735 _449_/a_27_156# _225_ 0.02454f
C14736 _270_ _636_/a_1840_334# 0
C14737 _125_ _636_/a_1583_191# 0.0132f
C14738 baud_inst.counter\[23\] _313_ 0.04077f
C14739 hold159/a_438_182# _211_ 0
C14740 hold153/a_56_118# _036_ 0
C14741 _045_ _634_/a_1840_334# 0
C14742 _172_ clkbuf_4_4_0_clk/a_27_118# 0.07482f
C14743 _361_/a_146_122# tx_inst.bit_index\[2\] 0
C14744 _646_/a_38_114# net47 0
C14745 _098_ _494_/a_279_412# 0.00133f
C14746 net42 _666_/a_298_337# 0.00588f
C14747 _374_/a_550_140# _169_ 0
C14748 _633_/a_2250_412# _123_ 0
C14749 clknet_0_clk net127 0
C14750 _277_ FILLER_14_164/a_32_246# 0
C14751 net124 clkbuf_4_15_0_clk/a_27_118# 0
C14752 net146 _705_/a_298_337# 0
C14753 _152_ _705_/a_324_432# 0.01167f
C14754 net39 _676_/a_1785_429# 0
C14755 net167 net26 0
C14756 _424_/a_142_412# FILLER_26_172/a_40_246# 0
C14757 net10 net40 0
C14758 _129_ net19 0.33611f
C14759 rx_inst.data_reg\[3\] VPWR 0.02874f
C14760 tx net54 0
C14761 hold67/a_326_118# hold67/a_438_182# 0
C14762 _421_/a_354_412# _236_ 0.00163f
C14763 _227_ _002_ 0
C14764 net3 clknet_4_4_0_clk 0
C14765 hold101/a_56_118# _103_ 0
C14766 _287_ net95 0.09744f
C14767 _550_/a_380_412# _028_ 0
C14768 _509_/a_257_140# net29 0
C14769 _089_ net152 0
C14770 net178 _163_ 0.02955f
C14771 hold178/a_326_118# _684_/a_741_93# 0
C14772 hold178/a_56_118# _684_/a_843_236# 0
C14773 FILLER_9_79/a_32_246# VPWR 0.07979f
C14774 hold152/a_438_182# _063_ 0
C14775 net49 _426_/a_154_118# 0.00126f
C14776 _638_/a_38_114# VPWR 0.00837f
C14777 _639_/a_38_114# net81 0.0526f
C14778 _639_/a_324_432# _050_ 0.05284f
C14779 hold77/a_438_182# FILLER_27_194/a_40_246# 0.00941f
C14780 _059_ _633_/a_1840_334# 0
C14781 _691_/a_1583_191# VPWR 0.03934f
C14782 clknet_4_4_0_clk _142_ 0.00176f
C14783 _269_ _061_ 0
C14784 _438_/a_350_122# _252_ -0
C14785 VPWR net162 0.0612f
C14786 _170_ _247_ 0.02421f
C14787 net126 FILLER_27_210/a_40_246# 0
C14788 net42 clknet_4_4_0_clk 0
C14789 _159_ _633_/a_1840_334# 0
C14790 _315_ hold107/a_56_118# 0
C14791 FILLER_4_100/a_40_246# _390_/a_59_156# 0
C14792 _683_/a_38_114# _683_/a_132_114# 0
C14793 _683_/a_741_93# _683_/a_843_236# -0
C14794 _132_ net176 0.03602f
C14795 clknet_4_12_0_clk _052_ 0.00265f
C14796 _265_ hold51/a_438_182# 0
C14797 _129_ hold51/a_326_118# 0
C14798 net71 net47 0.55159f
C14799 FILLER_16_56/a_32_246# _687_/a_843_236# 0
C14800 net48 _649_/a_132_114# 0
C14801 _643_/a_324_432# net24 0.0281f
C14802 rx_inst.bit_index\[1\] _262_ 1.28868f
C14803 net36 _261_ 0.12869f
C14804 _229_ net26 0.00655f
C14805 _230_ _642_/a_2250_412# 0.01328f
C14806 hold78/a_56_118# clknet_4_14_0_clk 0
C14807 _661_/a_741_93# _209_ 0
C14808 baud_inst.counter\[8\] _037_ 0
C14809 _231_ rx_inst.state\[2\] 0.00609f
C14810 _229_ net32 0
C14811 _643_/a_843_236# _273_ 0
C14812 _377_/a_46_156# tx_data[7] 0.00111f
C14813 hold181/a_56_118# baud_inst.counter\[2\] 0.02845f
C14814 net49 _703_/a_741_93# 0.01765f
C14815 FILLER_24_229/a_32_246# hold69/a_438_182# 0.00985f
C14816 baud_inst.counter\[13\] baud_inst.counter\[17\] 0
C14817 hold68/a_438_182# _702_/a_298_337# 0
C14818 fanout45/a_40_152# clknet_4_10_0_clk 0
C14819 _656_/a_2250_412# net41 0
C14820 _080_ _191_ 0
C14821 clk _065_ 0.03574f
C14822 hold61/a_56_118# _085_ 0.00132f
C14823 hold61/a_326_118# net38 0.0514f
C14824 _233_ net122 0.00315f
C14825 net79 _504_/a_209_168# 0.00653f
C14826 _376_/a_170_160# _166_ 0
C14827 net114 _313_ 0.24908f
C14828 _112_ _180_ 0
C14829 FILLER_5_164/a_40_246# tx_inst.bit_index\[2\] 0.00577f
C14830 hold162/a_56_118# net142 0.01398f
C14831 hold162/a_326_118# _110_ 0
C14832 _078_ _477_/a_22_110# 0
C14833 net2 _204_ 0
C14834 _673_/a_298_337# clknet_0_clk 0
C14835 _673_/a_741_93# clkbuf_4_0_0_clk/a_27_118# 0.00203f
C14836 hold126/a_438_182# net71 0.00183f
C14837 hold126/a_326_118# _268_ 0.00282f
C14838 net79 hold60/a_56_118# 0
C14839 VPWR _647_/a_681_505# 0
C14840 FILLER_26_229/a_32_246# hold70/a_56_118# 0
C14841 _388_/a_382_118# _146_ 0.00784f
C14842 _388_/a_559_412# net165 0.00555f
C14843 hold156/a_56_118# clknet_4_2_0_clk 0.01992f
C14844 rx_data[7] _265_ 0.02099f
C14845 net79 net6 0
C14846 _092_ baud_inst.counter\[4\] 0
C14847 hold76/a_438_182# _023_ 0.01343f
C14848 net37 FILLER_11_134/a_32_246# 0
C14849 _264_ _156_ 0.04097f
C14850 _267_ _649_/a_2250_412# 0
C14851 hold172/a_56_118# _665_/a_741_93# 0
C14852 baud_inst.counter\[12\] _357_/a_354_412# 0
C14853 _519_/a_81_118# _189_ 0.00112f
C14854 _696_/a_843_236# _024_ 0
C14855 _360_/a_382_118# tx_inst.data_reg\[0\] 0.05384f
C14856 hold115/a_56_118# _279_ 0
C14857 net79 hold135/a_56_118# 0.00366f
C14858 _661_/a_741_93# _069_ 0
C14859 _658_/a_612_127# clknet_4_1_0_clk 0
C14860 tx_inst.data_reg\[7\] _658_/a_298_337# 0.006f
C14861 _206_ _659_/a_132_114# 0
C14862 hold54/a_438_182# net54 0.01622f
C14863 FILLER_26_35/a_32_246# _107_ 0
C14864 hold66/a_56_118# rx_inst.data_reg\[0\] 0
C14865 hold97/a_56_118# VPWR 0.00501f
C14866 _064_ baud_inst.counter\[5\] 0.00144f
C14867 net31 _427_/a_146_122# 0.00219f
C14868 _294_ _012_ 0.24692f
C14869 net71 net70 0.00122f
C14870 net36 _452_/a_257_140# 0
C14871 net104 _020_ 0.0766f
C14872 rx_inst.data_reg\[3\] _266_ 0.01824f
C14873 _688_/a_1489_191# baud_inst.counter\[16\] 0
C14874 hold157/a_326_118# _690_/a_741_93# 0
C14875 hold157/a_438_182# _690_/a_324_432# 0
C14876 net50 _200_ 1.05493f
C14877 baud_inst.counter\[5\] net40 0.01764f
C14878 _638_/a_612_127# _273_ 0.0058f
C14879 FILLER_19_132/a_40_246# _261_ 0.02243f
C14880 clknet_4_7_0_clk _707_/a_612_127# 0.00527f
C14881 _656_/a_38_114# _388_/a_59_156# 0
C14882 _074_ _120_ 0.03376f
C14883 _079_ clknet_4_6_0_clk 0
C14884 hold119/a_438_182# _168_ 0
C14885 hold139/a_438_182# _247_ 0
C14886 hold139/a_326_118# _137_ 0.00215f
C14887 _638_/a_324_432# net30 0.02165f
C14888 _638_/a_38_114# _266_ 0.03188f
C14889 _438_/a_248_122# _236_ 0
C14890 clknet_4_6_0_clk _666_/a_612_127# 0
C14891 clknet_4_13_0_clk _650_/a_2002_114# 0
C14892 _639_/a_1489_191# rx_inst.data_reg\[7\] 0
C14893 _640_/a_681_505# net52 0
C14894 _547_/a_277_118# net113 0.00488f
C14895 net38 _681_/a_1583_191# 0.00263f
C14896 _073_ FILLER_6_205/a_40_246# 0.00364f
C14897 _690_/a_2250_412# _528_/a_81_118# 0.00872f
C14898 net16 _636_/a_298_337# 0.00577f
C14899 _206_ _664_/a_843_236# 0.02834f
C14900 net122 _216_ 0
C14901 FILLER_15_89/a_32_246# clknet_0_clk 0
C14902 _138_ _429_/a_142_412# -0
C14903 _675_/a_1583_191# net61 0
C14904 _675_/a_1489_191# hold61/a_56_118# 0
C14905 _675_/a_1840_334# _033_ 0.00273f
C14906 _706_/a_324_432# _042_ 0.0193f
C14907 _661_/a_681_505# net55 0
C14908 _661_/a_741_93# _207_ 0
C14909 tx_inst.data_reg\[5\] _653_/a_612_127# 0
C14910 _246_ clknet_0_clk 0.07259f
C14911 _536_/a_192_429# _693_/a_324_432# 0
C14912 _377_/a_46_156# clknet_4_1_0_clk 0
C14913 tx_inst.data_reg\[2\] _208_ 0.07527f
C14914 clknet_4_4_0_clk _150_ -0
C14915 clkbuf_4_0_0_clk/a_27_118# net95 0.03514f
C14916 _017_ _522_/a_209_168# 0
C14917 net176 _451_/a_257_140# 0
C14918 _232_ _429_/a_142_412# 0
C14919 _641_/a_1489_191# net24 0
C14920 _009_ _512_/a_165_412# 0
C14921 hold98/a_56_118# net109 0
C14922 hold125/a_56_118# VPWR 0.06098f
C14923 net58 _316_ 0.07634f
C14924 hold149/a_438_182# fanout45/a_40_152# 0.00888f
C14925 _083_ FILLER_12_106/a_40_246# 0
C14926 _412_/a_22_110# net28 0.01696f
C14927 net28 fanout32/a_40_152# 0
C14928 _411_/a_115_308# _451_/a_155_412# 0
C14929 hold112/a_56_118# _257_ 0
C14930 _153_ _061_ 0.03011f
C14931 _030_ net135 0
C14932 hold117/a_56_118# _681_/a_1489_191# 0
C14933 hold152/a_438_182# _089_ 0
C14934 hold63/a_56_118# _667_/a_741_93# 0
C14935 hold63/a_438_182# _667_/a_38_114# 0
C14936 FILLER_23_204/a_40_246# VPWR 0.14199f
C14937 tx_inst.data_reg\[0\] net9 0.02907f
C14938 _677_/a_1583_191# _676_/a_324_432# 0
C14939 fanout28/a_40_152# net62 0
C14940 _694_/a_843_236# _302_ 0.02095f
C14941 net39 _357_/a_354_412# 0
C14942 input7/a_40_152# net38 0
C14943 _050_ _264_ 0.00392f
C14944 net48 hold127/a_326_118# 0.04132f
C14945 _643_/a_1489_191# clknet_4_12_0_clk 0.0204f
C14946 baud_inst.counter\[20\] _695_/a_741_93# 0
C14947 _360_/a_71_118# VPWR 0.04707f
C14948 _699_/a_741_93# clknet_4_8_0_clk 0.04019f
C14949 _258_ clknet_0_clk 0
C14950 _110_ _310_ 0
C14951 _224_ _435_/a_166_436# 0
C14952 _046_ VPWR 0.17266f
C14953 net142 net141 0.00108f
C14954 _367_/a_170_412# _200_ 0.00143f
C14955 _081_ _265_ 0
C14956 _657_/a_550_127# _209_ 0
C14957 FILLER_5_156/a_32_246# clkbuf_4_4_0_clk/a_27_118# 0
C14958 clknet_4_0_0_clk baud_inst.counter\[0\] 0
C14959 _663_/a_298_337# VPWR 0.00707f
C14960 tx_inst.bit_index\[1\] _141_ 0
C14961 tx_inst.data_reg\[7\] _656_/a_324_432# 0
C14962 _643_/a_38_114# VPWR 0.0215f
C14963 hold160/a_438_182# net160 0.02087f
C14964 hold160/a_326_118# _296_ 0.00752f
C14965 net102 _300_ 0.15366f
C14966 _230_ FILLER_25_141/a_32_246# 0
C14967 hold166/a_56_118# net29 0.00919f
C14968 net126 net30 0.02657f
C14969 net46 hold90/a_326_118# 0.01664f
C14970 _099_ hold90/a_56_118# 0.00552f
C14971 hold106/a_438_182# hold107/a_56_118# 0.00113f
C14972 net22 _275_ 0
C14973 hold110/a_438_182# clknet_4_2_0_clk 0
C14974 VPWR _236_ 0.50055f
C14975 _224_ net24 0.37282f
C14976 FILLER_12_46/a_32_246# hold178/a_438_182# 0.00985f
C14977 _692_/a_1489_191# _105_ 0
C14978 hold99/a_56_118# net45 0
C14979 net36 _447_/a_81_118# 0
C14980 _174_ net168 0
C14981 _194_ _396_/a_155_412# 0.00267f
C14982 hold101/a_56_118# _688_/a_324_432# 0
C14983 hold101/a_326_118# _688_/a_38_114# 0
C14984 hold101/a_438_182# _688_/a_298_337# 0
C14985 _537_/a_192_429# _303_ 0.00431f
C14986 net28 _456_/a_257_140# 0
C14987 net16 net19 0.00965f
C14988 baud_inst.counter\[28\] hold59/a_326_118# 0
C14989 net54 _665_/a_324_432# 0.00505f
C14990 FILLER_15_116/a_40_246# clknet_0_clk 0
C14991 net44 net103 0.0818f
C14992 _645_/a_1489_191# net48 0
C14993 net53 net49 0
C14994 _079_ net29 0
C14995 VPWR _181_ 0.35547f
C14996 _305_ _695_/a_298_337# 0
C14997 net75 _695_/a_38_114# 0.01138f
C14998 input9/a_40_152# VPWR 0.01491f
C14999 _125_ _636_/a_2002_114# 0
C15000 _279_ net38 0.01799f
C15001 _070_ _209_ 0.03382f
C15002 clkbuf_4_11_0_clk/a_27_118# net99 0
C15003 net71 _634_/a_1583_191# 0
C15004 _240_ _635_/a_324_432# 0
C15005 _343_/a_155_412# _197_ 0.02254f
C15006 clknet_4_5_0_clk _665_/a_681_505# 0
C15007 _653_/a_38_114# VPWR 0.00173f
C15008 net42 hold63/a_326_118# 0
C15009 _488_/a_177_436# _145_ 0
C15010 net42 _666_/a_1583_191# 0.0014f
C15011 net62 _667_/a_1840_334# 0
C15012 _204_ _169_ 0.05445f
C15013 _206_ _211_ 1.29628f
C15014 _677_/a_1840_334# baud_inst.counter\[6\] 0
C15015 net50 _705_/a_132_114# 0
C15016 net120 FILLER_21_31/a_40_246# 0
C15017 _163_ _297_ 0
C15018 _203_ net43 0
C15019 _201_ _120_ 0
C15020 net56 _651_/a_324_432# 0.00545f
C15021 _227_ FILLER_14_148/a_40_246# 0
C15022 _124_ hold82/a_326_118# 0
C15023 _239_ _236_ 0.24049f
C15024 baud_inst.counter\[18\] clknet_4_8_0_clk 0
C15025 clknet_0_clk _668_/a_681_505# 0
C15026 hold161/a_438_182# net101 0
C15027 net39 _096_ 0.02766f
C15028 _689_/a_38_114# net40 0
C15029 hold124/a_438_182# _048_ 0
C15030 hold124/a_326_118# net72 0.01662f
C15031 rx_inst.data_reg\[0\] _635_/a_298_337# 0
C15032 hold110/a_56_118# _683_/a_324_432# 0.00352f
C15033 net178 _684_/a_681_505# 0
C15034 _679_/a_324_432# FILLER_5_74/a_32_246# 0
C15035 _206_ _376_/a_76_160# 0.00108f
C15036 fanout26/a_40_152# net29 0.00804f
C15037 _638_/a_1840_334# VPWR 0.00624f
C15038 _639_/a_1583_191# clknet_4_13_0_clk 0.00383f
C15039 baud_inst.counter\[21\] _692_/a_843_236# 0
C15040 hold125/a_326_118# net30 0
C15041 _172_ VPWR 0.04738f
C15042 _691_/a_2002_114# VPWR 0.00129f
C15043 net49 _421_/a_150_412# 0
C15044 _698_/a_1583_191# net142 0
C15045 _073_ _369_/a_248_122# 0
C15046 _048_ _271_ 0.16009f
C15047 _043_ VPWR 0.03309f
C15048 rx_inst.state\[3\] _667_/a_38_114# 0.01082f
C15049 clknet_0_clk _648_/a_843_236# 0
C15050 hold138/a_438_182# _264_ 0.01469f
C15051 _089_ _035_ 0.00118f
C15052 _316_ _027_ 0
C15053 _706_/a_550_127# _200_ 0
C15054 FILLER_22_133/a_40_246# VPWR 0.1343f
C15055 _046_ _266_ 0.00941f
C15056 net49 _435_/a_72_436# 0.00209f
C15057 net47 _273_ 1.1929f
C15058 _054_ net64 0
C15059 _547_/a_81_118# net99 0.03881f
C15060 _069_ _070_ 0
C15061 hold86/a_438_182# _019_ 0
C15062 _639_/a_741_93# hold80/a_56_118# 0
C15063 _639_/a_38_114# hold80/a_438_182# 0
C15064 net49 _703_/a_1785_429# 0
C15065 _672_/a_741_93# hold60/a_56_118# 0.00785f
C15066 _672_/a_324_432# hold60/a_326_118# 0
C15067 _705_/a_741_93# net172 0
C15068 _705_/a_38_114# _200_ 0
C15069 FILLER_16_154/a_32_246# _246_ 0
C15070 net84 clknet_0_clk 0.00145f
C15071 _643_/a_38_114# _266_ 0
C15072 VPWR _088_ 0.23077f
C15073 _675_/a_843_236# _674_/a_741_93# 0.00105f
C15074 hold57/a_326_118# _221_ 0
C15075 _282_ hold92/a_56_118# 0.01387f
C15076 net152 hold92/a_438_182# 0.00449f
C15077 hold108/a_326_118# net29 0.00174f
C15078 _075_ _001_ 0.00157f
C15079 _011_ VPWR 0.03663f
C15080 _000_ _417_/a_120_432# 0
C15081 _644_/a_843_236# rx_inst.bit_index\[2\] 0
C15082 _638_/a_298_337# _049_ 0.02395f
C15083 net79 _287_ 0.29944f
C15084 _339_/a_886_118# _653_/a_1583_191# 0
C15085 VPWR _684_/a_298_337# 0.0024f
C15086 _314_ hold107/a_326_118# 0.01275f
C15087 hold120/a_326_118# _694_/a_324_432# 0
C15088 hold170/a_326_118# clk 0.00173f
C15089 hold167/a_438_182# _002_ 0.00102f
C15090 hold167/a_326_118# net167 0
C15091 rx_inst.data_reg\[0\] _632_/a_612_127# 0
C15092 net177 _520_/a_155_412# 0
C15093 VPWR _647_/a_550_127# 0
C15094 hold144/a_326_118# _647_/a_38_114# 0
C15095 clknet_0_clk _667_/a_741_93# 0
C15096 _269_ _156_ 0.00495f
C15097 _257_ _136_ 0.00274f
C15098 net41 net137 0.007f
C15099 net177 net178 0
C15100 _040_ FILLER_4_237/a_40_246# 0.01393f
C15101 _678_/a_1489_191# clknet_0_clk 0.01563f
C15102 _167_ _236_ 0
C15103 _126_ net30 0.01732f
C15104 _467_/a_22_110# _636_/a_741_93# 0
C15105 _378_/a_382_118# _655_/a_1583_191# 0
C15106 net128 _189_ 0
C15107 baud_inst.counter\[12\] _190_ 0.03618f
C15108 _111_ VPWR 0.1801f
C15109 _679_/a_2250_412# baud_inst.counter\[6\] 0
C15110 _679_/a_1583_191# _185_ 0
C15111 _488_/a_380_412# VPWR 0
C15112 _339_/a_1023_118# _172_ 0
C15113 tx_start net11 0.06811f
C15114 FILLER_14_202/a_40_246# _650_/a_324_432# 0
C15115 _699_/a_38_114# clknet_4_10_0_clk 0
C15116 tx_inst.data_reg\[7\] _658_/a_1583_191# 0.00963f
C15117 _206_ _659_/a_1489_191# 0
C15118 hold55/a_438_182# _705_/a_324_432# 0
C15119 _674_/a_2250_412# net86 0
C15120 FILLER_26_35/a_32_246# net106 0
C15121 hold75/a_326_118# net75 0
C15122 _359_/a_22_110# _076_ 0
C15123 hold53/a_438_182# _051_ 0
C15124 hold103/a_56_118# VPWR 0.0089f
C15125 _644_/a_843_236# _243_ 0
C15126 rx_inst.bit_index\[2\] _445_/a_165_412# 0.00128f
C15127 _433_/a_244_140# _137_ 0
C15128 _433_/a_550_140# _247_ 0
C15129 net49 FILLER_27_135/a_32_246# 0
C15130 net70 _273_ 0.02366f
C15131 hold69/a_56_118# net65 0
C15132 _673_/a_741_93# net181 0.00168f
C15133 _673_/a_324_432# net86 0.04416f
C15134 _400_/a_192_429# net183 0.03324f
C15135 net122 _484_/a_154_118# 0
C15136 _485_/a_120_432# rx_inst.state\[3\] 0.00354f
C15137 clknet_4_7_0_clk net51 0.0123f
C15138 hold124/a_56_118# _267_ 0
C15139 _448_/a_244_412# _160_ 0.00795f
C15140 net116 _287_ 0
C15141 hold96/a_56_118# baud_inst.counter\[6\] 0
C15142 clk VPWR 1.98746f
C15143 _168_ _650_/a_38_114# 0.03404f
C15144 net82 hold82/a_326_118# 0.00648f
C15145 _638_/a_2250_412# net30 0
C15146 clknet_4_4_0_clk _070_ 0.00903f
C15147 _509_/a_257_140# _288_ 0
C15148 _302_ net103 0.01034f
C15149 _283_ FILLER_9_70/a_40_246# 0
C15150 _689_/a_741_93# _682_/a_38_114# 0
C15151 net128 hold129/a_438_182# 0
C15152 _690_/a_38_114# net101 0.02556f
C15153 _690_/a_1840_334# net103 0
C15154 _227_ FILLER_17_131/a_32_246# 0
C15155 net16 _636_/a_1583_191# 0
C15156 _314_ _694_/a_741_93# 0
C15157 _043_ _266_ 0.05125f
C15158 _206_ _664_/a_612_127# 0
C15159 _706_/a_2250_412# _042_ 0.01374f
C15160 net48 output16/a_40_152# 0
C15161 net132 hold151/a_56_118# 0.01764f
C15162 FILLER_28_176/a_32_246# VPWR 0.08345f
C15163 _661_/a_550_127# net55 0
C15164 hold90/a_326_118# _685_/a_741_93# 0.00222f
C15165 hold90/a_56_118# _685_/a_843_236# 0
C15166 net120 _693_/a_741_93# 0.00794f
C15167 _022_ _693_/a_38_114# 0
C15168 input10/a_40_152# _213_ 0
C15169 _017_ _296_ 0.00494f
C15170 net102 net160 -0
C15171 _193_ net54 0.00361f
C15172 _662_/a_324_432# net43 0.00108f
C15173 _662_/a_38_114# _120_ 0
C15174 net33 _706_/a_843_236# 0
C15175 net98 _292_ 0
C15176 _009_ _010_ 0.00872f
C15177 _090_ net154 0.0044f
C15178 _376_/a_76_160# _202_ 0
C15179 net73 net81 0
C15180 FILLER_15_162/a_40_246# clknet_0_clk 0.00144f
C15181 _425_/a_46_156# _455_/a_155_412# 0.01626f
C15182 hold117/a_438_182# net117 0.00145f
C15183 hold117/a_56_118# baud_inst.counter\[9\] 0.00663f
C15184 _286_ _505_/a_170_160# 0
C15185 _064_ clknet_0_clk 0
C15186 _228_ rx_inst.state\[2\] 0.84713f
C15187 hold131/a_438_182# _429_/a_142_412# 0
C15188 hold131/a_326_118# _429_/a_244_412# 0
C15189 hold173/a_56_118# _217_ 0.00543f
C15190 hold173/a_326_118# _195_ 0.00954f
C15191 _677_/a_2250_412# _676_/a_1583_191# 0
C15192 net39 _190_ 0.04025f
C15193 _677_/a_1489_191# _676_/a_741_93# 0
C15194 _013_ net29 0.13243f
C15195 _694_/a_612_127# _302_ 0
C15196 _117_ _666_/a_2250_412# 0
C15197 _117_ tx_busy 0.02074f
C15198 hold100/a_56_118# _312_ 0
C15199 _645_/a_612_127# net151 0
C15200 baud_inst.counter\[28\] _699_/a_324_432# 0
C15201 _360_/a_1109_431# VPWR 0
C15202 _101_ _299_ 0.00156f
C15203 _635_/a_741_93# clknet_0_clk 0
C15204 _193_ _364_/a_257_140# 0
C15205 net184 _196_ 0.00158f
C15206 tx_inst.bit_index\[1\] _197_ 0
C15207 hold116/a_438_182# net29 0
C15208 _007_ _476_/a_146_122# 0
C15209 clknet_0_clk net40 0.12782f
C15210 baud_inst.counter\[14\] net29 0.00783f
C15211 _491_/a_192_429# FILLER_0_56/a_32_246# 0
C15212 _696_/a_324_432# _309_ 0
C15213 _696_/a_843_236# baud_inst.counter\[24\] 0.00296f
C15214 _513_/a_435_412# _163_ 0.00128f
C15215 hold105/a_438_182# _701_/a_2250_412# 0
C15216 _663_/a_1583_191# VPWR 0.00626f
C15217 net62 FILLER_14_164/a_32_246# 0.01352f
C15218 net26 _669_/a_1840_334# 0
C15219 net28 _061_ 0.45599f
C15220 FILLER_26_229/a_32_246# rx_inst.data_reg\[5\] 0
C15221 _170_ _234_ 0.66073f
C15222 _643_/a_1840_334# VPWR 0.00251f
C15223 clknet_4_5_0_clk _206_ 0.15218f
C15224 net97 net29 0.03998f
C15225 net123 _089_ 0
C15226 FILLER_23_158/a_40_246# net24 0.00194f
C15227 hold147/a_56_118# net147 0
C15228 _487_/a_248_122# net55 0
C15229 tx_inst.state\[4\] clknet_4_6_0_clk 0
C15230 _672_/a_843_236# FILLER_0_54/a_40_246# 0
C15231 net29 net86 0.00132f
C15232 net95 net181 0.01524f
C15233 baud_inst.counter\[8\] _682_/a_1840_334# 0
C15234 rx_inst.state\[3\] fanout28/a_40_152# 0
C15235 rx_inst.data_reg\[6\] hold72/a_438_182# 0.00233f
C15236 net100 _130_ 0
C15237 VPWR baud_inst.counter\[16\] 0.50561f
C15238 FILLER_13_68/a_40_246# _292_ 0
C15239 _116_ baud_inst.counter\[29\] 0
C15240 net79 clkbuf_4_0_0_clk/a_27_118# 0.00577f
C15241 net44 _670_/a_324_432# 0
C15242 net13 _634_/a_324_432# 0
C15243 _556_/a_192_429# net49 0.01363f
C15244 _040_ _198_ 0
C15245 _466_/a_22_110# FILLER_17_201/a_32_246# 0
C15246 _153_ _156_ 0
C15247 _064_ _386_/a_59_156# 0
C15248 _671_/a_741_93# clknet_4_6_0_clk 0.03029f
C15249 baud_inst.counter\[18\] _688_/a_843_236# 0
C15250 FILLER_5_156/a_32_246# VPWR 0.08441f
C15251 _305_ _303_ 0
C15252 _234_ hold62/a_56_118# 0.00218f
C15253 _409_/a_167_412# VPWR 0
C15254 net54 _665_/a_2250_412# 0
C15255 _010_ _683_/a_38_114# 0
C15256 _292_ _683_/a_324_432# 0.02074f
C15257 net44 net101 0.0021f
C15258 rx_inst.data_reg\[2\] net48 0.02246f
C15259 net40 _348_/a_146_122# 0.00115f
C15260 _674_/a_324_432# net38 0.00249f
C15261 _516_/a_279_412# _189_ 0.00347f
C15262 _516_/a_165_412# _190_ 0.00161f
C15263 net75 _695_/a_1840_334# 0
C15264 FILLER_6_191/a_32_246# FILLER_6_189/a_40_246# 0.0524f
C15265 _064_ _182_ 0
C15266 _073_ _375_/a_170_412# 0
C15267 _188_ _355_/a_150_412# 0
C15268 hold120/a_326_118# baud_inst.counter\[22\] 0.06348f
C15269 FILLER_1_173/a_32_246# net170 0
C15270 _198_ _006_ 0.01358f
C15271 hold128/a_56_118# net91 0
C15272 _653_/a_1840_334# VPWR 0.00473f
C15273 clkbuf_4_14_0_clk/a_27_118# FILLER_25_163/a_32_246# 0.01277f
C15274 _019_ _145_ 0.25915f
C15275 fanout40/a_40_152# _523_/a_155_412# 0
C15276 hold87/a_326_118# net46 0.00143f
C15277 baud_inst.counter\[31\] _698_/a_741_93# 0
C15278 _097_ _290_ 0
C15279 _182_ net40 0.22787f
C15280 _670_/a_38_114# clknet_0_clk 0.0049f
C15281 net47 FILLER_28_204/a_32_246# 0.01718f
C15282 tx_inst.bit_index\[1\] _339_/a_382_118# 0.0607f
C15283 _680_/a_324_432# _681_/a_741_93# 0
C15284 _680_/a_38_114# _681_/a_843_236# 0
C15285 hold173/a_326_118# _401_/a_22_110# 0
C15286 _040_ tx_start 0
C15287 clknet_4_3_0_clk _090_ 0.12858f
C15288 _171_ FILLER_6_205/a_40_246# 0.03116f
C15289 hold74/a_56_118# net74 0
C15290 hold74/a_326_118# _126_ 0.01678f
C15291 _363_/a_120_432# _196_ 0.00232f
C15292 baud_inst.counter\[20\] net120 0.08468f
C15293 hold115/a_326_118# baud_inst.counter\[9\] 0.0049f
C15294 _689_/a_1840_334# net40 0.00784f
C15295 net2 VPWR 1.0368f
C15296 net178 _684_/a_550_127# 0
C15297 _079_ net122 0.02495f
C15298 _637_/a_38_114# rx_inst.data_reg\[5\] 0
C15299 net72 _648_/a_741_93# 0
C15300 net85 hold111/a_438_182# 0.00275f
C15301 net129 _292_ 0.00126f
C15302 tx VPWR 0.05863f
C15303 hold167/a_56_118# _669_/a_324_432# 0
C15304 _633_/a_324_432# _264_ 0.00138f
C15305 _268_ _649_/a_1840_334# 0.00168f
C15306 net71 _649_/a_2250_412# 0
C15307 _246_ _436_/a_550_140# 0
C15308 FILLER_18_160/a_32_246# clknet_0_clk 0
C15309 net100 net46 0
C15310 hold174/a_56_118# _197_ 0
C15311 net42 FILLER_12_166/a_40_246# 0.01992f
C15312 clkload3/Y VPWR 0.01903f
C15313 _203_ _664_/a_2250_412# 0.01315f
C15314 _683_/a_843_236# _096_ 0.00245f
C15315 rx_inst.bit_index\[1\] _642_/a_1583_191# 0
C15316 _240_ _650_/a_741_93# 0
C15317 clknet_4_11_0_clk _698_/a_298_337# 0.002f
C15318 baud_inst.counter\[15\] _301_ 0
C15319 _694_/a_843_236# FILLER_22_32/a_40_246# 0
C15320 net42 _215_ 0.00305f
C15321 net81 net118 0
C15322 _072_ _209_ 0.03224f
C15323 _658_/a_843_236# net165 0.00122f
C15324 _226_ _228_ 0.70202f
C15325 _229_ hold180/a_438_182# 0.01469f
C15326 hold100/a_438_182# _697_/a_324_432# 0
C15327 _392_/a_285_412# clknet_4_4_0_clk 0
C15328 baud_inst.counter\[13\] hold91/a_326_118# 0
C15329 _639_/a_843_236# net80 0
C15330 _045_ hold124/a_326_118# 0.00168f
C15331 hold96/a_438_182# _679_/a_324_432# 0
C15332 net109 clknet_4_0_0_clk 0
C15333 _701_/a_38_114# net107 0.01744f
C15334 FILLER_4_183/a_40_246# _480_/a_22_110# 0
C15335 _643_/a_2250_412# net30 0
C15336 _643_/a_1840_334# _266_ 0.00732f
C15337 hold140/a_56_118# baud_inst.counter\[25\] 0.03298f
C15338 hold140/a_438_182# net99 0.00134f
C15339 _675_/a_1583_191# _674_/a_1583_191# 0
C15340 _081_ _668_/a_324_432# 0.02377f
C15341 FILLER_16_176/a_40_246# _248_ 0
C15342 hold138/a_326_118# _156_ 0.01884f
C15343 _411_/a_115_308# VPWR 0.00763f
C15344 _691_/a_741_93# net49 0.00182f
C15345 _443_/a_252_412# _161_ 0.00244f
C15346 net145 _211_ 0.20557f
C15347 _678_/a_843_236# _282_ 0.00151f
C15348 _671_/a_741_93# net29 0.00541f
C15349 net30 _235_ 0
C15350 _000_ _140_ 0.02501f
C15351 _638_/a_1583_191# _049_ 0
C15352 tx_data[7] FILLER_0_80/a_40_246# 0
C15353 net92 FILLER_8_92/a_32_246# 0.01352f
C15354 VPWR _684_/a_1583_191# 0.00626f
C15355 net31 _231_ 0
C15356 _233_ _170_ 0.01507f
C15357 _537_/a_155_160# _022_ 0
C15358 _677_/a_298_337# net154 0
C15359 baud_inst.counter\[6\] _382_/a_382_118# 0
C15360 _686_/a_741_93# net29 0
C15361 _643_/a_843_236# _154_ 0.00131f
C15362 hold169/a_56_118# VPWR 0.01247f
C15363 net177 _297_ 0
C15364 clknet_0_clk _667_/a_1785_429# 0
C15365 _140_ _647_/a_38_114# 0
C15366 clknet_4_13_0_clk FILLER_16_221/a_32_246# 0.00404f
C15367 clknet_4_5_0_clk _202_ 0
C15368 fanout37/a_40_152# _168_ 0.00588f
C15369 _517_/a_209_168# net90 0.00815f
C15370 _644_/a_298_337# VPWR 0.00253f
C15371 _680_/a_741_93# _490_/a_45_160# 0
C15372 _017_ _531_/a_209_168# 0
C15373 hold126/a_56_118# net30 0.00961f
C15374 _206_ _655_/a_1583_191# 0.00828f
C15375 clknet_4_14_0_clk _633_/a_1583_191# 0.00255f
C15376 _474_/a_22_110# net65 0.01745f
C15377 net35 net175 0.01816f
C15378 baud_inst.counter\[7\] _352_/a_46_156# 0.01854f
C15379 _679_/a_2002_114# _185_ 0
C15380 clknet_4_3_0_clk _352_/a_268_412# 0.00127f
C15381 clk _400_/a_155_160# 0
C15382 net178 _188_ 0.00569f
C15383 _233_ hold62/a_56_118# 0
C15384 _313_ _702_/a_843_236# 0
C15385 _230_ _421_/a_252_412# 0.00387f
C15386 _696_/a_550_127# _180_ 0
C15387 net184 tx_inst.data_reg\[0\] 0
C15388 FILLER_8_14/a_32_246# net40 0.00531f
C15389 fanout30/a_40_152# _241_ 0
C15390 net46 _296_ 0
C15391 _072_ _069_ 0.00304f
C15392 tx_inst.data_reg\[7\] _658_/a_2002_114# 0
C15393 VPWR hold83/a_326_118# 0.004f
C15394 _114_ hold106/a_326_118# 0
C15395 _653_/a_38_114# _652_/a_741_93# 0
C15396 _126_ _647_/a_2250_412# 0
C15397 hold125/a_56_118# _138_ 0.02799f
C15398 net44 hold100/a_438_182# 0
C15399 _676_/a_324_432# FILLER_12_106/a_40_246# 0
C15400 _165_ clknet_0_clk 0.03085f
C15401 net55 _706_/a_741_93# 0.00122f
C15402 _260_ _409_/a_73_118# 0
C15403 _643_/a_843_236# FILLER_20_198/a_40_246# 0
C15404 rx_inst.bit_index\[2\] _257_ 0.15554f
C15405 rx_inst.bit_index\[2\] _256_ 0
C15406 hold76/a_56_118# _695_/a_612_127# 0
C15407 net27 net62 0.02575f
C15408 hold105/a_438_182# baud_inst.counter\[29\] 0.00238f
C15409 hold54/a_438_182# VPWR 0.00293f
C15410 tx FILLER_7_234/a_32_246# 0
C15411 net2 _266_ 1.61977f
C15412 clkload1/Y clknet_4_6_0_clk 0.00124f
C15413 _707_/a_324_432# _668_/a_1583_191# 0
C15414 _707_/a_298_337# _668_/a_2250_412# 0
C15415 hold150/a_438_182# net47 0.01311f
C15416 _003_ rx_inst.state\[3\] 0.03047f
C15417 _642_/a_2250_412# net180 0
C15418 net15 VPWR 0.14975f
C15419 _656_/a_843_236# _146_ 0
C15420 _488_/a_209_168# _181_ 0.00651f
C15421 _488_/a_177_436# net60 0
C15422 _656_/a_132_114# net165 0
C15423 _168_ _650_/a_1840_334# 0
C15424 hold176/a_438_182# baud_inst.counter\[25\] 0
C15425 net2 _167_ 0
C15426 _302_ net101 0
C15427 FILLER_11_32/a_32_246# _682_/a_324_432# 0
C15428 clknet_4_14_0_clk net52 0.11798f
C15429 _690_/a_1840_334# net101 0
C15430 baud_inst.counter\[20\] _533_/a_248_122# 0.00108f
C15431 _206_ _005_ 0
C15432 VPWR _634_/a_843_236# 0.00258f
C15433 VPWR _681_/a_298_337# 0.0038f
C15434 hold100/a_326_118# clknet_0_clk 0.00692f
C15435 _072_ _207_ 0
C15436 _486_/a_358_436# clk 0
C15437 net120 _693_/a_1785_429# 0
C15438 _696_/a_298_337# net46 0.03015f
C15439 FILLER_16_56/a_32_246# VPWR 0.07378f
C15440 _114_ hold120/a_56_118# 0
C15441 _225_ net2 0
C15442 _662_/a_1840_334# _120_ 0
C15443 FILLER_14_185/a_32_246# _459_/a_27_156# 0.01157f
C15444 _230_ net24 0.07129f
C15445 _643_/a_843_236# _160_ 0.00178f
C15446 _643_/a_38_114# _232_ 0
C15447 _425_/a_46_156# _130_ 0.00238f
C15448 _097_ baud_inst.counter\[15\] 0
C15449 _641_/a_843_236# net176 0.00623f
C15450 hold52/a_438_182# net24 0.00188f
C15451 hold144/a_438_182# _160_ 0.00164f
C15452 _641_/a_681_505# _052_ 0
C15453 hold171/a_326_118# net41 0
C15454 _668_/a_2250_412# hold51/a_438_182# 0.00887f
C15455 _117_ _704_/a_741_93# 0.00178f
C15456 clkbuf_4_5_0_clk/a_27_118# _275_ 0
C15457 clknet_4_3_0_clk _677_/a_298_337# 0.00147f
C15458 _097_ FILLER_12_42/a_32_246# 0.00135f
C15459 net35 _161_ 0.00926f
C15460 _256_ _243_ 0
C15461 baud_inst.counter\[28\] _699_/a_2250_412# 0
C15462 baud_inst.counter\[30\] _699_/a_1583_191# 0
C15463 baud_inst.counter\[31\] _699_/a_1840_334# 0
C15464 net43 _667_/a_741_93# 0.02069f
C15465 _671_/a_2250_412# _668_/a_38_114# 0
C15466 _264_ clkbuf_4_15_0_clk/a_27_118# 0.03368f
C15467 net24 FILLER_22_175/a_32_246# 0.00144f
C15468 rx_inst.bit_index\[2\] fanout24/a_40_152# 0
C15469 net145 _659_/a_1489_191# 0.00399f
C15470 _007_ _274_ 0.08362f
C15471 _169_ VPWR 0.36241f
C15472 fanout45/a_40_152# VPWR 0.03925f
C15473 net85 clknet_0_clk 0.04543f
C15474 _181_ FILLER_0_56/a_32_246# 0
C15475 _118_ _166_ 0.00167f
C15476 _663_/a_324_432# _663_/a_741_93# 0
C15477 _232_ _236_ 0.43168f
C15478 _163_ _011_ 0.00129f
C15479 _163_ _684_/a_298_337# 0.00225f
C15480 _513_/a_341_118# _684_/a_741_93# 0
C15481 _643_/a_741_93# _643_/a_843_236# 0
C15482 FILLER_15_173/a_40_246# _153_ 0
C15483 net92 _678_/a_741_93# 0.00215f
C15484 _190_ _683_/a_843_236# 0
C15485 _283_ _678_/a_324_432# 0
C15486 _180_ _683_/a_1840_334# 0
C15487 hold144/a_326_118# hold144/a_438_182# -0
C15488 clkbuf_4_7_0_clk/a_27_118# FILLER_12_208/a_32_246# 0
C15489 _679_/a_38_114# net115 0
C15490 hold87/a_56_118# VPWR 0.0122f
C15491 hold149/a_56_118# _694_/a_298_337# 0
C15492 net146 FILLER_6_205/a_40_246# 0
C15493 FILLER_17_160/a_40_246# clknet_0_clk 0.00196f
C15494 net49 FILLER_23_83/a_32_246# 0
C15495 _662_/a_1583_191# net21 0
C15496 _545_/a_248_122# baud_inst.counter\[25\] 0
C15497 _360_/a_1453_124# net9 0.00252f
C15498 _653_/a_843_236# net183 0
C15499 rx_done _639_/a_324_432# 0
C15500 _022_ FILLER_24_19/a_40_246# 0
C15501 hold76/a_326_118# net120 0
C15502 FILLER_21_192/a_40_246# _264_ 0
C15503 hold140/a_326_118# net140 0.00607f
C15504 _117_ _707_/a_298_337# 0
C15505 baud_inst.counter\[12\] net87 0.00203f
C15506 net49 _106_ 0.01862f
C15507 hold85/a_56_118# _636_/a_843_236# 0
C15508 _080_ net57 0
C15509 _316_ net49 0.00409f
C15510 fanout32/a_40_152# _223_ 0.02715f
C15511 _127_ _634_/a_843_236# 0
C15512 net67 _315_ 0
C15513 _114_ _314_ 0
C15514 net146 clkbuf_4_7_0_clk/a_27_118# 0
C15515 FILLER_15_17/a_40_246# net49 0
C15516 _674_/a_1840_334# _085_ 0
C15517 _674_/a_2250_412# net38 0
C15518 _012_ _190_ 0.00613f
C15519 net37 net166 0
C15520 _188_ baud_inst.counter\[19\] 0.02089f
C15521 _532_/a_257_140# _303_ 0
C15522 _662_/a_298_337# clknet_4_5_0_clk 0.00157f
C15523 net87 net88 0.05553f
C15524 _059_ net72 0
C15525 _643_/a_1583_191# _049_ 0
C15526 _112_ hold114/a_56_118# 0
C15527 VPWR _665_/a_324_432# 0.00119f
C15528 _206_ _199_ 0
C15529 _670_/a_1840_334# clknet_0_clk 0
C15530 rx_data[3] net30 0
C15531 _442_/a_248_122# _236_ 0
C15532 _257_ net64 0
C15533 _673_/a_324_432# net38 0.01713f
C15534 _680_/a_741_93# _681_/a_2250_412# 0
C15535 net50 net22 0.02101f
C15536 net28 _156_ 0
C15537 hold99/a_56_118# _051_ 0
C15538 _500_/a_155_412# net29 0.00157f
C15539 net94 _503_/a_165_412# 0
C15540 _064_ net43 0.01892f
C15541 hold156/a_326_118# net156 0.00179f
C15542 fanout32/a_40_152# _240_ 0.07127f
C15543 _466_/a_22_110# VPWR 0
C15544 net26 _666_/a_741_93# 0.00555f
C15545 net37 _373_/a_170_412# 0.00264f
C15546 _555_/a_209_168# _314_ 0.00899f
C15547 net79 net181 0.79369f
C15548 clknet_4_3_0_clk _676_/a_681_505# 0.00109f
C15549 net48 hold119/a_56_118# 0
C15550 VPWR _084_ 0.18437f
C15551 _519_/a_81_118# clknet_0_clk 0.03375f
C15552 _679_/a_324_432# net96 0.00752f
C15553 _679_/a_38_114# clknet_4_3_0_clk 0
C15554 net167 _669_/a_741_93# 0.00374f
C15555 _002_ _669_/a_843_236# 0.00108f
C15556 rx_inst.state\[2\] net28 0.00374f
C15557 _633_/a_2250_412# _264_ 0
C15558 _246_ _249_ 0.52511f
C15559 fanout40/a_40_152# _188_ 0.00339f
C15560 _250_ net29 0
C15561 _226_ _434_/a_150_412# 0
C15562 net37 _447_/a_379_118# 0.00167f
C15563 net84 clkbuf_4_13_0_clk/a_27_118# 0.01089f
C15564 _024_ baud_inst.counter\[25\] 0
C15565 _390_/a_59_156# net7 0
C15566 hold59/a_56_118# VPWR 0.01014f
C15567 _273_ _649_/a_2250_412# 0
C15568 _341_/a_71_118# tx_inst.data_reg\[0\] 0.05062f
C15569 _683_/a_1840_334# baud_inst.counter\[11\] 0
C15570 _100_ _687_/a_38_114# 0.03954f
C15571 _653_/a_741_93# _653_/a_843_236# -0
C15572 _090_ baud_inst.counter\[5\] 0.00138f
C15573 _693_/a_681_505# net46 0
C15574 clkbuf_4_6_0_clk/a_27_118# _168_ 0.02489f
C15575 baud_inst.counter\[26\] _699_/a_324_432# 0
C15576 _177_ _699_/a_38_114# 0.04062f
C15577 net53 _698_/a_681_505# 0
C15578 clknet_4_11_0_clk _698_/a_1583_191# 0.00426f
C15579 baud_inst.counter\[27\] _699_/a_741_93# 0
C15580 net27 _666_/a_1840_334# 0
C15581 _169_ _266_ 0
C15582 hold159/a_326_118# net159 0.00156f
C15583 _658_/a_612_127# net165 0
C15584 tx_inst.data_reg\[4\] _661_/a_2250_412# 0
C15585 FILLER_13_137/a_32_246# clknet_0_clk 0
C15586 hold116/a_326_118# net116 0.00581f
C15587 hold116/a_438_182# _288_ 0.00722f
C15588 _639_/a_612_127# net80 0.0025f
C15589 _050_ hold80/a_56_118# 0.00161f
C15590 _169_ _167_ 0.00187f
C15591 _378_/a_59_156# net159 0.00102f
C15592 net155 _390_/a_59_156# 0.01004f
C15593 _206_ _390_/a_382_118# 0.04972f
C15594 net57 _041_ 0.00651f
C15595 _689_/a_324_432# _015_ 0
C15596 VPWR _016_ 0.14723f
C15597 net87 _529_/a_45_160# 0
C15598 _410_/a_257_140# _234_ 0
C15599 net37 _436_/a_142_412# 0
C15600 hold124/a_56_118# net71 0.00696f
C15601 _031_ net68 0.00605f
C15602 _675_/a_741_93# _030_ 0
C15603 FILLER_4_100/a_40_246# _066_ 0.00143f
C15604 _098_ hold129/a_56_118# 0
C15605 _254_ _161_ 0.19643f
C15606 _691_/a_1785_429# net49 0.00115f
C15607 _203_ FILLER_5_213/a_32_246# 0.0044f
C15608 net152 hold95/a_56_118# 0.00421f
C15609 net35 clkbuf_4_14_0_clk/a_27_118# 0
C15610 net108 net116 0
C15611 net97 _288_ 0.55551f
C15612 _358_/a_268_436# net29 0.0038f
C15613 hold52/a_326_118# VPWR 0.01171f
C15614 VPWR hold61/a_326_118# 0.01444f
C15615 _240_ _456_/a_257_140# 0
C15616 hold120/a_56_118# _107_ 0
C15617 net29 net38 0
C15618 _070_ _386_/a_382_118# 0.00234f
C15619 _017_ net104 0
C15620 _163_ baud_inst.counter\[16\] 0
C15621 _154_ net47 0.03651f
C15622 _091_ FILLER_6_98/a_40_246# 0
C15623 _078_ _217_ 0.01248f
C15624 FILLER_16_70/a_40_246# VPWR 0.13863f
C15625 net48 _648_/a_132_114# 0
C15626 _512_/a_165_412# baud_inst.counter\[10\] 0.00102f
C15627 _411_/a_358_436# _486_/a_115_308# 0
C15628 _643_/a_612_127# _154_ 0
C15629 hold113/a_56_118# _310_ 0
C15630 hold157/a_326_118# _688_/a_324_432# 0.00347f
C15631 hold157/a_56_118# _688_/a_741_93# 0.00785f
C15632 _638_/a_741_93# net70 0
C15633 _658_/a_1840_334# _656_/a_38_114# 0
C15634 _658_/a_2250_412# _656_/a_298_337# 0
C15635 _644_/a_1583_191# VPWR 0.00861f
C15636 net179 _665_/a_38_114# 0
C15637 _284_ _063_ 0
C15638 _650_/a_324_432# net19 0
C15639 _357_/a_150_412# _180_ 0
C15640 baud_inst.counter\[12\] _685_/a_324_432# 0
C15641 baud_inst.counter\[17\] _526_/a_146_122# 0
C15642 net128 _685_/a_38_114# 0.0302f
C15643 hold119/a_326_118# _157_ 0.00111f
C15644 clknet_4_14_0_clk _633_/a_2002_114# 0
C15645 _231_ net62 0.12818f
C15646 net37 _671_/a_324_432# 0
C15647 baud_inst.counter\[15\] net90 0.00672f
C15648 _025_ hold91/a_438_182# 0
C15649 _313_ _702_/a_612_127# 0
C15650 _694_/a_681_505# clknet_4_10_0_clk 0
C15651 hold68/a_56_118# _701_/a_1583_191# 0
C15652 net111 clknet_4_13_0_clk 0
C15653 net56 _401_/a_120_432# 0.00172f
C15654 _545_/a_248_122# baud_inst.counter\[24\] 0.00493f
C15655 output23/a_40_152# _705_/a_741_93# 0
C15656 hold132/a_326_118# _158_ 0.01221f
C15657 _653_/a_843_236# _652_/a_1583_191# 0.00216f
C15658 _653_/a_741_93# _652_/a_1840_334# 0
C15659 hold177/a_326_118# clknet_0_clk 0.01074f
C15660 net47 FILLER_20_198/a_40_246# 0
C15661 hold110/a_56_118# _183_ 0
C15662 _660_/a_38_114# net41 0.0495f
C15663 _660_/a_298_337# _071_ 0.03771f
C15664 hold126/a_438_182# _154_ 0.00219f
C15665 _135_ _251_ 0
C15666 baud_inst.counter\[26\] _698_/a_843_236# 0
C15667 _466_/a_22_110# _266_ 0.00624f
C15668 hold76/a_56_118# net76 0.00106f
C15669 hold117/a_326_118# net40 0
C15670 _487_/a_146_122# clknet_0_clk 0
C15671 hold134/a_326_118# net133 0.01276f
C15672 _282_ _037_ 0.00406f
C15673 hold57/a_326_118# _651_/a_324_432# 0
C15674 hold57/a_56_118# _651_/a_741_93# 0
C15675 _168_ hold62/a_438_182# 0
C15676 hold118/a_438_182# _265_ 0
C15677 hold118/a_326_118# _129_ 0.00985f
C15678 _019_ net60 0
C15679 clknet_4_1_0_clk _386_/a_285_412# 0
C15680 _399_/a_154_118# _142_ 0
C15681 hold166/a_326_118# net63 0
C15682 net138 clknet_4_13_0_clk 0
C15683 baud_inst.counter\[4\] _142_ 0
C15684 hold75/a_56_118# _695_/a_1840_334# 0
C15685 hold70/a_438_182# hold72/a_56_118# 0
C15686 _202_ _199_ 0.00413f
C15687 FILLER_14_202/a_40_246# _264_ 0
C15688 net42 baud_inst.counter\[4\] 0.10361f
C15689 _314_ _107_ 0
C15690 _654_/a_38_114# net170 0
C15691 _117_ _081_ 0
C15692 _255_ _252_ 0
C15693 net111 net65 0.00457f
C15694 FILLER_27_46/a_32_246# VPWR 0.07663f
C15695 _553_/a_170_412# net105 0
C15696 _635_/a_741_93# clkbuf_4_13_0_clk/a_27_118# 0.00844f
C15697 _646_/a_324_432# FILLER_21_194/a_32_246# 0
C15698 VPWR _681_/a_1583_191# 0.01403f
C15699 hold89/a_326_118# VPWR 0
C15700 _428_/a_354_412# _245_ 0
C15701 hold127/a_438_182# net24 0
C15702 _074_ tx_inst.data_reg\[0\] 0.01308f
C15703 _696_/a_1583_191# net46 0.02189f
C15704 _160_ net47 0.84747f
C15705 net152 net40 0.03444f
C15706 baud_inst.counter\[13\] VPWR 0.21888f
C15707 net70 _154_ 0.15356f
C15708 _643_/a_612_127# _160_ 0
C15709 _641_/a_612_127# net176 0.0039f
C15710 net39 _685_/a_324_432# 0
C15711 hold78/a_56_118# _633_/a_741_93# 0
C15712 rx_inst.bit_index\[2\] _238_ 0
C15713 _117_ _704_/a_1785_429# 0
C15714 _547_/a_175_118# net46 0.00182f
C15715 net39 fanout38/a_40_152# 0
C15716 net39 _689_/a_324_432# 0.0214f
C15717 clknet_4_3_0_clk _677_/a_1583_191# 0.01683f
C15718 _179_ _699_/a_1489_191# 0
C15719 _193_ VPWR 0.13951f
C15720 net33 _705_/a_1583_191# 0.00122f
C15721 VPWR _649_/a_132_114# 0
C15722 hold99/a_56_118# _698_/a_324_432# 0
C15723 input7/a_40_152# VPWR 0.0051f
C15724 _195_ _476_/a_146_122# 0.00149f
C15725 net43 _667_/a_1785_429# 0.00138f
C15726 _697_/a_38_114# _696_/a_843_236# 0
C15727 net145 tx_inst.data_reg\[5\] 0.24048f
C15728 _285_ _673_/a_324_432# 0
C15729 _498_/a_165_412# net40 0.00811f
C15730 fanout34/a_40_152# FILLER_9_169/a_32_246# 0.00624f
C15731 FILLER_19_75/a_40_246# net99 0
C15732 _643_/a_741_93# net47 0.01426f
C15733 _643_/a_324_432# _054_ 0.03196f
C15734 _024_ baud_inst.counter\[24\] 0.03786f
C15735 net31 _228_ 0.18836f
C15736 hold181/a_326_118# clknet_4_0_0_clk 0.00279f
C15737 hold110/a_56_118# net115 0
C15738 _705_/a_38_114# net22 0
C15739 net32 fanout25/a_40_152# 0.00176f
C15740 _163_ _684_/a_1583_191# 0.03991f
C15741 clknet_4_13_0_clk _047_ 0.01477f
C15742 hold121/a_56_118# _106_ 0
C15743 _041_ fanout27/a_40_152# 0
C15744 _415_/a_170_412# _234_ 0.00103f
C15745 _060_ net126 0
C15746 net54 _380_/a_59_156# 0
C15747 _198_ _706_/a_132_114# 0
C15748 _013_ FILLER_14_72/a_32_246# 0
C15749 hold153/a_326_118# hold154/a_56_118# 0
C15750 hold153/a_56_118# hold154/a_326_118# 0
C15751 net75 net147 0
C15752 _378_/a_496_118# VPWR 0
C15753 hold155/a_56_118# net41 0
C15754 _090_ _496_/a_170_412# 0
C15755 _417_/a_22_110# _140_ 0.01159f
C15756 VPWR _544_/a_46_156# 0.01371f
C15757 net75 net46 0
C15758 _052_ _111_ 0.25241f
C15759 _556_/a_192_429# _699_/a_741_93# 0
C15760 _639_/a_843_236# _121_ 0
C15761 _360_/a_1377_160# net9 0.00178f
C15762 _653_/a_2250_412# _221_ 0
C15763 _073_ tx_inst.state\[4\] 0
C15764 _206_ FILLER_1_201/a_40_246# 0
C15765 _117_ _707_/a_1583_191# 0
C15766 baud_inst.counter\[14\] FILLER_14_72/a_32_246# 0
C15767 tx_inst.data_reg\[3\] clknet_0_clk 0.0599f
C15768 hold85/a_438_182# _636_/a_2250_412# 0
C15769 net49 _423_/a_165_412# 0.001f
C15770 _243_ _238_ 0
C15771 _287_ _683_/a_38_114# 0
C15772 net135 _683_/a_324_432# 0
C15773 net28 FILLER_15_173/a_40_246# 0
C15774 hold85/a_326_118# net48 0.00293f
C15775 _662_/a_843_236# net54 0.0313f
C15776 _509_/a_155_412# _683_/a_38_114# 0
C15777 _670_/a_298_337# baud_inst.counter\[4\] -0
C15778 net89 baud_inst.counter\[19\] 0
C15779 _699_/a_38_114# VPWR 0.00681f
C15780 net109 _096_ 0.02109f
C15781 net35 FILLER_18_148/a_40_246# 0
C15782 _244_ clknet_0_clk 0.14871f
C15783 _662_/a_1583_191# clknet_4_5_0_clk 0.00315f
C15784 net44 _696_/a_741_93# 0.00364f
C15785 _031_ hold105/a_326_118# 0.03324f
C15786 hold171/a_56_118# _388_/a_59_156# 0
C15787 _284_ _089_ 0
C15788 VPWR _279_ 0.1476f
C15789 VPWR _665_/a_2250_412# 0.00235f
C15790 net3 _654_/a_132_114# 0
C15791 _673_/a_2250_412# net38 0.04963f
C15792 _673_/a_1840_334# _085_ 0
C15793 _686_/a_324_432# net90 0
C15794 _424_/a_550_140# net24 0
C15795 hold117/a_438_182# _682_/a_324_432# 0
C15796 hold117/a_56_118# _682_/a_843_236# 0
C15797 net94 _037_ 0.02662f
C15798 _285_ net29 0.01547f
C15799 hold117/a_326_118# _682_/a_741_93# 0
C15800 net125 _245_ 0
C15801 _701_/a_324_432# net46 0
C15802 net45 FILLER_21_96/a_40_246# 0
C15803 net55 _200_ 1.34339f
C15804 _316_ hold59/a_438_182# 0
C15805 _032_ hold59/a_326_118# 0.01059f
C15806 net110 _096_ 0.00492f
C15807 net177 _011_ 0
C15808 net37 clknet_4_9_0_clk 0
C15809 _060_ hold125/a_326_118# 0
C15810 net177 _684_/a_298_337# 0
C15811 net26 clkbuf_4_5_0_clk/a_27_118# 0
C15812 clknet_4_3_0_clk _676_/a_550_127# 0
C15813 _079_ _170_ 0
C15814 hold56/a_326_118# _216_ 0.00541f
C15815 hold104/a_56_118# _690_/a_741_93# 0.00158f
C15816 net128 clknet_0_clk 0.09116f
C15817 _702_/a_324_432# _700_/a_1840_334# 0
C15818 _702_/a_741_93# _700_/a_1583_191# 0.01182f
C15819 _679_/a_1840_334# clknet_4_3_0_clk 0
C15820 _679_/a_1583_191# baud_inst.counter\[7\] 0.00581f
C15821 _688_/a_38_114# net40 0
C15822 _147_ _386_/a_285_412# 0.00116f
C15823 _163_ _356_/a_146_122# 0.00307f
C15824 _696_/a_324_432# clknet_0_clk 0.00146f
C15825 _081_ _650_/a_38_114# 0
C15826 _306_ _687_/a_132_114# 0
C15827 net37 _259_ 0
C15828 _659_/a_324_432# net41 0.01941f
C15829 net174 VPWR 0.13596f
C15830 net106 hold106/a_326_118# 0
C15831 _693_/a_38_114# _302_ 0
C15832 _128_ hold70/a_438_182# 0.00749f
C15833 _045_ _059_ 0
C15834 tx_start FILLER_8_238/a_32_246# 0.00523f
C15835 _100_ _687_/a_1840_334# 0
C15836 _294_ net46 0
C15837 output12/a_40_152# VPWR 0.0726f
C15838 net36 rx_inst.bit_index\[2\] 1.69905f
C15839 _234_ _247_ 0.00249f
C15840 net32 FILLER_17_162/a_32_246# 0
C15841 net30 _649_/a_1583_191# 0.00213f
C15842 _693_/a_550_127# net46 -0
C15843 baud_inst.counter\[6\] _287_ 0
C15844 hold88/a_326_118# _013_ 0
C15845 _240_ _061_ 0.08083f
C15846 _177_ _699_/a_1840_334# 0.00181f
C15847 net53 _698_/a_550_127# 0
C15848 tx_inst.bit_index\[1\] _652_/a_324_432# 0
C15849 _361_/a_146_122# net34 0.00231f
C15850 _636_/a_38_114# hold84/a_438_182# 0
C15851 net146 _375_/a_170_412# 0
C15852 _435_/a_72_436# net25 0
C15853 net3 _391_/a_46_156# 0.0245f
C15854 hold171/a_326_118# tx_inst.data_reg\[7\] 0.02558f
C15855 hold88/a_326_118# baud_inst.counter\[14\] 0.00278f
C15856 clknet_0_clk _014_ 0.01143f
C15857 _643_/a_324_432# _060_ 0
C15858 _659_/a_298_337# _068_ 0.02105f
C15859 _204_ clknet_4_6_0_clk 0
C15860 _698_/a_741_93# VPWR 0.01407f
C15861 _693_/a_843_236# FILLER_22_22/a_32_246# 0
C15862 hold100/a_326_118# _110_ 0
C15863 hold100/a_56_118# net142 0
C15864 clknet_4_4_0_clk net172 0
C15865 net81 net80 0.1582f
C15866 hold96/a_56_118# net96 0
C15867 _246_ clknet_4_12_0_clk 0
C15868 net49 fanout48/a_40_152# 0.02828f
C15869 _644_/a_298_337# _232_ 0
C15870 hold127/a_326_118# VPWR 0.01664f
C15871 _432_/a_248_122# net37 0
C15872 net37 _157_ 0.0184f
C15873 _154_ _649_/a_324_432# 0.03215f
C15874 _178_ _699_/a_132_114# 0
C15875 baud_inst.counter\[3\] _674_/a_1840_334# 0.00224f
C15876 _463_/a_22_110# _648_/a_1583_191# 0
C15877 hold137/a_438_182# tx_inst.data_reg\[5\] 0.00211f
C15878 net93 _282_ 0.00824f
C15879 hold115/a_56_118# _288_ 0
C15880 _077_ _706_/a_324_432# 0
C15881 net42 hold123/a_56_118# 0
C15882 _354_/a_170_412# net88 0.0025f
C15883 _670_/a_843_236# clknet_4_9_0_clk 0.00789f
C15884 _010_ baud_inst.counter\[10\] 0.17849f
C15885 _292_ _183_ 0.01033f
C15886 hold65/a_438_182# hold70/a_438_182# 0
C15887 net112 _154_ 0
C15888 _535_/a_146_122# _302_ 0
C15889 VPWR _502_/a_279_412# 0
C15890 clknet_4_14_0_clk clknet_0_clk 0.01355f
C15891 baud_inst.counter\[8\] clknet_4_0_0_clk 0.51735f
C15892 _690_/a_298_337# _104_ 0
C15893 _106_ FILLER_24_4/a_40_246# 0.00261f
C15894 _699_/a_843_236# _549_/a_155_412# 0
C15895 _076_ _200_ 0.00122f
C15896 _090_ clknet_0_clk 0.09275f
C15897 _644_/a_2002_114# VPWR 0
C15898 _175_ tx_inst.data_reg\[2\] 0.00286f
C15899 net128 _685_/a_1840_334# 0
C15900 _650_/a_2250_412# net19 0.04638f
C15901 _168_ FILLER_16_203/a_32_246# 0
C15902 net155 tx_inst.data_reg\[1\] 0.02962f
C15903 _240_ _433_/a_142_412# 0
C15904 hold145/a_438_182# _339_/a_886_118# 0
C15905 net37 _671_/a_2250_412# 0
C15906 _313_ net68 0.0855f
C15907 _086_ _085_ 0
C15908 _341_/a_295_385# VPWR 0.00102f
C15909 _694_/a_550_127# clknet_4_10_0_clk 0
C15910 _491_/a_435_412# _033_ 0.00217f
C15911 net60 hold61/a_56_118# 0
C15912 hold146/a_438_182# net27 0
C15913 net16 hold118/a_326_118# 0
C15914 rx_data[4] hold118/a_56_118# 0
C15915 _031_ _701_/a_2250_412# 0
C15916 net56 _142_ 0.54965f
C15917 net23 _705_/a_1583_191# 0
C15918 baud_inst.counter\[25\] baud_inst.counter\[24\] 1.93112f
C15919 net99 _309_ 0
C15920 _311_ net140 0.00676f
C15921 _064_ FILLER_8_116/a_40_246# 0.01158f
C15922 net44 hold104/a_438_182# 0.00444f
C15923 output13/a_40_152# _272_ 0
C15924 net42 net56 0
C15925 _653_/a_38_114# _063_ 0.00251f
C15926 _080_ fanout43/a_40_152# 0
C15927 output12/a_40_152# _127_ 0
C15928 _645_/a_1489_191# VPWR -0
C15929 _660_/a_1840_334# net41 0
C15930 _073_ FILLER_7_210/a_40_246# 0.00511f
C15931 baud_inst.counter\[26\] _698_/a_612_127# 0
C15932 hold98/a_326_118# FILLER_11_32/a_32_246# 0
C15933 tx_inst.bit_index\[2\] _141_ 0
C15934 net98 _689_/a_843_236# 0
C15935 _248_ net139 0
C15936 _152_ clknet_0_clk 0.00215f
C15937 net178 hold109/a_326_118# 0
C15938 rx_inst.state\[1\] hold81/a_438_182# 0
C15939 net28 _277_ 0.22977f
C15940 hold147/a_438_182# _692_/a_1583_191# 0
C15941 FILLER_28_176/a_32_246# hold131/a_438_182# 0
C15942 hold147/a_326_118# _692_/a_1840_334# 0
C15943 hold147/a_56_118# _692_/a_2250_412# 0
C15944 FILLER_5_164/a_40_246# net34 0.0191f
C15945 net57 _651_/a_843_236# 0
C15946 net51 _668_/a_681_505# 0
C15947 _707_/a_741_93# rx_inst.state\[1\] 0.0032f
C15948 baud_inst.counter\[16\] _523_/a_155_412# 0.00618f
C15949 net44 _531_/a_474_130# 0
C15950 net55 _656_/a_38_114# 0.00621f
C15951 tx_inst.data_reg\[2\] net165 0
C15952 _506_/a_155_412# net115 0.00127f
C15953 _292_ _189_ 0.06689f
C15954 _231_ rx_inst.state\[3\] 0
C15955 hold163/a_438_182# _164_ 0
C15956 net48 fanout47/a_40_152# 0.02784f
C15957 FILLER_23_204/a_40_246# _649_/a_843_236# 0
C15958 net35 _154_ 0.02083f
C15959 tx_inst.bit_index\[1\] _221_ 0
C15960 _671_/a_1583_191# _650_/a_324_432# 0
C15961 _671_/a_2250_412# _650_/a_298_337# 0
C15962 _160_ _649_/a_324_432# 0
C15963 _661_/a_1489_191# FILLER_0_128/a_40_246# 0
C15964 hold129/a_326_118# _180_ 0.05095f
C15965 clknet_4_8_0_clk _300_ 0
C15966 rx_inst.data_reg\[2\] FILLER_29_179/a_40_246# 0.00123f
C15967 _413_/a_170_412# VPWR 0
C15968 FILLER_5_59/a_40_246# clknet_0_clk 0
C15969 VPWR net83 0.08805f
C15970 net106 _314_ 0.51303f
C15971 FILLER_0_154/a_40_246# FILLER_0_156/a_32_246# 0.0524f
C15972 VPWR _681_/a_2002_114# 0
C15973 _204_ net29 0
C15974 FILLER_18_160/a_32_246# _249_ 0
C15975 _313_ _701_/a_324_432# 0
C15976 tx_inst.data_reg\[6\] _206_ 1.90178f
C15977 _360_/a_382_118# tx_inst.bit_index\[1\] 0
C15978 _360_/a_1453_124# net184 0.02608f
C15979 net85 clkbuf_4_13_0_clk/a_27_118# 0.05458f
C15980 input10/a_40_152# net38 0.00416f
C15981 hold184/a_56_118# clknet_0_clk 0
C15982 _292_ net115 0
C15983 _677_/a_2250_412# net137 0
C15984 _009_ _290_ 0
C15985 net177 baud_inst.counter\[16\] 0
C15986 net90 clknet_4_9_0_clk 0.05617f
C15987 hold74/a_56_118# _270_ 0
C15988 _126_ _468_/a_22_110# 0.05598f
C15989 _696_/a_2002_114# net46 0
C15990 rx_inst.bit_index\[1\] net175 0.42055f
C15991 _055_ clkbuf_4_14_0_clk/a_27_118# 0
C15992 _424_/a_244_140# VPWR 0
C15993 _152_ _077_ 0
C15994 _090_ _182_ 1.22044f
C15995 net173 fanout34/a_40_152# 0
C15996 net112 _160_ 0
C15997 _659_/a_132_114# clknet_4_1_0_clk 0
C15998 _233_ _247_ 0
C15999 net31 _434_/a_150_412# 0.0087f
C16000 _230_ _428_/a_150_412# 0
C16001 FILLER_0_174/a_32_246# _380_/a_382_118# 0.01107f
C16002 net28 _482_/a_154_118# 0.00122f
C16003 hold165/a_438_182# net3 0
C16004 output20/a_40_152# _705_/a_1583_191# 0
C16005 net39 _685_/a_2250_412# 0
C16006 _643_/a_741_93# _649_/a_324_432# 0
C16007 net39 FILLER_11_32/a_32_246# 0.0178f
C16008 _704_/a_324_432# FILLER_13_228/a_40_246# 0
C16009 net113 net46 0.10216f
C16010 clknet_4_3_0_clk _677_/a_2002_114# 0
C16011 net39 _689_/a_2250_412# 0.00691f
C16012 _662_/a_38_114# tx_inst.data_reg\[0\] 0.00548f
C16013 _690_/a_2250_412# _014_ 0
C16014 _431_/a_81_118# _224_ 0.00139f
C16015 VPWR _649_/a_1489_191# 0
C16016 _656_/a_38_114# _067_ 0.00347f
C16017 _192_ FILLER_6_189/a_40_246# 0
C16018 _195_ _274_ 0.00105f
C16019 net122 _374_/a_550_140# 0
C16020 net37 _374_/a_244_140# 0
C16021 hold129/a_438_182# _292_ 0
C16022 _241_ _140_ 0.00124f
C16023 _663_/a_324_432# _075_ 0.00284f
C16024 _663_/a_298_337# clknet_4_7_0_clk 0.00141f
C16025 _035_ net40 0.3859f
C16026 hold162/a_326_118# net162 0.00135f
C16027 _536_/a_435_412# net120 0.00296f
C16028 _073_ _664_/a_1583_191# 0.00486f
C16029 _695_/a_741_93# _108_ 0
C16030 _552_/a_155_412# _701_/a_741_93# 0
C16031 _705_/a_1840_334# net22 0.01301f
C16032 rx_data[7] _650_/a_1840_334# 0
C16033 _163_ _684_/a_2002_114# 0
C16034 net94 net93 0
C16035 _285_ hold95/a_438_182# 0.00184f
C16036 _091_ net153 0
C16037 FILLER_12_171/a_40_246# clkbuf_4_6_0_clk/a_27_118# 0.00459f
C16038 FILLER_29_221/a_32_246# _634_/a_741_93# 0
C16039 _424_/a_244_140# _239_ 0
C16040 net112 hold144/a_326_118# 0
C16041 _286_ hold95/a_56_118# 0
C16042 net35 fanout36/a_40_152# 0
C16043 _288_ net38 0.00149f
C16044 _651_/a_38_114# net183 0.0025f
C16045 _041_ fanout43/a_40_152# 0
C16046 _677_/a_1583_191# baud_inst.counter\[5\] 0.00348f
C16047 net51 _667_/a_741_93# 0
C16048 net58 _699_/a_843_236# 0
C16049 hold86/a_326_118# _673_/a_324_432# 0
C16050 tx_inst.bit_index\[1\] net9 0
C16051 net20 _050_ 0
C16052 _679_/a_843_236# _287_ 0
C16053 net50 clkbuf_4_5_0_clk/a_27_118# 0
C16054 _228_ net62 0.04034f
C16055 FILLER_13_228/a_40_246# net19 0.03551f
C16056 _487_/a_146_122# net43 0
C16057 clknet_0_clk rx_inst.state\[4\] 0.08322f
C16058 net49 _241_ 0.01564f
C16059 clkbuf_4_12_0_clk/a_27_118# _436_/a_142_412# 0
C16060 net49 FILLER_25_163/a_32_246# 0.00228f
C16061 _218_ clkbuf_4_4_0_clk/a_27_118# 0
C16062 hold108/a_326_118# clknet_4_2_0_clk 0.00193f
C16063 _532_/a_155_412# net46 0.00514f
C16064 _662_/a_612_127# net54 0.00486f
C16065 _290_ _683_/a_38_114# 0.01155f
C16066 hold141/a_438_182# _696_/a_741_93# 0
C16067 _444_/a_142_412# _243_ 0
C16068 _699_/a_1840_334# VPWR 0.00464f
C16069 hold141/a_326_118# _696_/a_843_236# 0
C16070 hold91/a_326_118# net29 0.01669f
C16071 _639_/a_324_432# net19 0.03359f
C16072 _081_ fanout37/a_40_152# 0.00108f
C16073 net166 net26 0.04619f
C16074 net49 net47 0.08568f
C16075 rx_inst.bit_index\[1\] _161_ 0.12814f
C16076 _661_/a_298_337# _148_ 0.00103f
C16077 _674_/a_324_432# VPWR 0.03072f
C16078 hold148/a_56_118# _693_/a_324_432# 0
C16079 rx_data[3] hold73/a_56_118# 0
C16080 _346_/a_354_412# _165_ 0
C16081 hold72/a_438_182# rx_inst.data_reg\[5\] 0.01348f
C16082 _378_/a_382_118# FILLER_0_103/a_32_246# 0
C16083 _672_/a_2250_412# net86 0.00144f
C16084 net45 hold134/a_438_182# 0.01218f
C16085 _663_/a_741_93# _166_ 0.00151f
C16086 _655_/a_681_505# net40 0
C16087 _661_/a_132_114# net38 0
C16088 _686_/a_2250_412# net90 0.01f
C16089 net180 net24 0.00178f
C16090 _493_/a_139_160# _162_ 0.00462f
C16091 _701_/a_2250_412# net46 0.00111f
C16092 _658_/a_843_236# _069_ 0.00355f
C16093 _215_ _393_/a_170_412# 0.00172f
C16094 _695_/a_843_236# net76 0
C16095 _244_ FILLER_26_172/a_40_246# 0
C16096 clknet_4_5_0_clk _479_/a_22_110# 0.00448f
C16097 _677_/a_298_337# clknet_0_clk 0.04207f
C16098 _270_ _647_/a_1840_334# 0.002f
C16099 net83 _266_ 0
C16100 _442_/a_350_122# _255_ -0
C16101 _639_/a_741_93# hold51/a_56_118# 0.00106f
C16102 _639_/a_324_432# hold51/a_326_118# 0
C16103 FILLER_14_202/a_40_246# _153_ 0.02352f
C16104 net168 _666_/a_132_114# 0
C16105 net172 _666_/a_1583_191# 0
C16106 net177 _684_/a_1583_191# 0.00268f
C16107 FILLER_16_166/a_32_246# _223_ 0
C16108 hold104/a_438_182# _302_ 0.01963f
C16109 hold104/a_326_118# _164_ 0.01472f
C16110 hold89/a_326_118# _163_ 0
C16111 net104 _530_/a_155_412# 0
C16112 _230_ FILLER_21_147/a_40_246# 0
C16113 _678_/a_38_114# VPWR 0.00162f
C16114 _152_ hold146/a_56_118# 0
C16115 _412_/a_120_432# _205_ 0
C16116 _115_ _700_/a_298_337# 0.00157f
C16117 _688_/a_1840_334# net40 0.00415f
C16118 baud_inst.counter\[19\] _528_/a_81_118# 0.0079f
C16119 _163_ baud_inst.counter\[13\] 1.36108f
C16120 _696_/a_2250_412# clknet_0_clk 0.00454f
C16121 net45 _051_ 0.76321f
C16122 _275_ _478_/a_27_156# 0.02521f
C16123 _188_ _684_/a_298_337# 0
C16124 clknet_4_13_0_clk clknet_4_15_0_clk 0.00529f
C16125 _659_/a_2250_412# net41 0
C16126 hold158/a_326_118# clknet_4_2_0_clk 0
C16127 hold105/a_326_118# _313_ 0
C16128 _693_/a_1840_334# _302_ 0
C16129 FILLER_15_162/a_40_246# net51 0.00185f
C16130 output16/a_40_152# VPWR 0.04994f
C16131 _632_/a_681_505# _273_ 0
C16132 _254_ _154_ 0
C16133 hold64/a_56_118# VPWR 0.00713f
C16134 _310_ net162 0.01381f
C16135 _080_ _041_ 0.00918f
C16136 _304_ net149 0.00989f
C16137 net163 _530_/a_257_140# 0
C16138 _531_/a_474_130# _302_ 0.00348f
C16139 hold142/a_438_182# _111_ 0
C16140 net31 net28 0
C16141 _153_ net62 0
C16142 net118 _168_ 0
C16143 VPWR net77 0.12679f
C16144 _547_/a_379_118# clknet_0_clk 0
C16145 tx_inst.bit_index\[1\] _652_/a_2250_412# 0.00378f
C16146 _636_/a_298_337# _264_ 0
C16147 net13 _271_ 0
C16148 _031_ baud_inst.counter\[29\] 0.06976f
C16149 tx_inst.data_reg\[6\] _341_/a_886_118# 0.11869f
C16150 _295_ baud_inst.counter\[14\] 0.02225f
C16151 _171_ _664_/a_298_337# 0
C16152 _678_/a_324_432# hold93/a_56_118# 0.00352f
C16153 FILLER_15_17/a_40_246# baud_inst.counter\[18\] 0.00127f
C16154 _696_/a_843_236# baud_inst.counter\[14\] 0
C16155 hold126/a_326_118# net70 0.00157f
C16156 _655_/a_741_93# input10/a_40_152# 0
C16157 _659_/a_132_114# _147_ 0
C16158 clknet_4_1_0_clk _211_ 0.02518f
C16159 _659_/a_843_236# tx_inst.data_reg\[3\] 0
C16160 _698_/a_1785_429# VPWR 0
C16161 _654_/a_324_432# _071_ 0
C16162 _654_/a_741_93# net41 0
C16163 _464_/a_22_110# _124_ 0
C16164 _634_/a_324_432# hold83/a_326_118# 0
C16165 _634_/a_38_114# hold83/a_438_182# 0
C16166 FILLER_22_152/a_32_246# _161_ 0.00142f
C16167 net158 net160 0
C16168 clknet_4_1_0_clk _282_ 0
C16169 tx_inst.data_reg\[3\] net43 0
C16170 VPWR _439_/a_354_412# 0
C16171 _178_ _699_/a_1489_191# 0.0102f
C16172 _183_ _289_ 0.00763f
C16173 _508_/a_209_168# net29 0
C16174 net71 _648_/a_2250_412# 0
C16175 _154_ _649_/a_2250_412# 0.03868f
C16176 hold66/a_438_182# net64 0.0053f
C16177 _661_/a_38_114# _210_ 0.0053f
C16178 net41 _664_/a_1583_191# 0
C16179 net157 baud_inst.counter\[16\] 0.0259f
C16180 _170_ _436_/a_244_412# 0.00509f
C16181 clknet_4_14_0_clk _048_ 0
C16182 _313_ net113 0
C16183 output15/a_40_152# rx_data[3] 0
C16184 net65 clknet_4_15_0_clk 0.22243f
C16185 rx_data[7] _639_/a_38_114# 0.00132f
C16186 _042_ FILLER_4_237/a_40_246# 0.0037f
C16187 output21/a_40_152# _665_/a_843_236# 0
C16188 _489_/a_358_436# _087_ 0
C16189 hold163/a_326_118# _692_/a_1840_334# 0
C16190 hold163/a_56_118# _692_/a_2250_412# 0
C16191 hold163/a_438_182# _692_/a_1583_191# 0
C16192 baud_inst.counter\[20\] _692_/a_843_236# 0.00538f
C16193 tx_inst.state\[4\] _171_ 0
C16194 _670_/a_612_127# clknet_4_9_0_clk 0.00178f
C16195 _154_ _420_/a_248_122# 0
C16196 _677_/a_298_337# _182_ 0.01503f
C16197 _205_ _670_/a_1489_191# 0
C16198 FILLER_17_160/a_40_246# _249_ 0
C16199 output21/a_40_152# _166_ 0
C16200 _414_/a_165_412# _234_ 0
C16201 net103 _687_/a_550_127# 0
C16202 _644_/a_324_432# net47 0
C16203 rx_inst.state\[2\] _223_ 0
C16204 _661_/a_1840_334# tx_data[2] 0
C16205 _192_ _664_/a_324_432# 0.00219f
C16206 _009_ net108 0
C16207 hold80/a_438_182# net80 0.00839f
C16208 baud_inst.counter\[14\] clknet_4_2_0_clk 0
C16209 _699_/a_843_236# _027_ 0.02455f
C16210 _302_ FILLER_24_19/a_40_246# 0
C16211 tx_inst.data_reg\[7\] hold155/a_56_118# 0.02872f
C16212 hold74/a_56_118# _265_ 0
C16213 fanout36/a_40_152# _254_ 0
C16214 _658_/a_843_236# clknet_4_4_0_clk 0.01071f
C16215 _266_ _470_/a_22_110# 0.00394f
C16216 _073_ hold172/a_326_118# 0
C16217 net44 hold176/a_326_118# 0
C16218 net26 _671_/a_324_432# 0.01719f
C16219 net23 net33 0
C16220 net177 FILLER_16_56/a_32_246# 0
C16221 _240_ _156_ 0.04204f
C16222 _650_/a_1583_191# _157_ 0
C16223 _307_ _024_ 0
C16224 clknet_4_8_0_clk net160 0
C16225 FILLER_5_74/a_32_246# clkbuf_4_0_0_clk/a_27_118# 0.00571f
C16226 net145 _339_/a_308_118# 0
C16227 _676_/a_681_505# clknet_0_clk 0
C16228 _704_/a_324_432# hold50/a_326_118# 0
C16229 _704_/a_38_114# hold50/a_438_182# 0
C16230 net177 _356_/a_146_122# 0.00148f
C16231 _341_/a_500_118# VPWR 0
C16232 net97 clknet_4_2_0_clk 0.57814f
C16233 _645_/a_38_114# net47 0
C16234 net124 net71 0.03726f
C16235 clknet_4_14_0_clk FILLER_26_172/a_40_246# 0.00641f
C16236 _660_/a_1489_191# _392_/a_59_156# 0
C16237 tx_inst.bit_index\[2\] _197_ 0
C16238 baud_inst.counter\[8\] _350_/a_279_412# 0.00187f
C16239 _396_/a_155_412# net27 0
C16240 net23 _705_/a_2002_114# 0
C16241 tx_done _705_/a_1489_191# 0
C16242 net32 _671_/a_324_432# 0
C16243 output12/a_40_152# _461_/a_22_110# 0.02665f
C16244 output17/a_40_152# VPWR 0.08856f
C16245 _672_/a_38_114# _085_ 0.02017f
C16246 _672_/a_324_432# net38 0.00287f
C16247 hold172/a_56_118# _275_ 0.07916f
C16248 rx_inst.data_reg\[2\] VPWR 0.12503f
C16249 net41 net38 0.00185f
C16250 _095_ _689_/a_843_236# 0
C16251 net25 _647_/a_38_114# 0
C16252 _699_/a_298_337# net45 0.01756f
C16253 hold167/a_56_118# fanout26/a_40_152# 0.02752f
C16254 net51 _668_/a_550_127# 0
C16255 _264_ net19 0.00978f
C16256 hold176/a_56_118# clknet_0_clk 0.00686f
C16257 net57 _651_/a_612_127# 0.00108f
C16258 net42 FILLER_12_173/a_32_246# 0
C16259 baud_inst.counter\[16\] _298_ 0.05011f
C16260 _644_/a_741_93# net49 0
C16261 _381_/a_46_156# _209_ 0.01736f
C16262 net55 _656_/a_1840_334# 0
C16263 hold174/a_438_182# _480_/a_22_110# 0
C16264 net115 _289_ 0.39468f
C16265 net75 _692_/a_324_432# 0
C16266 _706_/a_38_114# _120_ 0.03596f
C16267 _706_/a_324_432# net43 0.032f
C16268 _671_/a_741_93# hold62/a_56_118# 0
C16269 _671_/a_38_114# hold62/a_438_182# 0
C16270 _643_/a_324_432# _257_ 0
C16271 net55 _705_/a_1489_191# 0
C16272 hold144/a_56_118# _257_ 0.0065f
C16273 tx_inst.data_reg\[7\] FILLER_0_128/a_40_246# 0
C16274 _689_/a_1489_191# clknet_4_2_0_clk 0.00179f
C16275 tx_busy _705_/a_324_432# 0
C16276 _073_ FILLER_5_207/a_32_246# 0
C16277 output16/a_40_152# _266_ 0.02408f
C16278 _313_ _701_/a_2250_412# 0.00153f
C16279 _360_/a_1377_160# net184 0.00298f
C16280 _673_/a_38_114# _145_ 0.00112f
C16281 clknet_4_1_0_clk _655_/a_298_337# 0.01457f
C16282 hold57/a_56_118# _195_ 0
C16283 net74 _125_ 0.07971f
C16284 hold131/a_56_118# net131 0
C16285 net30 _272_ 0.0016f
C16286 _266_ net77 0.06525f
C16287 _645_/a_324_432# net49 0.02696f
C16288 net69 _637_/a_1840_334# 0
C16289 _537_/a_341_118# hold148/a_56_118# 0
C16290 net97 _683_/a_298_337# 0
C16291 net108 _683_/a_38_114# 0.03863f
C16292 net123 _670_/a_38_114# 0.0384f
C16293 hold123/a_56_118# _670_/a_1583_191# 0
C16294 net55 _382_/a_382_118# 0
C16295 net153 _281_ 0
C16296 _659_/a_1489_191# clknet_4_1_0_clk 0.00326f
C16297 FILLER_8_92/a_32_246# _036_ 0.02726f
C16298 _188_ baud_inst.counter\[16\] 0.47653f
C16299 net47 _649_/a_38_114# 0
C16300 _054_ _649_/a_298_337# 0
C16301 _191_ _670_/a_324_432# 0.00518f
C16302 _643_/a_1840_334# _649_/a_843_236# 0
C16303 baud_inst.counter\[28\] _553_/a_170_412# 0
C16304 _307_ _695_/a_843_236# 0
C16305 VPWR rx_inst.data_reg\[6\] 0.19944f
C16306 VPWR _632_/a_324_432# 0.00426f
C16307 FILLER_8_189/a_40_246# _215_ 0
C16308 _679_/a_38_114# _182_ 0.03609f
C16309 _424_/a_142_412# _236_ 0
C16310 net122 _204_ 0.26441f
C16311 clknet_4_12_0_clk FILLER_18_160/a_32_246# 0
C16312 net94 clknet_4_1_0_clk 0.0016f
C16313 _663_/a_1583_191# clknet_4_7_0_clk 0.00313f
C16314 _081_ clkbuf_4_6_0_clk/a_27_118# 0
C16315 net120 _022_ 0.01593f
C16316 _088_ net61 0.08306f
C16317 _073_ _664_/a_2002_114# 0
C16318 _315_ _701_/a_741_93# 0
C16319 net49 _443_/a_252_412# 0
C16320 _547_/a_81_118# _546_/a_192_429# 0.02457f
C16321 _174_ FILLER_1_173/a_32_246# 0
C16322 clknet_0_clk net168 0.00595f
C16323 hold130/a_438_182# baud_inst.counter\[12\] 0
C16324 hold130/a_326_118# net128 0.00196f
C16325 clkbuf_4_12_0_clk/a_27_118# _259_ 0
C16326 _652_/a_550_127# _063_ 0
C16327 VPWR _668_/a_298_337# 0.00163f
C16328 net28 _404_/a_46_156# 0.00348f
C16329 hold58/a_438_182# _702_/a_2250_412# 0
C16330 _147_ _211_ 0.20472f
C16331 FILLER_0_109/a_32_246# net38 0
C16332 net71 FILLER_26_227/a_40_246# 0.01243f
C16333 net46 baud_inst.counter\[29\] 0.12644f
C16334 baud_inst.counter\[20\] _534_/a_46_156# 0.01288f
C16335 _694_/a_298_337# _106_ 0
C16336 input6/a_40_152# tx_data[3] 0.03141f
C16337 hold105/a_56_118# _700_/a_298_337# 0
C16338 _198_ _042_ 0
C16339 FILLER_8_63/a_40_246# net29 0
C16340 baud_inst.counter\[30\] _702_/a_298_337# 0
C16341 baud_inst.counter\[28\] _702_/a_324_432# 0.02214f
C16342 _429_/a_550_140# _648_/a_38_114# 0
C16343 FILLER_24_133/a_32_246# _242_ 0
C16344 net45 _698_/a_324_432# 0.05443f
C16345 _111_ _698_/a_38_114# 0.004f
C16346 _376_/a_76_160# net27 0.04421f
C16347 _677_/a_2002_114# baud_inst.counter\[5\] 0
C16348 net50 _704_/a_843_236# 0
C16349 _414_/a_165_412# _233_ 0.00409f
C16350 _268_ hold70/a_438_182# 0
C16351 _032_ _699_/a_2250_412# 0
C16352 net81 _121_ 0
C16353 _448_/a_244_412# net25 0
C16354 _457_/a_22_110# _264_ 0.02404f
C16355 VPWR _380_/a_59_156# 0.01194f
C16356 _679_/a_550_127# net135 0
C16357 _679_/a_612_127# _287_ 0.00908f
C16358 hold182/a_56_118# VPWR 0.00462f
C16359 net18 _634_/a_843_236# 0
C16360 _635_/a_324_432# net64 0.01404f
C16361 rx_inst.state\[2\] _261_ 0.00555f
C16362 tx_data[4] FILLER_0_103/a_32_246# 0
C16363 hold161/a_438_182# net156 0
C16364 _152_ net43 0.07924f
C16365 _246_ _449_/a_27_156# 0.00774f
C16366 clkbuf_4_12_0_clk/a_27_118# _157_ 0
C16367 _469_/a_22_110# net30 0.00168f
C16368 net147 _303_ 1.79297f
C16369 _672_/a_324_432# FILLER_0_42/a_32_246# 0
C16370 _194_ net183 0
C16371 _303_ net46 0.39114f
C16372 _020_ _692_/a_38_114# 0.00219f
C16373 net163 _692_/a_741_93# 0.00135f
C16374 _694_/a_681_505# VPWR 0.00153f
C16375 _073_ net54 0.04309f
C16376 _639_/a_1583_191# _707_/a_38_114# 0
C16377 _082_ _002_ 0.00148f
C16378 net44 net167 0.03606f
C16379 _159_ _243_ 0
C16380 _639_/a_2250_412# net19 0.01324f
C16381 _644_/a_324_432# _644_/a_741_93# 0
C16382 FILLER_24_218/a_40_246# _638_/a_38_114# 0
C16383 hold111/a_56_118# _122_ 0.00898f
C16384 _382_/a_59_156# _149_ 0.00166f
C16385 _170_ net48 0.32133f
C16386 rx_inst.bit_index\[2\] _155_ 0
C16387 _207_ _381_/a_46_156# 0.00184f
C16388 tx_inst.data_reg\[7\] _387_/a_46_156# 0.00111f
C16389 hold98/a_438_182# hold117/a_326_118# 0.00196f
C16390 _102_ _689_/a_843_236# 0.00137f
C16391 VPWR clknet_4_6_0_clk 1.161f
C16392 _674_/a_2250_412# VPWR 0.00904f
C16393 _467_/a_22_110# VPWR -0
C16394 tx_inst.data_reg\[4\] net165 1.89768f
C16395 _058_ _264_ 0
C16396 _179_ _165_ 0.00211f
C16397 net20 hold80/a_326_118# 0.00105f
C16398 rx_done hold80/a_56_118# 0.00162f
C16399 _206_ FILLER_0_103/a_32_246# 0.00489f
C16400 _662_/a_843_236# VPWR 0.00935f
C16401 _638_/a_38_114# _632_/a_298_337# 0
C16402 _638_/a_298_337# _632_/a_38_114# 0
C16403 hold96/a_438_182# _287_ 0.01217f
C16404 net50 _707_/a_38_114# 0
C16405 _663_/a_1785_429# _166_ 0
C16406 net3 tx_inst.data_reg\[0\] 0
C16407 _655_/a_550_127# net40 0
C16408 tx_start _705_/a_2250_412# 0
C16409 _228_ rx_inst.state\[3\] 0.00164f
C16410 _127_ rx_inst.data_reg\[6\] 0.00291f
C16411 FILLER_8_171/a_32_246# VPWR 0.08427f
C16412 net53 _640_/a_324_432# 0.01072f
C16413 hold53/a_56_118# _640_/a_1840_334# 0
C16414 _281_ _280_ 0.46427f
C16415 _191_ _667_/a_612_127# 0
C16416 clknet_4_7_0_clk net2 0.03453f
C16417 hold75/a_56_118# _313_ 0
C16418 _658_/a_612_127# _069_ 0
C16419 _218_ VPWR 0.01272f
C16420 hold130/a_438_182# net39 0
C16421 _537_/a_192_429# net148 0.0165f
C16422 _695_/a_612_127# net76 0.00102f
C16423 _645_/a_741_93# _644_/a_38_114# 0
C16424 _645_/a_324_432# _644_/a_324_432# 0
C16425 hold121/a_326_118# net49 0.04436f
C16426 _673_/a_324_432# VPWR 0.01652f
C16427 baud_inst.counter\[8\] _096_ 0
C16428 net26 clknet_4_9_0_clk 0
C16429 clkbuf_4_2_0_clk/a_27_118# clknet_4_2_0_clk 0.06862f
C16430 _002_ clknet_0_clk 0
C16431 _091_ _655_/a_612_127# 0
C16432 tx clknet_4_7_0_clk 0.00204f
C16433 _138_ hold127/a_326_118# 0
C16434 net177 _684_/a_2002_114# 0
C16435 net104 _018_ 0.08722f
C16436 hold55/a_438_182# _077_ 0
C16437 _674_/a_298_337# _181_ 0
C16438 _678_/a_1840_334# VPWR 0.00202f
C16439 _231_ _205_ 0.09862f
C16440 hold104/a_56_118# _103_ 0.00292f
C16441 _115_ _700_/a_1583_191# 0.01626f
C16442 net120 _108_ 0
C16443 _206_ FILLER_4_102/a_32_246# 0.0015f
C16444 tx_inst.state\[4\] net146 0.10538f
C16445 _307_ baud_inst.counter\[25\] 0
C16446 _232_ hold127/a_326_118# 0.0238f
C16447 FILLER_25_7/a_40_246# _106_ 0
C16448 _133_ hold127/a_56_118# 0
C16449 hold108/a_56_118# _683_/a_1840_334# 0
C16450 hold108/a_326_118# _683_/a_1583_191# 0
C16451 _206_ _384_/a_59_156# 0.01191f
C16452 _060_ _649_/a_298_337# 0.0214f
C16453 _632_/a_1489_191# net64 0
C16454 net32 _259_ 0
C16455 _678_/a_741_93# _036_ 0.00166f
C16456 FILLER_15_173/a_40_246# _223_ 0.00103f
C16457 _269_ _636_/a_298_337# 0
C16458 net73 _636_/a_38_114# 0
C16459 _687_/a_38_114# _296_ 0.00226f
C16460 rx_inst.bit_index\[1\] FILLER_18_148/a_40_246# 0.02018f
C16461 _266_ rx_inst.data_reg\[6\] 0.37722f
C16462 _632_/a_741_93# net30 0.01948f
C16463 _632_/a_324_432# _266_ 0.00394f
C16464 rx_inst.state\[2\] _452_/a_257_140# 0.00126f
C16465 FILLER_14_202/a_40_246# net28 0
C16466 net35 net49 0.05688f
C16467 _671_/a_1840_334# clkbuf_4_6_0_clk/a_27_118# 0.00156f
C16468 _636_/a_1583_191# _264_ 0
C16469 net55 _658_/a_1489_191# 0
C16470 _343_/a_155_412# net169 0
C16471 _171_ _664_/a_1583_191# 0
C16472 _278_ _676_/a_2250_412# 0
C16473 _659_/a_612_127# tx_inst.data_reg\[3\] 0
C16474 net178 net40 0.06558f
C16475 _083_ hold123/a_438_182# 0
C16476 _392_/a_382_118# _664_/a_612_127# 0
C16477 _266_ _668_/a_298_337# 0
C16478 _000_ _668_/a_324_432# 0.00152f
C16479 net26 _157_ 0
C16480 _455_/a_257_140# net52 0.00169f
C16481 VPWR _253_ 0.1796f
C16482 net43 rx_inst.state\[4\] 0
C16483 hold86/a_438_182# _086_ 0
C16484 _479_/a_22_110# _199_ 0
C16485 FILLER_11_142/a_40_246# _667_/a_38_114# 0
C16486 hold166/a_326_118# net167 0
C16487 hold166/a_438_182# _002_ 0.00625f
C16488 net166 hold167/a_326_118# 0
C16489 _101_ net101 0
C16490 _215_ net172 0
C16491 net32 _157_ 0
C16492 _432_/a_248_122# net32 0.00423f
C16493 _229_ FILLER_18_158/a_40_246# 0
C16494 _170_ _250_ 0.10127f
C16495 _257_ _224_ 0.02345f
C16496 _536_/a_341_118# net147 0
C16497 _090_ net152 0.40018f
C16498 clkbuf_4_2_0_clk/a_27_118# _683_/a_298_337# 0.00286f
C16499 _688_/a_843_236# net160 0.00293f
C16500 net39 baud_inst.counter\[4\] 0.07516f
C16501 _688_/a_741_93# _296_ 0.00213f
C16502 hold101/a_326_118# baud_inst.counter\[16\] 0
C16503 _315_ hold105/a_438_182# 0.01327f
C16504 _256_ _224_ 0.01735f
C16505 _536_/a_341_118# net46 0.00135f
C16506 input3/a_40_152# VPWR 0.00115f
C16507 FILLER_15_173/a_40_246# _240_ 0.00227f
C16508 rx_data[7] _639_/a_1840_334# 0
C16509 baud_inst.counter\[10\] _287_ 0
C16510 _183_ net135 0.00503f
C16511 tx _665_/a_1583_191# 0
C16512 net28 net62 2.73133f
C16513 _703_/a_324_432# _702_/a_843_236# 0
C16514 baud_inst.counter\[20\] _692_/a_612_127# 0.00114f
C16515 baud_inst.counter\[10\] _509_/a_155_412# 0.0644f
C16516 _677_/a_1583_191# _182_ 0
C16517 _644_/a_2250_412# net47 0
C16518 net36 _418_/a_46_156# 0.01056f
C16519 hold146/a_56_118# net168 0
C16520 hold146/a_326_118# net172 0.00116f
C16521 VPWR net29 1.50808f
C16522 _233_ _234_ 0.01621f
C16523 _191_ _281_ 0.01693f
C16524 net67 clknet_4_11_0_clk 0.19295f
C16525 _099_ _669_/a_843_236# 0
C16526 _313_ baud_inst.counter\[29\] 1.27902f
C16527 net85 clknet_4_12_0_clk 0
C16528 _662_/a_741_93# net179 0.00333f
C16529 _508_/a_380_412# net40 0
C16530 _699_/a_612_127# _027_ 0
C16531 net74 _129_ 0
C16532 _377_/a_268_412# net10 0
C16533 _377_/a_46_156# _207_ 0.00203f
C16534 _680_/a_741_93# _030_ 0
C16535 output20/a_40_152# net23 0.01926f
C16536 rx_inst.data_reg\[7\] hold81/a_326_118# 0
C16537 hold88/a_326_118# _687_/a_843_236# 0
C16538 net48 hold139/a_438_182# 0.05035f
C16539 _021_ _693_/a_843_236# 0.01328f
C16540 _658_/a_612_127# clknet_4_4_0_clk 0.00179f
C16541 _658_/a_1489_191# _067_ 0
C16542 hold86/a_56_118# net79 0.00288f
C16543 net51 _650_/a_843_236# 0
C16544 net177 hold89/a_326_118# 0
C16545 net26 _671_/a_2250_412# 0.0034f
C16546 _180_ _685_/a_298_337# 0
C16547 hold124/a_326_118# net126 0.00268f
C16548 hold77/a_326_118# _158_ 0.00144f
C16549 _674_/a_298_337# _088_ 0.00298f
C16550 baud_inst.counter\[8\] _093_ 0.00187f
C16551 _676_/a_550_127# clknet_0_clk 0
C16552 net177 baud_inst.counter\[13\] 0.03594f
C16553 clknet_4_6_0_clk _266_ 0.12585f
C16554 _467_/a_22_110# _266_ 0
C16555 hold120/a_56_118# _023_ 0.00189f
C16556 net54 net41 1.93316f
C16557 _697_/a_38_114# baud_inst.counter\[25\] 0.00124f
C16558 _697_/a_741_93# net99 0
C16559 hold106/a_326_118# _701_/a_843_236# 0
C16560 hold106/a_438_182# _701_/a_741_93# 0
C16561 rx_data[0] _638_/a_2250_412# 0.007f
C16562 clknet_4_5_0_clk _392_/a_382_118# 0.0031f
C16563 _679_/a_612_127# clkbuf_4_0_0_clk/a_27_118# 0
C16564 _679_/a_1840_334# clknet_0_clk 0.00276f
C16565 _398_/a_115_308# _216_ 0
C16566 tx_done net22 0.00287f
C16567 clknet_4_6_0_clk _167_ 0
C16568 hold93/a_326_118# net29 0
C16569 _356_/a_146_122# _188_ 0
C16570 _267_ _264_ 0.02142f
C16571 clknet_4_12_0_clk FILLER_17_160/a_40_246# 0
C16572 _698_/a_612_127# FILLER_20_106/a_32_246# 0
C16573 _672_/a_2250_412# net38 0
C16574 hold161/a_438_182# hold102/a_56_118# 0
C16575 hold161/a_326_118# hold102/a_326_118# 0.00146f
C16576 hold161/a_56_118# hold102/a_438_182# 0
C16577 _687_/a_298_337# net88 0
C16578 baud_inst.counter\[28\] _112_ 0
C16579 _269_ net19 0
C16580 net182 VPWR 0.16004f
C16581 _695_/a_1583_191# _313_ 0.00251f
C16582 _313_ _542_/a_257_140# 0
C16583 fanout24/a_40_152# _224_ 0
C16584 _699_/a_1583_191# net45 0.01631f
C16585 _697_/a_741_93# clkbuf_4_9_0_clk/a_27_118# 0
C16586 _292_ _685_/a_38_114# 0.02654f
C16587 _305_ _692_/a_1840_334# 0
C16588 net75 _692_/a_2250_412# 0
C16589 _023_ _692_/a_1583_191# 0
C16590 _706_/a_2250_412# net43 0
C16591 _706_/a_1840_334# _120_ 0
C16592 clknet_4_5_0_clk net27 0.11707f
C16593 _671_/a_681_505# rx_inst.state\[4\] 0
C16594 _341_/a_382_118# net9 0
C16595 net55 net22 0.00747f
C16596 net48 _237_ 0
C16597 rx_inst.bit_index\[2\] _427_/a_248_122# 0
C16598 _178_ _114_ 0
C16599 hold169/a_326_118# net169 0
C16600 hold169/a_56_118# _007_ 0.06559f
C16601 _705_/a_741_93# _704_/a_324_432# 0
C16602 _705_/a_324_432# _704_/a_741_93# 0
C16603 net115 net135 0.10562f
C16604 baud_inst.counter\[17\] clknet_4_2_0_clk 0.80521f
C16605 tx_inst.data_reg\[0\] _150_ 0
C16606 net55 net6 0.22822f
C16607 _657_/a_38_114# VPWR 0.0048f
C16608 tx_inst.bit_index\[1\] net184 0
C16609 _696_/a_132_114# clknet_4_8_0_clk 0
C16610 _158_ _633_/a_843_236# 0.00994f
C16611 net37 _421_/a_252_412# 0.00488f
C16612 clknet_4_1_0_clk _655_/a_1583_191# 0.01706f
C16613 _660_/a_132_114# _174_ 0
C16614 FILLER_6_189/a_40_246# net168 0.02022f
C16615 net57 _217_ 0
C16616 hold90/a_56_118# net91 0.00994f
C16617 net90 hold91/a_56_118# 0.01491f
C16618 hold119/a_56_118# VPWR 0.04156f
C16619 FILLER_5_74/a_32_246# net181 0
C16620 baud_inst.counter\[14\] FILLER_14_70/a_40_246# 0
C16621 FILLER_19_77/a_32_246# _547_/a_81_118# 0
C16622 _046_ _632_/a_298_337# 0
C16623 _023_ hold148/a_438_182# 0
C16624 _679_/a_843_236# net181 0
C16625 hold174/a_438_182# hold169/a_438_182# 0
C16626 _291_ _683_/a_843_236# 0
C16627 net108 _683_/a_1840_334# 0.00302f
C16628 hold123/a_326_118# _670_/a_1489_191# 0
C16629 net123 _670_/a_1840_334# 0
C16630 _483_/a_120_432# clknet_0_clk 0.00125f
C16631 hold65/a_326_118# _264_ 0
C16632 net176 _698_/a_324_432# 0
C16633 _352_/a_46_156# baud_inst.counter\[4\] 0
C16634 net47 _649_/a_1840_334# 0.04008f
C16635 _054_ _649_/a_1583_191# 0
C16636 tx_inst.data_reg\[5\] clknet_4_1_0_clk 0
C16637 tx_inst.data_reg\[7\] _659_/a_2250_412# 0
C16638 net157 _016_ 0.4814f
C16639 net16 _647_/a_1583_191# 0
C16640 clknet_4_8_0_clk _547_/a_81_118# 0.00291f
C16641 _661_/a_298_337# _151_ 0.00518f
C16642 _191_ _670_/a_2250_412# 0.04643f
C16643 _082_ _669_/a_298_337# 0.00546f
C16644 net44 _669_/a_38_114# 0.02764f
C16645 hold139/a_438_182# _250_ 0
C16646 hold139/a_56_118# _249_ 0
C16647 rx_inst.bit_index\[1\] _641_/a_1583_191# 0
C16648 _486_/a_115_308# net180 0
C16649 _388_/a_382_118# net5 0
C16650 _388_/a_59_156# _212_ 0.0872f
C16651 _307_ baud_inst.counter\[24\] 0
C16652 VPWR _632_/a_2250_412# 0.00232f
C16653 _073_ _065_ 0
C16654 _656_/a_1489_191# clknet_4_4_0_clk 0.00716f
C16655 _656_/a_550_127# tx_inst.data_reg\[2\] 0
C16656 _679_/a_1840_334# _182_ 0
C16657 hold54/a_438_182# _665_/a_1583_191# 0
C16658 hold54/a_326_118# _665_/a_1840_334# 0
C16659 hold54/a_56_118# _665_/a_2250_412# 0
C16660 _034_ _685_/a_324_432# 0
C16661 net44 FILLER_19_55/a_40_246# 0
C16662 _110_ _696_/a_2250_412# 0.00531f
C16663 net146 FILLER_7_210/a_40_246# 0.00123f
C16664 net39 _688_/a_324_432# 0
C16665 _446_/a_146_122# _043_ 0
C16666 _508_/a_209_168# _288_ 0.02672f
C16667 _227_ _374_/a_244_412# 0
C16668 net49 _254_ 0.02415f
C16669 _078_ FILLER_8_191/a_32_246# 0
C16670 _277_ _223_ 0.00128f
C16671 VPWR _668_/a_1583_191# 0.00591f
C16672 net44 net156 0.00175f
C16673 baud_inst.counter\[3\] _672_/a_38_114# 0.00169f
C16674 _675_/a_324_432# clknet_4_0_0_clk 0.00675f
C16675 _118_ _117_ 0.00353f
C16676 net99 clknet_0_clk 0.15291f
C16677 baud_inst.counter\[30\] _702_/a_1583_191# 0.0192f
C16678 _111_ _698_/a_1840_334# 0
C16679 net45 _698_/a_2250_412# 0.00259f
C16680 clknet_0_clk _669_/a_298_337# 0.00186f
C16681 FILLER_26_227/a_40_246# _273_ 0
C16682 _167_ net29 0
C16683 net73 rx_data[7] 0.04194f
C16684 clk hold145/a_326_118# 0.06213f
C16685 tx_inst.state\[4\] _705_/a_298_337# 0
C16686 net37 net24 0.04427f
C16687 VPWR _648_/a_132_114# 0
C16688 _698_/a_324_432# FILLER_21_96/a_40_246# 0
C16689 clknet_4_3_0_clk net135 0
C16690 net96 _287_ 0.01542f
C16691 _707_/a_1489_191# FILLER_13_228/a_40_246# 0
C16692 _693_/a_324_432# clknet_4_10_0_clk 0.01919f
C16693 clknet_4_5_0_clk _706_/a_298_337# 0.00247f
C16694 _098_ baud_inst.counter\[14\] 0
C16695 _217_ _400_/a_341_118# 0.00623f
C16696 _251_ _252_ 0.00262f
C16697 _314_ _701_/a_843_236# 0.00107f
C16698 net105 _701_/a_1583_191# 0.00111f
C16699 net163 _692_/a_1785_429# 0
C16700 FILLER_24_229/a_32_246# hold65/a_56_118# 0.00404f
C16701 _632_/a_38_114# _049_ 0
C16702 _694_/a_550_127# VPWR 0
C16703 FILLER_12_0/a_32_246# _101_ 0
C16704 FILLER_15_185/a_32_246# net30 0.0019f
C16705 _180_ FILLER_17_94/a_40_246# 0
C16706 clkbuf_4_9_0_clk/a_27_118# clknet_0_clk 0.05199f
C16707 fanout40/a_40_152# net40 0.02591f
C16708 FILLER_17_0/a_40_246# _300_ 0.00137f
C16709 FILLER_18_65/a_40_246# net140 0.00266f
C16710 net44 _180_ 0.03065f
C16711 hold155/a_56_118# _658_/a_298_337# 0
C16712 _677_/a_298_337# net152 0
C16713 hold57/a_438_182# _220_ 0
C16714 hold57/a_326_118# _142_ 0.0124f
C16715 _102_ _689_/a_612_127# 0.00324f
C16716 net26 _475_/a_170_412# 0.00361f
C16717 _379_/a_46_156# _214_ 0
C16718 _235_ _416_/a_248_122# -0
C16719 _638_/a_843_236# _632_/a_843_236# 0.00216f
C16720 net6 _389_/a_46_156# 0
C16721 _662_/a_612_127# VPWR 0.00115f
C16722 clknet_4_11_0_clk _702_/a_681_505# 0
C16723 _075_ _166_ 0.00553f
C16724 hold102/a_56_118# _690_/a_38_114# 0
C16725 _145_ _086_ 0
C16726 tx_inst.data_reg\[7\] net38 0.005f
C16727 net184 hold174/a_56_118# 0.06704f
C16728 _153_ net19 0.26027f
C16729 rx_inst.data_reg\[4\] FILLER_18_210/a_32_246# 0.01568f
C16730 _043_ _632_/a_298_337# 0.00769f
C16731 _191_ net63 0
C16732 _697_/a_38_114# baud_inst.counter\[24\] 0.05936f
C16733 rx_inst.bit_index\[1\] fanout36/a_40_152# 0
C16734 _697_/a_324_432# net140 0
C16735 _305_ net148 0.04001f
C16736 _645_/a_1583_191# _644_/a_843_236# 0.00278f
C16737 _645_/a_1840_334# _644_/a_741_93# 0
C16738 _245_ _424_/a_244_412# 0
C16739 _673_/a_2250_412# VPWR 0.00903f
C16740 clknet_0_clk FILLER_14_148/a_40_246# 0
C16741 _230_ _443_/a_354_412# 0
C16742 _171_ FILLER_5_207/a_32_246# 0
C16743 _050_ hold51/a_56_118# 0
C16744 _640_/a_298_337# VPWR 0.00672f
C16745 _094_ net40 0.00862f
C16746 FILLER_7_82/a_32_246# _679_/a_2250_412# 0
C16747 VPWR hold95/a_438_182# 0.00456f
C16748 _098_ _685_/a_1489_191# 0
C16749 hold119/a_438_182# _000_ 0
C16750 hold119/a_326_118# net30 0.00334f
C16751 _115_ _700_/a_2002_114# 0
C16752 _674_/a_1583_191# _181_ 0.01103f
C16753 _068_ FILLER_7_121/a_40_246# 0
C16754 net48 rx_inst.data_reg\[7\] 0.00281f
C16755 tx_data[2] _388_/a_382_118# 0
C16756 _118_ net11 0
C16757 net128 _035_ 0
C16758 hold66/a_56_118# _638_/a_843_236# 0
C16759 hold108/a_438_182# _683_/a_1489_191# 0
C16760 _120_ net172 0.00332f
C16761 net43 net168 0
C16762 baud_inst.counter\[13\] _684_/a_550_127# 0
C16763 _515_/a_170_160# net90 0
C16764 hold119/a_56_118# _167_ 0.00673f
C16765 hold68/a_326_118# _113_ 0
C16766 hold69/a_438_182# _267_ 0
C16767 clknet_0_clk _434_/a_354_412# 0
C16768 net150 net78 0.13631f
C16769 net93 _499_/a_209_168# 0.00219f
C16770 _269_ _636_/a_1583_191# 0.00743f
C16771 _642_/a_741_93# hold176/a_438_182# 0
C16772 _642_/a_843_236# hold176/a_326_118# 0
C16773 _644_/a_38_114# _256_ 0
C16774 _517_/a_380_412# _180_ 0.00211f
C16775 _677_/a_1583_191# FILLER_10_110/a_40_246# 0.00262f
C16776 _687_/a_1840_334# _296_ 0.00381f
C16777 rx_inst.data_reg\[3\] net84 0
C16778 _673_/a_38_114# net60 0
C16779 _673_/a_298_337# _181_ 0
C16780 FILLER_7_40/a_32_246# _010_ 0
C16781 net163 clknet_4_8_0_clk 0.03414f
C16782 _134_ net24 0.00348f
C16783 _194_ _343_/a_257_140# 0
C16784 _278_ FILLER_11_125/a_32_246# 0
C16785 fanout42/a_40_152# VPWR 0.00322f
C16786 rx_inst.data_reg\[1\] net125 0.00107f
C16787 _481_/a_120_432# _005_ 0.00338f
C16788 FILLER_24_156/a_32_246# VPWR 0.08444f
C16789 net94 hold94/a_438_182# 0.00176f
C16790 _065_ net41 0.01961f
C16791 net172 _664_/a_741_93# 0
C16792 net168 _664_/a_324_432# 0.01344f
C16793 _651_/a_741_93# _084_ 0
C16794 net156 _689_/a_1583_191# 0
C16795 _266_ _668_/a_1583_191# 0.00146f
C16796 _292_ clknet_0_clk 0.22688f
C16797 _126_ rx_data[4] 0.01793f
C16798 net74 net16 0.11377f
C16799 _313_ FILLER_28_53/a_32_246# 0
C16800 hold149/a_326_118# _693_/a_741_93# 0.00125f
C16801 hold149/a_438_182# _693_/a_324_432# 0
C16802 net44 net140 0.0055f
C16803 net145 _653_/a_741_93# 0
C16804 _688_/a_612_127# net160 0.00249f
C16805 output19/a_40_152# clknet_4_13_0_clk 0
C16806 net66 net30 0.10371f
C16807 _133_ _446_/a_248_122# 0
C16808 _071_ FILLER_0_174/a_32_246# 0.00135f
C16809 net129 _358_/a_72_436# 0
C16810 baud_inst.counter\[20\] net164 0.00383f
C16811 baud_inst.counter\[10\] _290_ 0.00406f
C16812 tx_inst.bit_index\[1\] _341_/a_71_118# 0.05196f
C16813 hold55/a_438_182# net43 0
C16814 _676_/a_843_236# baud_inst.counter\[4\] 0.01994f
C16815 net48 _433_/a_550_140# 0
C16816 net30 _648_/a_1583_191# 0.03184f
C16817 _658_/a_843_236# FILLER_3_141/a_40_246# 0
C16818 hold181/a_56_118# baud_inst.counter\[8\] 0
C16819 net27 _005_ 0.01606f
C16820 _427_/a_146_122# _161_ 0
C16821 fanout36/a_40_152# FILLER_22_152/a_32_246# 0
C16822 _195_ _172_ 0.00229f
C16823 hold174/a_438_182# _166_ 0
C16824 _099_ _669_/a_612_127# 0
C16825 _662_/a_1785_429# net179 0
C16826 clknet_0_clk _382_/a_59_156# 0.01568f
C16827 hold167/a_326_118# clknet_4_9_0_clk 0.04615f
C16828 _114_ net133 0
C16829 net114 _027_ -0
C16830 rx_data[7] net118 0.00133f
C16831 _443_/a_150_412# _254_ 0.00362f
C16832 _021_ _693_/a_612_127# 0.02437f
C16833 _282_ _683_/a_741_93# 0.00216f
C16834 _090_ _035_ 0.02426f
C16835 VPWR _493_/a_45_160# 0.00622f
C16836 _637_/a_298_337# clknet_4_15_0_clk 0.00388f
C16837 _555_/a_380_412# VPWR 0
C16838 _392_/a_559_412# _214_ 0.0016f
C16839 _486_/a_358_436# net29 0.00911f
C16840 net148 _020_ 0.00408f
C16841 _548_/a_76_160# net46 0
C16842 tx_data[3] input8/a_40_152# 0.00131f
C16843 input6/a_40_152# tx_data[5] 0.01348f
C16844 net156 _690_/a_1840_334# 0
C16845 net12 _638_/a_1840_334# 0.0128f
C16846 net31 _223_ 0.01361f
C16847 hold150/a_438_182# _123_ 0
C16848 _697_/a_1840_334# baud_inst.counter\[25\] 0.00211f
C16849 VPWR hold70/a_56_118# 0.02129f
C16850 output12/a_40_152# net18 0.02843f
C16851 hold85/a_326_118# VPWR 0.00452f
C16852 _640_/a_1840_334# net24 0
C16853 net12 _043_ 0.00426f
C16854 _390_/a_382_118# clknet_4_1_0_clk 0
C16855 _188_ baud_inst.counter\[13\] 0.01968f
C16856 VPWR FILLER_0_115/a_40_246# 0.12088f
C16857 hold103/a_56_118# _528_/a_81_118# 0
C16858 net122 VPWR 0.18575f
C16859 hold169/a_326_118# _651_/a_2250_412# 0
C16860 _098_ _686_/a_741_93# 0.00156f
C16861 net50 _376_/a_272_160# 0
C16862 net2 _439_/a_150_412# 0
C16863 _192_ _214_ 0.00116f
C16864 _695_/a_2002_114# _313_ 0
C16865 net45 _694_/a_843_236# 0.00343f
C16866 _699_/a_2002_114# net45 0
C16867 _178_ _165_ 0
C16868 _143_ fanout41/a_40_152# 0
C16869 _292_ _182_ 0.01039f
C16870 hold120/a_56_118# _695_/a_324_432# 0
C16871 hold140/a_326_118# clknet_4_9_0_clk 0.00137f
C16872 hold55/a_56_118# net21 0.00224f
C16873 _055_ net49 0.39503f
C16874 _284_ net40 0
C16875 _292_ _685_/a_1840_334# 0
C16876 _228_ _205_ 0
C16877 hold164/a_438_182# net104 0.00152f
C16878 _537_/a_341_118# clknet_4_10_0_clk 0.01209f
C16879 hold110/a_438_182# net97 0.00485f
C16880 _671_/a_550_127# rx_inst.state\[4\] 0
C16881 _519_/a_81_118# _520_/a_155_412# 0
C16882 net31 _240_ 0
C16883 hold150/a_326_118# _159_ 0
C16884 FILLER_17_131/a_32_246# clknet_0_clk 0
C16885 _657_/a_1840_334# VPWR 0.00568f
C16886 output22/a_40_152# net22 0.02572f
C16887 clknet_4_13_0_clk _636_/a_843_236# 0.03273f
C16888 net20 rx_done 0.21082f
C16889 _303_ _692_/a_324_432# 0
C16890 _661_/a_741_93# tx_inst.data_reg\[1\] 0
C16891 _091_ hold93/a_438_182# 0.00183f
C16892 _158_ _633_/a_612_127# 0.00386f
C16893 _660_/a_550_127# _175_ 0
C16894 hold77/a_56_118# clknet_0_clk 0
C16895 hold141/a_56_118# _311_ 0.05133f
C16896 hold141/a_326_118# baud_inst.counter\[25\] 0.00915f
C16897 _504_/a_380_412# _287_ 0
C16898 _705_/a_681_505# net43 0.0012f
C16899 hold164/a_326_118# _020_ 0.05488f
C16900 hold101/a_438_182# FILLER_17_22/a_40_246# 0
C16901 _136_ _433_/a_142_412# 0
C16902 _436_/a_142_412# _137_ 0
C16903 input10/a_40_152# VPWR 0.05414f
C16904 tx_inst.data_reg\[6\] _208_ 0.0149f
C16905 _679_/a_612_127# net181 0
C16906 _291_ _683_/a_612_127# 0
C16907 _004_ clknet_0_clk 0.02204f
C16908 _185_ _282_ 0.0202f
C16909 _060_ hold127/a_438_182# 0.00194f
C16910 _287_ hold60/a_438_182# 0
C16911 net44 _669_/a_1840_334# 0
C16912 _089_ baud_inst.counter\[13\] 0
C16913 _044_ hold131/a_56_118# 0.00895f
C16914 FILLER_21_192/a_40_246# _223_ 0
C16915 _662_/a_324_432# clk 0.00718f
C16916 clknet_4_4_0_clk tx_inst.data_reg\[2\] 0.07131f
C16917 _670_/a_741_93# VPWR 0.03175f
C16918 _240_ clkbuf_4_15_0_clk/a_27_118# 0
C16919 _258_ _043_ 0
C16920 net39 _688_/a_2250_412# 0
C16921 _294_ _293_ 0
C16922 net123 net128 0
C16923 _081_ net118 0
C16924 _044_ net47 0.01929f
C16925 _127_ hold70/a_56_118# 0.00574f
C16926 net27 _199_ 0.04129f
C16927 rx_inst.data_reg\[1\] _245_ 0
C16928 hold135/a_438_182# _287_ 0
C16929 net156 hold158/a_438_182# 0.01315f
C16930 _675_/a_2250_412# clknet_4_0_0_clk 0.00455f
C16931 hold96/a_326_118# net86 0
C16932 hold61/a_438_182# _033_ 0
C16933 hold61/a_326_118# net61 0.00454f
C16934 hold159/a_56_118# net155 0.00272f
C16935 hold159/a_326_118# _206_ 0
C16936 _163_ net29 0
C16937 _528_/a_81_118# baud_inst.counter\[16\] 0.02433f
C16938 _696_/a_1489_191# _686_/a_1840_334# 0
C16939 clknet_4_12_0_clk hold139/a_56_118# 0.00364f
C16940 baud_inst.counter\[30\] _702_/a_2002_114# 0.00143f
C16941 clknet_0_clk _669_/a_1583_191# 0
C16942 net54 _706_/a_843_236# 0.01927f
C16943 _705_/a_741_93# net21 0.00531f
C16944 VPWR _288_ 0.85493f
C16945 hold87/a_56_118# _310_ 0
C16946 _378_/a_59_156# _206_ 0.03145f
C16947 FILLER_12_106/a_40_246# clknet_0_clk 0.00184f
C16948 baud_inst.counter\[1\] clknet_4_1_0_clk 0
C16949 _109_ net90 0
C16950 hold178/a_56_118# net39 0.01427f
C16951 VPWR FILLER_29_198/a_40_246# 0.16777f
C16952 _693_/a_2250_412# clknet_4_10_0_clk 0
C16953 clknet_4_5_0_clk _706_/a_1583_191# 0.00399f
C16954 net173 _398_/a_494_160# 0.0016f
C16955 _241_ net25 0.05315f
C16956 _046_ net84 0
C16957 _444_/a_244_412# _236_ 0
C16958 tx_busy net80 0
C16959 _219_ _221_ 0
C16960 tx_inst.data_reg\[3\] _339_/a_71_118# 0.01458f
C16961 clknet_4_13_0_clk hold81/a_438_182# 0.01156f
C16962 hold85/a_326_118# _266_ 0.0036f
C16963 hold85/a_438_182# net30 0.00831f
C16964 _633_/a_132_114# net78 0
C16965 _314_ _701_/a_612_127# 0.00241f
C16966 net30 hold70/a_326_118# 0.01429f
C16967 _635_/a_681_505# _266_ 0
C16968 hold141/a_438_182# _180_ 0.00738f
C16969 FILLER_13_89/a_40_246# _685_/a_324_432# 0
C16970 _632_/a_1840_334# _049_ 0
C16971 _058_ FILLER_20_177/a_32_246# 0
C16972 _639_/a_843_236# net51 0
C16973 net81 _707_/a_843_236# 0
C16974 clknet_4_13_0_clk _707_/a_741_93# 0
C16975 clkbuf_4_11_0_clk/a_27_118# _703_/a_741_93# 0
C16976 _216_ _666_/a_843_236# 0
C16977 _663_/a_681_505# clknet_4_6_0_clk 0
C16978 hold152/a_56_118# _676_/a_1583_191# 0.00317f
C16979 _513_/a_435_412# net40 0
C16980 net37 net30 0.28786f
C16981 FILLER_19_178/a_40_246# _133_ 0
C16982 _698_/a_324_432# _051_ 0
C16983 _363_/a_22_110# _193_ 0
C16984 _355_/a_354_412# _296_ 0.00123f
C16985 hold121/a_438_182# net121 0
C16986 _644_/a_324_432# _055_ 0.01929f
C16987 _644_/a_38_114# net132 0.02235f
C16988 _660_/a_38_114# _656_/a_2250_412# 0
C16989 _488_/a_209_168# net29 0
C16990 baud_inst.counter\[26\] _112_ 0
C16991 net36 _224_ 0.51476f
C16992 _677_/a_1583_191# net152 0.03725f
C16993 _102_ net158 0.02369f
C16994 VPWR _682_/a_681_505# 0.00167f
C16995 _548_/a_76_160# _313_ 0
C16996 hold171/a_56_118# net55 0.00525f
C16997 hold124/a_56_118# hold126/a_326_118# 0.00494f
C16998 FILLER_27_194/a_40_246# VPWR 0.14118f
C16999 hold116/a_56_118# _183_ 0.01078f
C17000 _073_ VPWR 0.42539f
C17001 hold116/a_326_118# baud_inst.counter\[10\] 0.01423f
C17002 net35 _420_/a_146_122# 0.00153f
C17003 _638_/a_1583_191# _632_/a_1840_334# 0
C17004 _638_/a_1840_334# _632_/a_1583_191# 0
C17005 hold53/a_326_118# _263_ 0.00228f
C17006 clknet_4_11_0_clk _702_/a_550_127# 0
C17007 tx_inst.bit_index\[1\] hold145/a_56_118# 0.00386f
C17008 baud_inst.counter\[28\] _701_/a_298_337# 0.00188f
C17009 _132_ hold175/a_56_118# 0
C17010 net9 _380_/a_382_118# 0
C17011 _483_/a_120_432# net43 0
C17012 _017_ _690_/a_741_93# 0.00133f
C17013 net102 _690_/a_324_432# 0.00348f
C17014 net37 _647_/a_324_432# 0
C17015 _286_ FILLER_5_59/a_40_246# 0
C17016 _404_/a_46_156# _223_ 0
C17017 hold166/a_56_118# _669_/a_2250_412# 0
C17018 _371_/a_170_412# _198_ 0.00382f
C17019 _697_/a_132_114# _309_ 0
C17020 _697_/a_1840_334# baud_inst.counter\[24\] 0
C17021 hold79/a_438_182# _181_ 0
C17022 _661_/a_132_114# VPWR 0
C17023 VPWR _702_/a_38_114# 0
C17024 _645_/a_298_337# net132 0
C17025 _645_/a_38_114# _055_ 0.0254f
C17026 _230_ _257_ 0.02301f
C17027 net108 baud_inst.counter\[10\] 0
C17028 _677_/a_298_337# _035_ 0.0027f
C17029 _677_/a_38_114# net153 0
C17030 rx_inst.data_reg\[4\] _636_/a_741_93# 0
C17031 net138 _636_/a_324_432# 0.00273f
C17032 _230_ _256_ 0.02305f
C17033 _206_ _166_ 0
C17034 hold80/a_56_118# net19 0.01872f
C17035 _640_/a_1583_191# VPWR 0.02388f
C17036 net87 net46 0.00122f
C17037 clknet_4_10_0_clk _104_ 0
C17038 net49 _694_/a_38_114# 0.03346f
C17039 FILLER_0_35/a_40_246# net38 0.02734f
C17040 hold161/a_56_118# _689_/a_298_337# 0
C17041 _650_/a_38_114# _000_ 0.05382f
C17042 _650_/a_298_337# net30 0.03214f
C17043 _691_/a_1489_191# net103 0
C17044 hold131/a_326_118# _272_ 0
C17045 _674_/a_2002_114# _181_ 0
C17046 _232_ _253_ 0
C17047 fanout47/a_40_152# VPWR 0.06848f
C17048 hold76/a_56_118# clknet_4_10_0_clk 0
C17049 baud_inst.counter\[6\] _162_ 0
C17050 FILLER_29_221/a_32_246# _124_ 0
C17051 _151_ _148_ 0.00416f
C17052 _277_ FILLER_12_166/a_40_246# 0.00164f
C17053 _679_/a_741_93# net38 0
C17054 hold171/a_56_118# _067_ 0
C17055 tx_inst.data_reg\[4\] _656_/a_550_127# 0
C17056 _269_ _636_/a_2002_114# 0
C17057 net44 _533_/a_248_122# 0
C17058 net71 _264_ 0.32827f
C17059 _422_/a_248_122# _223_ 0
C17060 _657_/a_550_127# tx_inst.data_reg\[1\] 0
C17061 net94 _185_ 0
C17062 _283_ baud_inst.counter\[6\] 0.07972f
C17063 fanout34/a_40_152# _222_ 0
C17064 _227_ _450_/a_127_96# 0.00141f
C17065 FILLER_21_165/a_40_246# _259_ 0
C17066 _673_/a_1583_191# _181_ 0
C17067 _673_/a_1840_334# net60 0.00832f
C17068 hold160/a_438_182# _690_/a_2250_412# 0
C17069 net55 net8 0.08188f
C17070 net94 clknet_4_0_0_clk 0.00578f
C17071 _651_/a_1840_334# _166_ 0
C17072 _473_/a_120_432# _264_ 0.0044f
C17073 FILLER_9_72/a_32_246# hold95/a_326_118# 0
C17074 _671_/a_1583_191# _153_ 0
C17075 _665_/a_1583_191# _665_/a_2250_412# -0
C17076 _270_ _125_ 0.13292f
C17077 _217_ _653_/a_1583_191# 0
C17078 _248_ FILLER_19_178/a_40_246# 0
C17079 FILLER_26_88/a_40_246# VPWR 0.13585f
C17080 hold141/a_438_182# net140 0.00817f
C17081 hold141/a_326_118# baud_inst.counter\[24\] 0.00153f
C17082 net168 _664_/a_2250_412# 0
C17083 net172 _664_/a_1785_429# 0
C17084 _200_ _664_/a_1840_334# 0.0035f
C17085 _220_ net183 0.93097f
C17086 _278_ clknet_4_3_0_clk 0
C17087 hold156/a_56_118# baud_inst.counter\[17\] 0.10531f
C17088 _355_/a_252_412# net88 0
C17089 _078_ hold56/a_56_118# 0
C17090 baud_inst.counter\[22\] hold103/a_326_118# 0
C17091 net120 _302_ 1.77349f
C17092 _636_/a_324_432# _047_ 0.02813f
C17093 _680_/a_324_432# hold136/a_56_118# 0
C17094 hold116/a_56_118# net115 0.00438f
C17095 _194_ _166_ 0
C17096 input11/a_40_152# tx_start 0.03104f
C17097 hold170/a_326_118# net41 0
C17098 hold170/a_56_118# _071_ 0
C17099 net161 net160 0.00608f
C17100 tx_inst.bit_index\[2\] _221_ 0
C17101 fanout26/a_40_152# _669_/a_2250_412# 0
C17102 hold103/a_438_182# _100_ 0
C17103 _636_/a_1489_191# _156_ 0.00103f
C17104 _703_/a_741_93# _115_ 0
C17105 net59 _702_/a_324_432# 0
C17106 _422_/a_248_122# _240_ 0
C17107 net30 _648_/a_2002_114# 0.00169f
C17108 _266_ _648_/a_1489_191# 0
C17109 tx_inst.bit_index\[1\] _341_/a_1109_431# 0
C17110 net184 _341_/a_382_118# 0.00251f
C17111 _360_/a_382_118# tx_inst.bit_index\[2\] 0.00128f
C17112 _676_/a_612_127# baud_inst.counter\[4\] 0
C17113 net48 _247_ 0.02937f
C17114 _013_ hold129/a_56_118# 0
C17115 _116_ _703_/a_38_114# 0.05899f
C17116 _021_ fanout46/a_40_152# 0.00118f
C17117 FILLER_21_194/a_32_246# net47 0.02171f
C17118 FILLER_3_207/a_40_246# _200_ 0.00831f
C17119 hold135/a_438_182# clkbuf_4_0_0_clk/a_27_118# 0.00191f
C17120 _194_ hold174/a_326_118# 0.00775f
C17121 net42 _663_/a_38_114# 0.02188f
C17122 _046_ _635_/a_741_93# 0
C17123 net51 rx_inst.state\[4\] 0.01043f
C17124 _021_ net149 0.06763f
C17125 tx_inst.data_reg\[1\] _070_ 0.03047f
C17126 net51 net119 0
C17127 _312_ net46 0
C17128 _637_/a_1583_191# clknet_4_15_0_clk 0.00623f
C17129 _681_/a_38_114# net117 0.02001f
C17130 hold89/a_326_118# net89 0.00156f
C17131 _677_/a_38_114# _280_ 0.00364f
C17132 net43 FILLER_14_148/a_40_246# 0.02118f
C17133 _154_ _648_/a_2250_412# 0
C17134 _454_/a_257_140# net24 0.00276f
C17135 rx_inst.bit_index\[1\] net49 0.02339f
C17136 _110_ net99 0
C17137 _289_ _182_ 0
C17138 FILLER_27_194/a_40_246# _266_ 0.00395f
C17139 hold106/a_326_118# net107 0
C17140 _283_ _677_/a_741_93# 0.0043f
C17141 _642_/a_324_432# _669_/a_741_93# 0
C17142 net26 _197_ 0.01857f
C17143 FILLER_14_72/a_32_246# VPWR 0.06563f
C17144 hold68/a_326_118# _700_/a_324_432# 0
C17145 _287_ _349_/a_248_122# 0
C17146 _098_ _686_/a_1785_429# 0
C17147 _672_/a_324_432# VPWR 0.00376f
C17148 net41 VPWR 1.26461f
C17149 _414_/a_279_412# net166 0
C17150 net45 _694_/a_612_127# 0
C17151 _110_ clkbuf_4_9_0_clk/a_27_118# 0
C17152 _658_/a_324_432# net5 0
C17153 _223_ net62 0.04086f
C17154 _653_/a_741_93# _220_ 0
C17155 _653_/a_324_432# _142_ 0.00843f
C17156 _519_/a_81_118# _297_ 0
C17157 hold85/a_438_182# hold74/a_326_118# 0
C17158 hold85/a_326_118# hold74/a_438_182# 0
C17159 _124_ hold83/a_56_118# 0.03151f
C17160 tx_inst.bit_index\[2\] net9 0
C17161 _064_ _653_/a_38_114# 0.02149f
C17162 net42 _653_/a_324_432# 0.00331f
C17163 _047_ hold81/a_56_118# 0
C17164 _181_ net40 0.0445f
C17165 net60 _086_ 0.01896f
C17166 _246_ net2 0
C17167 _160_ _632_/a_550_127# 0
C17168 net27 _365_/a_257_140# 0.00445f
C17169 _678_/a_1840_334# clkbuf_4_1_0_clk/a_27_118# 0
C17170 _155_ net126 0.00146f
C17171 _059_ hold125/a_326_118# 0.03433f
C17172 net124 _154_ 0
C17173 net8 _389_/a_46_156# 0.00866f
C17174 _429_/a_142_412# _244_ 0.00156f
C17175 net183 FILLER_6_151/a_40_246# 0
C17176 _099_ _685_/a_38_114# 0
C17177 net46 _685_/a_324_432# 0.00258f
C17178 _158_ net78 0.00239f
C17179 _202_ _166_ 0
C17180 net96 net108 0
C17181 _688_/a_1489_191# clknet_4_2_0_clk 0.00182f
C17182 net82 FILLER_29_221/a_32_246# 0.01471f
C17183 _705_/a_550_127# net43 0
C17184 VPWR _650_/a_132_114# 0
C17185 _136_ _156_ 0
C17186 _250_ _247_ 0.02307f
C17187 _157_ _137_ 0.02525f
C17188 _019_ _673_/a_38_114# 0.01133f
C17189 net96 net181 0.00158f
C17190 rx_inst.data_reg\[3\] net85 0.11972f
C17191 net34 _364_/a_155_412# 0.03374f
C17192 _119_ _664_/a_1583_191# 0
C17193 net88 _520_/a_257_140# 0
C17194 _014_ _520_/a_155_412# 0
C17195 _232_ _444_/a_550_140# 0
C17196 _180_ _546_/a_341_118# 0.00399f
C17197 _240_ net62 0
C17198 hold125/a_56_118# _648_/a_612_127# 0
C17199 _138_ _648_/a_132_114# 0
C17200 net44 hold87/a_438_182# 0.01526f
C17201 _634_/a_741_93# _124_ 0.00122f
C17202 net34 _141_ 0.0403f
C17203 _170_ _435_/a_268_436# 0
C17204 net32 _435_/a_166_436# 0.00527f
C17205 net49 FILLER_22_152/a_32_246# 0
C17206 _662_/a_2250_412# clk 0.0038f
C17207 _636_/a_38_114# net80 0
C17208 rx_inst.state\[2\] _136_ 0
C17209 output17/a_40_152# net18 0.00143f
C17210 hold157/a_438_182# baud_inst.counter\[16\] 0.00787f
C17211 baud_inst.counter\[23\] net49 0
C17212 _076_ clkbuf_4_5_0_clk/a_27_118# 0.00207f
C17213 rx_data[6] VPWR 0.05601f
C17214 _078_ _200_ 0.00331f
C17215 hold130/a_56_118# _180_ 0
C17216 VPWR hold84/a_56_118# 0.00443f
C17217 _641_/a_298_337# net100 0.0014f
C17218 _405_/a_27_156# _667_/a_1840_334# 0
C17219 _048_ _633_/a_741_93# 0
C17220 _660_/a_298_337# net55 0.00101f
C17221 _358_/a_72_436# _357_/a_252_412# 0
C17222 baud_inst.counter\[14\] FILLER_15_42/a_40_246# 0
C17223 net49 _100_ 0
C17224 _533_/a_248_122# _302_ 0
C17225 VPWR FILLER_11_123/a_40_246# 0.13027f
C17226 fanout33/a_40_152# net21 0.05555f
C17227 tx_inst.data_reg\[4\] _069_ 0
C17228 clk _667_/a_741_93# 0.00725f
C17229 _180_ _686_/a_843_236# 0.00118f
C17230 VPWR FILLER_0_109/a_32_246# 0.0763f
C17231 hold88/a_326_118# VPWR 0.00633f
C17232 net54 _706_/a_612_127# 0
C17233 _425_/a_46_156# _161_ 0
C17234 _544_/a_268_412# net141 0.00149f
C17235 _544_/a_46_156# _310_ 0.02247f
C17236 _283_ _679_/a_843_236# 0
C17237 _285_ _679_/a_741_93# 0.00132f
C17238 _527_/a_341_118# baud_inst.counter\[16\] 0
C17239 _642_/a_1489_191# rx_inst.state\[2\] 0
C17240 hold143/a_56_118# net65 0.00333f
C17241 FILLER_2_81/a_32_246# _145_ 0.00156f
C17242 _155_ hold125/a_326_118# 0.00213f
C17243 VPWR rx_inst.data_reg\[5\] 0.05923f
C17244 _286_ _679_/a_38_114# 0
C17245 _064_ _652_/a_681_505# 0
C17246 rx_data[3] rx_data[4] 0
C17247 net32 net24 0.30026f
C17248 net37 _428_/a_150_412# 0
C17249 net12 net15 0.00312f
C17250 hold172/a_438_182# _200_ 0
C17251 net92 _683_/a_2250_412# 0
C17252 _062_ net57 0.02989f
C17253 _508_/a_209_168# clknet_4_2_0_clk 0.01376f
C17254 baud_inst.counter\[20\] FILLER_25_36/a_32_246# 0
C17255 _635_/a_550_127# _266_ 0
C17256 _068_ _339_/a_500_118# 0
C17257 hold130/a_326_118# _292_ 0.01072f
C17258 _404_/a_268_412# clknet_0_clk 0
C17259 _314_ net107 0.38613f
C17260 fanout37/a_40_152# _000_ 0.00842f
C17261 clkbuf_4_11_0_clk/a_27_118# baud_inst.counter\[27\] 0
C17262 VPWR _521_/a_170_412# 0
C17263 _697_/a_843_236# net46 0.00268f
C17264 _658_/a_324_432# tx_data[2] 0
C17265 hold152/a_326_118# _676_/a_1489_191# 0
C17266 _663_/a_550_127# clknet_4_6_0_clk 0
C17267 _011_ net40 0.02067f
C17268 _684_/a_298_337# net40 0.00506f
C17269 hold177/a_326_118# _297_ 0
C17270 net183 _667_/a_1840_334# 0
C17271 net58 _702_/a_843_236# 0.00157f
C17272 _032_ _702_/a_324_432# 0
C17273 _031_ _315_ 0.0012f
C17274 _677_/a_2002_114# net152 0.00134f
C17275 VPWR _682_/a_550_127# 0
C17276 _312_ _313_ 0.16593f
C17277 net28 _205_ 0.04824f
C17278 _646_/a_1840_334# _264_ 0
C17279 net18 rx_inst.data_reg\[6\] 0
C17280 net70 _632_/a_843_236# 0
C17281 _102_ _688_/a_843_236# 0
C17282 fanout31/a_40_152# clknet_0_clk 0.00233f
C17283 _022_ _692_/a_843_236# 0
C17284 net39 _508_/a_474_130# 0.00148f
C17285 _676_/a_38_114# clkbuf_4_3_0_clk/a_27_118# 0
C17286 baud_inst.counter\[28\] _701_/a_1583_191# 0.01545f
C17287 input8/a_40_152# tx_data[5] 0.02328f
C17288 tx_data[6] net170 0
C17289 _004_ net43 0.00164f
C17290 clknet_4_14_0_clk _429_/a_142_412# 0.00522f
C17291 _705_/a_1840_334# _478_/a_27_156# 0
C17292 _116_ clknet_4_11_0_clk 0.13258f
C17293 _645_/a_1840_334# _055_ 0
C17294 _699_/a_741_93# _699_/a_843_236# 0
C17295 rx_inst.bit_index\[1\] _443_/a_150_412# 0
C17296 VPWR _454_/a_155_412# 0.07986f
C17297 _661_/a_1489_191# VPWR 0
C17298 VPWR _702_/a_1840_334# 0.00204f
C17299 hold56/a_438_182# _141_ 0
C17300 tx_inst.bit_index\[0\] net56 0
C17301 hold118/a_326_118# _264_ 0
C17302 net36 FILLER_19_139/a_40_246# 0.00405f
C17303 rx_data[6] _127_ 0
C17304 _488_/a_380_412# net40 0
C17305 _488_/a_177_436# _086_ 0.00182f
C17306 hold123/a_438_182# _676_/a_2250_412# 0
C17307 _640_/a_2002_114# VPWR 0
C17308 net48 rx_inst.data_reg\[4\] 0.1376f
C17309 hold127/a_56_118# _424_/a_244_412# 0
C17310 hold67/a_438_182# clknet_4_11_0_clk 0.0168f
C17311 net82 hold83/a_56_118# 0.01258f
C17312 _232_ FILLER_24_156/a_32_246# 0.00424f
C17313 net114 net49 0
C17314 _650_/a_1583_191# net30 0.01046f
C17315 net120 hold148/a_326_118# 0.03288f
C17316 clknet_0_clk _666_/a_324_432# 0.00327f
C17317 _230_ _408_/a_154_118# 0.00163f
C17318 hold68/a_438_182# net105 0.00358f
C17319 net177 net29 0
C17320 _552_/a_155_412# _313_ 0.01215f
C17321 _216_ _395_/a_248_122# 0
C17322 baud_inst.counter\[24\] _686_/a_741_93# 0
C17323 _064_ clk 0.00591f
C17324 _669_/a_741_93# clknet_4_9_0_clk 0.02335f
C17325 _645_/a_843_236# rx_inst.data_reg\[2\] 0
C17326 FILLER_7_40/a_32_246# _287_ 0
C17327 tx_inst.data_reg\[4\] clknet_4_4_0_clk 0.22162f
C17328 clknet_4_12_0_clk hold176/a_56_118# 0.03269f
C17329 _053_ hold176/a_438_182# 0.00134f
C17330 _132_ hold176/a_326_118# 0.00145f
C17331 net32 _438_/a_146_122# 0.00249f
C17332 baud_inst.counter\[27\] _547_/a_81_118# 0.01182f
C17333 hold57/a_438_182# net27 0
C17334 _082_ _099_ 0.00202f
C17335 FILLER_19_75/a_40_246# FILLER_19_77/a_32_246# 0.0524f
C17336 net133 _702_/a_132_114# 0
C17337 _170_ FILLER_18_169/a_40_246# 0
C17338 _127_ rx_inst.data_reg\[5\] 0
C17339 hold133/a_438_182# _702_/a_741_93# 0
C17340 _273_ _264_ 0.36035f
C17341 baud_inst.counter\[31\] _346_/a_150_412# 0
C17342 net35 net25 0.09446f
C17343 _665_/a_741_93# tx_inst.state\[3\] 0.00516f
C17344 net37 clkbuf_0_clk/a_116_82# 0.00526f
C17345 net82 _634_/a_741_93# 0
C17346 _245_ _444_/a_244_140# 0
C17347 _217_ _653_/a_2002_114# 0
C17348 hold122/a_326_118# _220_ 0
C17349 _432_/a_350_122# VPWR 0
C17350 FILLER_19_75/a_40_246# clknet_4_8_0_clk 0.00255f
C17351 net30 hold84/a_326_118# 0
C17352 net42 hold122/a_56_118# 0.01294f
C17353 fanout43/a_40_152# _667_/a_843_236# 0
C17354 baud_inst.counter\[19\] _014_ 0
C17355 _230_ _238_ 0
C17356 hold149/a_56_118# fanout46/a_40_152# 0.00219f
C17357 _421_/a_354_412# _237_ 0.00362f
C17358 tx_inst.data_reg\[6\] _392_/a_382_118# 0
C17359 net44 _697_/a_298_337# 0
C17360 tx_done _704_/a_843_236# 0.00116f
C17361 _680_/a_741_93# net136 0.00811f
C17362 _173_ _194_ 0.64629f
C17363 _217_ _477_/a_22_110# 0.00361f
C17364 net111 _157_ 0
C17365 FILLER_10_147/a_32_246# _653_/a_2250_412# 0
C17366 net156 _688_/a_298_337# 0.01554f
C17367 _060_ _648_/a_298_337# 0
C17368 _074_ FILLER_1_212/a_32_246# 0.0026f
C17369 _238_ FILLER_22_175/a_32_246# 0
C17370 clknet_0_clk _099_ 0.03448f
C17371 _277_ _671_/a_132_114# 0
C17372 net28 _671_/a_1583_191# 0
C17373 net2 _667_/a_741_93# 0
C17374 _266_ rx_inst.data_reg\[5\] 0.21607f
C17375 _193_ _341_/a_1377_160# 0.00469f
C17376 _034_ baud_inst.counter\[4\] 0
C17377 _661_/a_324_432# _384_/a_59_156# 0
C17378 hold155/a_326_118# net6 0
C17379 baud_inst.counter\[6\] clkbuf_4_3_0_clk/a_27_118# 0
C17380 net13 clknet_4_14_0_clk 0.01232f
C17381 _117_ input2/a_40_152# 0.00216f
C17382 _693_/a_324_432# VPWR 0.01463f
C17383 _255_ _251_ 0
C17384 _046_ net85 1.2024f
C17385 _510_/a_248_122# net135 0.00467f
C17386 _510_/a_146_122# _287_ 0
C17387 _282_ _096_ 0
C17388 _441_/a_154_118# _236_ 0
C17389 FILLER_24_133/a_32_246# net52 0
C17390 _637_/a_2002_114# clknet_4_15_0_clk 0
C17391 _175_ _005_ 0.00144f
C17392 _198_ clknet_0_clk 0
C17393 rx_data[7] net80 0.00742f
C17394 FILLER_5_181/a_32_246# _197_ 0.00185f
C17395 hold115/a_326_118# _010_ 0
C17396 _168_ clknet_0_clk 0.05178f
C17397 _062_ fanout27/a_40_152# 0
C17398 net23 _707_/a_324_432# 0
C17399 net129 _515_/a_76_160# 0
C17400 FILLER_8_63/a_40_246# clknet_4_2_0_clk 0
C17401 _674_/a_324_432# net61 0
C17402 hold60/a_326_118# net86 0
C17403 _674_/a_741_93# _033_ 0
C17404 _171_ VPWR 0.27879f
C17405 _392_/a_496_118# VPWR 0
C17406 clkbuf_0_clk/a_116_82# _670_/a_843_236# 0
C17407 _234_ _671_/a_741_93# 0.00374f
C17408 hold111/a_438_182# rx_inst.data_reg\[0\] 0.01945f
C17409 net42 FILLER_12_128/a_40_246# 0
C17410 baud_inst.counter\[16\] net40 0.0222f
C17411 net135 _182_ 0.07941f
C17412 rx_data[2] _637_/a_550_127# 0
C17413 net14 _637_/a_1489_191# 0
C17414 _170_ VPWR 1.24469f
C17415 _022_ _534_/a_46_156# 0
C17416 _672_/a_2250_412# VPWR 0.00599f
C17417 tx_busy _121_ 0.00293f
C17418 baud_inst.counter\[19\] _529_/a_139_160# 0
C17419 _118_ hold50/a_56_118# 0.00662f
C17420 net163 FILLER_17_0/a_40_246# 0.00329f
C17421 _077_ _198_ 0.0094f
C17422 _002_ net51 0.24344f
C17423 _304_ _692_/a_298_337# 0.00166f
C17424 net147 _692_/a_38_114# 0.00102f
C17425 _658_/a_1840_334# _212_ 0
C17426 _431_/a_379_118# _246_ 0.00293f
C17427 _139_ _649_/a_324_432# 0
C17428 _653_/a_2250_412# _142_ 0
C17429 _653_/a_1785_429# _220_ 0
C17430 net128 _297_ 0
C17431 _535_/a_248_122# VPWR 0
C17432 hold135/a_438_182# net181 0.00746f
C17433 hold135/a_326_118# net86 0.00783f
C17434 _064_ _653_/a_1840_334# 0
C17435 FILLER_15_17/a_40_246# net160 0
C17436 VPWR hold62/a_56_118# 0.04244f
C17437 _691_/a_298_337# hold104/a_326_118# 0
C17438 _047_ _157_ 0
C17439 _649_/a_843_236# rx_inst.data_reg\[6\] 0
C17440 _649_/a_132_114# net127 0
C17441 FILLER_25_150/a_32_246# net24 0
C17442 _032_ _112_ 0
C17443 _180_ _347_/a_146_122# 0
C17444 _072_ tx_inst.data_reg\[1\] 0.00546f
C17445 _639_/a_298_337# net30 0
C17446 _099_ _685_/a_1840_334# 0
C17447 _672_/a_38_114# net60 0.02984f
C17448 _677_/a_741_93# clkbuf_4_3_0_clk/a_27_118# 0.01984f
C17449 FILLER_15_162/a_40_246# net2 0
C17450 hold161/a_56_118# hold158/a_438_182# 0
C17451 net28 _374_/a_142_412# 0
C17452 VPWR _650_/a_1489_191# 0
C17453 _249_ _434_/a_354_412# 0.00306f
C17454 _031_ hold106/a_438_182# 0
C17455 _170_ _239_ 0.00138f
C17456 hold121/a_56_118# baud_inst.counter\[23\] 0
C17457 _695_/a_843_236# clknet_4_10_0_clk 0.00838f
C17458 _173_ _341_/a_886_118# 0
C17459 _518_/a_139_160# baud_inst.counter\[14\] 0.00158f
C17460 net34 _197_ 0.52841f
C17461 _368_/a_257_140# _200_ 0.00193f
C17462 _014_ _297_ 0.00383f
C17463 _135_ FILLER_29_145/a_40_246# 0
C17464 tx_inst.data_reg\[2\] FILLER_3_141/a_40_246# 0
C17465 FILLER_25_177/a_40_246# _170_ 0.00452f
C17466 _178_ _693_/a_1583_191# 0
C17467 FILLER_10_78/a_32_246# _358_/a_72_436# 0
C17468 net15 net84 0.01689f
C17469 _138_ _648_/a_1489_191# 0.00104f
C17470 output21/a_40_152# net11 0
C17471 _265_ _129_ 0.16577f
C17472 net144 _170_ 0
C17473 _659_/a_298_337# _149_ 0
C17474 _659_/a_324_432# net137 0
C17475 VPWR _494_/a_279_412# 0
C17476 net44 _517_/a_209_168# 0
C17477 net1 FILLER_25_25/a_40_246# 0
C17478 net36 _230_ 0.05191f
C17479 net167 _191_ 0
C17480 _427_/a_350_122# _236_ 0
C17481 net36 hold52/a_438_182# 0
C17482 _707_/a_741_93# net22 0
C17483 net120 FILLER_22_32/a_40_246# 0
C17484 _640_/a_843_236# _224_ 0
C17485 net85 _043_ 0
C17486 tx_inst.state\[4\] clkbuf_4_7_0_clk/a_27_118# 0
C17487 _048_ _633_/a_1785_429# 0
C17488 _649_/a_38_114# _648_/a_324_432# 0
C17489 _649_/a_298_337# _648_/a_741_93# 0
C17490 _660_/a_1583_191# net55 0
C17491 _358_/a_411_436# _180_ 0
C17492 _358_/a_72_436# _189_ 0.0196f
C17493 _690_/a_38_114# _690_/a_132_114# -0
C17494 _690_/a_741_93# _690_/a_843_236# -0
C17495 fanout25/a_40_152# FILLER_18_158/a_40_246# 0.01f
C17496 net55 FILLER_0_156/a_32_246# 0.00148f
C17497 net92 FILLER_8_70/a_32_246# 0
C17498 _286_ hold110/a_56_118# 0
C17499 _295_ VPWR 0.17644f
C17500 _696_/a_843_236# VPWR 0.00509f
C17501 net54 _119_ 0
C17502 FILLER_7_82/a_32_246# _287_ 0
C17503 _280_ _683_/a_1489_191# 0
C17504 hold102/a_326_118# baud_inst.counter\[17\] 0.0156f
C17505 _270_ net16 0.00172f
C17506 net179 _392_/a_285_118# 0.00147f
C17507 _652_/a_1489_191# _142_ 0.00361f
C17508 _285_ _679_/a_1785_429# 0.00227f
C17509 net94 _679_/a_1489_191# 0.01675f
C17510 net35 _139_ 0.00188f
C17511 rx_inst.bit_index\[2\] rx_inst.state\[2\] 0.12377f
C17512 net42 _652_/a_1489_191# 0.0014f
C17513 FILLER_19_77/a_32_246# _309_ 0
C17514 hold69/a_438_182# _273_ 0.0036f
C17515 _462_/a_22_110# clknet_4_15_0_clk 0.00231f
C17516 FILLER_12_166/a_40_246# net62 0
C17517 _680_/a_324_432# clknet_4_0_0_clk 0.0256f
C17518 _706_/a_843_236# VPWR 0.0112f
C17519 net54 _705_/a_1583_191# 0
C17520 net26 net30 0.03191f
C17521 hold139/a_438_182# VPWR 0.00833f
C17522 hold100/a_326_118# _111_ 0.00147f
C17523 hold100/a_438_182# net45 0
C17524 clknet_4_5_0_clk fanout33/a_40_152# 0.01935f
C17525 net42 hold169/a_326_118# 0.00259f
C17526 _041_ _667_/a_843_236# 0
C17527 net49 fanout28/a_40_152# 0.00534f
C17528 _646_/a_1840_334# _269_ 0
C17529 _697_/a_612_127# net46 0
C17530 clknet_4_8_0_clk _309_ 0.02797f
C17531 _684_/a_1583_191# net40 0.00357f
C17532 clknet_4_7_0_clk clknet_4_6_0_clk 0.04403f
C17533 _444_/a_244_140# _255_ 0
C17534 hold182/a_56_118# _089_ 0
C17535 _045_ _633_/a_324_432# 0.00106f
C17536 _660_/a_843_236# tx_inst.data_reg\[2\] 0
C17537 hold129/a_438_182# _358_/a_72_436# 0
C17538 FILLER_15_67/a_40_246# hold88/a_56_118# 0.00786f
C17539 _556_/a_192_429# _115_ 0
C17540 _113_ _700_/a_324_432# 0.02939f
C17541 _370_/a_154_118# _203_ 0.0011f
C17542 VPWR clknet_4_2_0_clk 1.26251f
C17543 net55 _385_/a_268_412# 0
C17544 _233_ _671_/a_741_93# 0
C17545 net121 _694_/a_324_432# 0
C17546 _067_ FILLER_0_156/a_32_246# 0.00138f
C17547 net33 _478_/a_229_118# 0.00152f
C17548 _170_ _167_ 0.06594f
C17549 net18 _632_/a_2250_412# 0
C17550 _169_ _667_/a_741_93# 0.04831f
C17551 FILLER_28_204/a_32_246# _264_ 0.00412f
C17552 _022_ _692_/a_612_127# 0
C17553 FILLER_10_147/a_32_246# tx_inst.bit_index\[1\] 0
C17554 _269_ hold118/a_326_118# 0
C17555 _017_ _103_ 0.0104f
C17556 net48 _633_/a_681_505# 0
C17557 VPWR _263_ 0.07059f
C17558 fanout41/a_40_152# _659_/a_741_93# 0.00309f
C17559 clknet_4_14_0_clk FILLER_23_143/a_32_246# 0.0012f
C17560 _537_/a_341_118# VPWR 0
C17561 tx_inst.data_reg\[7\] VPWR 0.47209f
C17562 net173 clknet_0_clk 0
C17563 _707_/a_1583_191# net80 0
C17564 _170_ _225_ 0
C17565 hold121/a_56_118# FILLER_21_33/a_32_246# 0
C17566 _019_ _086_ 0.13592f
C17567 _646_/a_1583_191# _156_ 0
C17568 _261_ _262_ 0.11112f
C17569 _344_/a_354_412# _024_ 0
C17570 _098_ hold91/a_326_118# 0.00107f
C17571 clknet_0_clk _685_/a_843_236# 0.01517f
C17572 _650_/a_2002_114# net30 0
C17573 _650_/a_1489_191# _266_ 0.01726f
C17574 _691_/a_1840_334# hold163/a_326_118# 0
C17575 _691_/a_1583_191# hold163/a_438_182# 0
C17576 hold175/a_326_118# VPWR 0.00634f
C17577 clknet_0_clk _666_/a_2250_412# 0.04642f
C17578 _676_/a_1489_191# _191_ 0.00338f
C17579 _651_/a_741_93# clknet_4_6_0_clk 0.03763f
C17580 VPWR _237_ 0.05227f
C17581 _315_ _313_ 0.01091f
C17582 VPWR FILLER_12_208/a_32_246# 0.08479f
C17583 rx_inst.data_reg\[0\] clknet_0_clk 0.00458f
C17584 _674_/a_1583_191# _279_ 0
C17585 _676_/a_298_337# VPWR 0.00218f
C17586 hold127/a_326_118# net127 0
C17587 _416_/a_146_122# net25 0.00157f
C17588 _696_/a_324_432# net162 0
C17589 _274_ net168 0.09976f
C17590 _155_ hold126/a_56_118# 0
C17591 FILLER_8_236/a_40_246# tx_inst.state\[3\] 0
C17592 FILLER_8_171/a_32_246# _651_/a_741_93# 0
C17593 net103 FILLER_17_22/a_40_246# 0.00111f
C17594 net15 _635_/a_741_93# 0
C17595 hold133/a_326_118# _702_/a_612_127# 0
C17596 _216_ tx_inst.state\[4\] 0
C17597 _284_ _090_ 0.00491f
C17598 _217_ _651_/a_843_236# 0
C17599 VPWR _683_/a_298_337# 0.00107f
C17600 clknet_4_6_0_clk _007_ 0
C17601 baud_inst.counter\[26\] hold140/a_326_118# 0.00488f
C17602 tx_inst.data_reg\[0\] net172 0
C17603 FILLER_16_176/a_40_246# hold139/a_326_118# 0
C17604 _551_/a_76_160# hold114/a_56_118# 0
C17605 input4/a_40_152# net7 0
C17606 net4 input7/a_40_152# 0.0223f
C17607 _665_/a_1785_429# tx_inst.state\[3\] 0
C17608 _025_ FILLER_17_79/a_40_246# 0
C17609 _640_/a_741_93# net49 0
C17610 _425_/a_268_412# _418_/a_46_156# 0
C17611 net40 _681_/a_298_337# 0
C17612 net146 VPWR 0.18642f
C17613 _239_ _237_ 0.06923f
C17614 _693_/a_843_236# _106_ 0
C17615 net94 _093_ 0
C17616 _652_/a_741_93# FILLER_11_123/a_40_246# 0
C17617 net44 _697_/a_1583_191# 0.03785f
C17618 _198_ FILLER_6_189/a_40_246# 0.00165f
C17619 _551_/a_272_160# _313_ 0.002f
C17620 _447_/a_175_118# _223_ 0.00213f
C17621 _349_/a_248_122# net181 0
C17622 _349_/a_146_122# net86 0
C17623 tx_inst.bit_index\[1\] _142_ 0.70125f
C17624 _356_/a_146_122# net40 0
C17625 net179 _706_/a_741_93# 0.00268f
C17626 net92 _183_ 0.03917f
C17627 net156 _688_/a_1583_191# 0.00866f
C17628 _672_/a_324_432# FILLER_0_56/a_32_246# 0
C17629 net42 tx_inst.bit_index\[1\] 0.00186f
C17630 _519_/a_81_118# _011_ 0
C17631 _519_/a_277_118# _163_ 0.00128f
C17632 FILLER_15_162/a_40_246# _169_ 0
C17633 _060_ _648_/a_1583_191# 0
C17634 baud_inst.counter\[1\] clknet_4_0_0_clk 0.11815f
C17635 _234_ _250_ 0
C17636 clknet_4_15_0_clk hold72/a_326_118# 0.02483f
C17637 baud_inst.counter\[28\] _311_ 0
C17638 clknet_4_1_0_clk FILLER_4_102/a_32_246# 0
C17639 net184 tx_inst.bit_index\[2\] 0.45427f
C17640 clknet_4_1_0_clk _384_/a_59_156# 0.00185f
C17641 hold184/a_438_182# VPWR 0.00792f
C17642 hold115/a_438_182# _289_ 0.00136f
C17643 tx_inst.data_reg\[7\] _339_/a_1023_118# 0
C17644 baud_inst.counter\[7\] _282_ 0
C17645 _678_/a_324_432# hold92/a_326_118# 0
C17646 _678_/a_741_93# hold92/a_56_118# 0.00324f
C17647 _550_/a_209_168# _701_/a_741_93# 0
C17648 clkbuf_4_10_0_clk/a_27_118# hold114/a_56_118# 0
C17649 _055_ _044_ 0.00634f
C17650 _693_/a_2250_412# VPWR 0.01082f
C17651 _170_ _448_/a_550_140# 0
C17652 hold165/a_56_118# _656_/a_1840_334# 0
C17653 _073_ hold168/a_438_182# 0.00171f
C17654 hold167/a_438_182# net91 0
C17655 _644_/a_38_114# _159_ 0.04062f
C17656 _262_ _452_/a_257_140# 0
C17657 _545_/a_248_122# _308_ 0
C17658 _226_ rx_inst.bit_index\[2\] 0.02717f
C17659 _697_/a_132_114# clknet_0_clk 0
C17660 hold132/a_438_182# VPWR 0.00183f
C17661 _360_/a_589_385# net41 0
C17662 _681_/a_1489_191# baud_inst.counter\[9\] 0.00128f
C17663 net97 _509_/a_257_140# 0.00459f
C17664 _089_ net29 0.02108f
C17665 output22/a_40_152# _704_/a_843_236# 0
C17666 hold139/a_438_182# _167_ 0
C17667 hold120/a_326_118# net46 0.00533f
C17668 hold113/a_438_182# net113 0.03249f
C17669 _194_ FILLER_4_172/a_32_246# 0
C17670 _038_ net86 0
C17671 clknet_0_clk _131_ 0.00774f
C17672 FILLER_19_55/a_40_246# _540_/a_45_160# 0.01798f
C17673 net27 net183 0.00272f
C17674 net23 _707_/a_2250_412# 0
C17675 hold166/a_56_118# fanout26/a_40_152# 0.00117f
C17676 _053_ baud_inst.counter\[25\] 0.00454f
C17677 hold118/a_56_118# _050_ 0
C17678 FILLER_25_198/a_32_246# net30 0
C17679 _674_/a_1785_429# _033_ 0
C17680 net92 net154 0
C17681 _132_ _669_/a_38_114# 0.00156f
C17682 _053_ _669_/a_324_432# 0
C17683 net43 _666_/a_324_432# 0
C17684 fanout30/a_40_152# _264_ 0
C17685 _645_/a_298_337# _159_ 0
C17686 _351_/a_46_156# baud_inst.counter\[4\] 0.01f
C17687 clkload1/Y clkbuf_4_7_0_clk/a_27_118# 0.00934f
C17688 net14 net17 0.06187f
C17689 net12 output12/a_40_152# 0.02851f
C17690 _432_/a_146_122# net49 0
C17691 net20 _704_/a_2250_412# 0.06381f
C17692 FILLER_8_118/a_32_246# net137 0
C17693 _486_/a_115_308# net26 0.01397f
C17694 _029_ net45 0
C17695 net55 _654_/a_324_432# 0.03109f
C17696 net51 FILLER_14_148/a_40_246# 0.00101f
C17697 baud_inst.counter\[8\] _291_ 0
C17698 _499_/a_209_168# _185_ 0.05116f
C17699 _240_ net19 0
C17700 net147 _692_/a_1840_334# 0
C17701 _663_/a_324_432# net27 0
C17702 hold118/a_438_182# net118 0.00247f
C17703 _637_/a_741_93# hold72/a_56_118# 0.00324f
C17704 _178_ _701_/a_843_236# 0
C17705 _211_ _209_ 0.46481f
C17706 VPWR _104_ 0.1229f
C17707 net131 _123_ 0
C17708 FILLER_6_205/a_40_246# _664_/a_1583_191# 0
C17709 net92 net115 0.04946f
C17710 net39 _513_/a_155_160# 0
C17711 net182 _089_ 0
C17712 _080_ _667_/a_612_127# 0
C17713 net22 _704_/a_1489_191# 0
C17714 _286_ _506_/a_155_412# 0
C17715 baud_inst.counter\[6\] hold93/a_56_118# 0.00103f
C17716 baud_inst.counter\[30\] _180_ 0.02503f
C17717 hold76/a_56_118# VPWR 0.00545f
C17718 _424_/a_550_140# _238_ 0
C17719 hold128/a_326_118# hold90/a_56_118# 0
C17720 _691_/a_324_432# net104 0.04226f
C17721 _202_ FILLER_5_192/a_40_246# 0
C17722 _215_ _666_/a_1840_334# 0.00129f
C17723 _639_/a_1583_191# net30 0
C17724 _672_/a_1840_334# net60 0
C17725 _672_/a_1583_191# _181_ 0.00984f
C17726 VPWR rx_inst.data_reg\[7\] 0.05518f
C17727 _228_ _161_ 0.00175f
C17728 _637_/a_681_505# net72 0
C17729 _637_/a_132_114# _048_ 0
C17730 _071_ net9 0
C17731 _650_/a_324_432# _140_ 0
C17732 _109_ _696_/a_550_127# 0
C17733 _695_/a_612_127# clknet_4_10_0_clk 0
C17734 _313_ _700_/a_681_505# 0
C17735 _524_/a_146_122# _296_ 0.00174f
C17736 baud_inst.counter\[16\] _522_/a_380_412# 0.00338f
C17737 hold175/a_326_118# _225_ 0
C17738 tx_inst.bit_index\[2\] net169 0
C17739 _707_/a_298_337# _121_ 0.01274f
C17740 _286_ _292_ 0.03128f
C17741 tx_inst.state\[4\] _666_/a_843_236# 0
C17742 output20/a_40_152# _707_/a_2250_412# 0
C17743 _024_ _308_ 0.23416f
C17744 _118_ _705_/a_324_432# 0.02893f
C17745 FILLER_13_137/a_32_246# clk 0.00111f
C17746 _431_/a_81_118# net37 0.001f
C17747 _178_ _693_/a_2002_114# 0
C17748 _691_/a_38_114# _020_ 0.02051f
C17749 _691_/a_741_93# net163 0.03575f
C17750 baud_inst.counter\[22\] _699_/a_324_432# 0
C17751 net83 _271_ 0.66662f
C17752 net55 _212_ 0.10665f
C17753 _646_/a_741_93# net111 0
C17754 _092_ net95 0.01394f
C17755 net18 hold70/a_56_118# 0.00202f
C17756 net70 hold70/a_438_182# 0
C17757 clknet_4_4_0_clk _664_/a_843_236# 0.01963f
C17758 clknet_4_7_0_clk _668_/a_1583_191# 0
C17759 _244_ _236_ 0
C17760 net44 baud_inst.counter\[15\] 0.06533f
C17761 _649_/a_741_93# _648_/a_1583_191# 0
C17762 _677_/a_324_432# VPWR 0
C17763 _530_/a_257_140# _164_ 0.00139f
C17764 clknet_4_12_0_clk _434_/a_354_412# 0.00143f
C17765 _198_ net43 0
C17766 _191_ _180_ 0.02158f
C17767 hold167/a_56_118# VPWR 0.01051f
C17768 _018_ _690_/a_741_93# 0.00386f
C17769 net48 FILLER_17_199/a_40_246# 0.00917f
C17770 _344_/a_354_412# baud_inst.counter\[25\] 0
C17771 _168_ net43 0.01477f
C17772 _121_ hold51/a_438_182# 0.00357f
C17773 _233_ _250_ 0
C17774 hold106/a_438_182# _313_ 0
C17775 FILLER_12_128/a_40_246# _670_/a_1583_191# 0.00208f
C17776 net49 _427_/a_146_122# 0
C17777 _280_ baud_inst.counter\[11\] 0
C17778 net55 _478_/a_27_156# 0
C17779 _058_ _223_ 0.00671f
C17780 hold179/a_326_118# net172 0
C17781 net94 baud_inst.counter\[7\] 0.32161f
C17782 net92 clknet_4_3_0_clk 0.10333f
C17783 _284_ _677_/a_298_337# 0
C17784 net33 net54 0.63566f
C17785 VPWR _433_/a_550_140# 0
C17786 _646_/a_324_432# _057_ 0.03238f
C17787 _076_ _664_/a_132_114# 0
C17788 net2 _650_/a_843_236# 0
C17789 _206_ _380_/a_285_412# 0.00785f
C17790 _198_ _664_/a_324_432# 0
C17791 clknet_4_14_0_clk hold125/a_56_118# 0
C17792 _170_ _428_/a_252_412# 0
C17793 net54 _656_/a_2250_412# 0
C17794 tx_start net43 0.0029f
C17795 _504_/a_177_436# net38 0
C17796 _680_/a_2250_412# clknet_4_0_0_clk 0.02452f
C17797 tx_inst.data_reg\[3\] _172_ 0
C17798 _706_/a_612_127# VPWR 0.003f
C17799 net142 net46 0
C17800 _110_ _099_ 0
C17801 hold140/a_56_118# VPWR 0.02865f
C17802 hold60/a_326_118# net38 0
C17803 _045_ _633_/a_2250_412# 0.03309f
C17804 _155_ _649_/a_298_337# 0
C17805 _660_/a_612_127# tx_inst.data_reg\[2\] 0
C17806 _316_ _115_ 0
C17807 net45 _693_/a_38_114# 0.00111f
C17808 _517_/a_380_412# baud_inst.counter\[15\] 0.01393f
C17809 _517_/a_177_436# baud_inst.counter\[14\] 0
C17810 hold178/a_326_118# _096_ 0
C17811 hold100/a_438_182# FILLER_21_96/a_40_246# 0.00941f
C17812 hold56/a_326_118# VPWR 0.01065f
C17813 net140 _540_/a_45_160# 0
C17814 _058_ _240_ 0.00655f
C17815 hold136/a_438_182# _181_ 0
C17816 _705_/a_298_337# VPWR 0.00252f
C17817 _102_ net161 0.00325f
C17818 _169_ _667_/a_1785_429# 0
C17819 clknet_0_clk _386_/a_559_412# 0.00247f
C17820 net41 clkbuf_4_1_0_clk/a_27_118# 0
C17821 _480_/a_22_110# net27 0.00215f
C17822 net46 _686_/a_132_114# 0
C17823 _697_/a_741_93# _697_/a_1489_191# 0
C17824 net48 _633_/a_550_127# 0
C17825 net55 _383_/a_46_156# 0.02036f
C17826 rx rx_inst.state\[1\] 0
C17827 _470_/a_22_110# _271_ 0.01756f
C17828 net148 net147 0.0038f
C17829 hold67/a_326_118# net58 0
C17830 _699_/a_741_93# net114 0
C17831 net45 FILLER_25_9/a_32_246# 0
C17832 net148 net46 0
C17833 hold160/a_438_182# _688_/a_1840_334# 0
C17834 FILLER_12_171/a_40_246# clknet_0_clk 0.00964f
C17835 _638_/a_741_93# _264_ 0.00589f
C17836 hold135/a_326_118# net38 0.04576f
C17837 net51 hold80/a_438_182# 0
C17838 _707_/a_2002_114# net80 0
C17839 hold113/a_56_118# net99 0.01071f
C17840 _661_/a_38_114# _378_/a_382_118# 0
C17841 rx_data[0] _632_/a_741_93# 0
C17842 _117_ _075_ 0
C17843 _294_ fanout29/a_40_152# 0.01161f
C17844 net156 _101_ 0.21418f
C17845 clknet_0_clk _685_/a_612_127# 0.00157f
C17846 hold161/a_326_118# baud_inst.counter\[17\] 0.00142f
C17847 rx_inst.data_reg\[7\] _266_ 0
C17848 _057_ _473_/a_22_110# 0
C17849 _651_/a_1785_429# clknet_4_6_0_clk 0
C17850 _296_ _684_/a_324_432# 0
C17851 FILLER_0_35/a_40_246# VPWR 0.15429f
C17852 rx_inst.bit_index\[2\] FILLER_19_149/a_40_246# 0.00145f
C17853 _128_ _637_/a_741_93# 0
C17854 _030_ _490_/a_139_160# 0
C17855 baud_inst.counter\[8\] hold117/a_438_182# 0
C17856 _676_/a_1583_191# VPWR 0.00694f
C17857 _004_ net51 0.0012f
C17858 _270_ _635_/a_38_114# 0.00208f
C17859 _062_ _041_ 0.00487f
C17860 clknet_4_14_0_clk _236_ 1.78928f
C17861 clknet_4_4_0_clk _211_ 0.00174f
C17862 _679_/a_741_93# VPWR 0.00954f
C17863 hold116/a_56_118# _182_ 0
C17864 hold166/a_326_118# net166 0.00298f
C17865 hold147/a_56_118# net49 0.00363f
C17866 hold133/a_438_182# _115_ 0
C17867 _073_ _665_/a_298_337# 0.00396f
C17868 VPWR _683_/a_1583_191# 0.00897f
C17869 clkbuf_0_clk/a_116_82# net26 0.05064f
C17870 fanout32/a_40_152# _224_ 0
C17871 hold172/a_56_118# net55 0.00766f
C17872 _240_ _636_/a_1583_191# 0
C17873 net105 hold114/a_438_182# 0
C17874 baud_inst.counter\[28\] hold68/a_438_182# 0
C17875 _675_/a_1583_191# net135 0
C17876 _651_/a_38_114# _667_/a_1583_191# 0
C17877 net101 _299_ 0.50712f
C17878 VPWR _701_/a_132_114# 0
C17879 FILLER_14_70/a_40_246# VPWR 0.12376f
C17880 net177 FILLER_14_72/a_32_246# 0
C17881 hold176/a_438_182# VPWR 0.00359f
C17882 _693_/a_612_127# _106_ 0
C17883 net44 _697_/a_2002_114# 0
C17884 _082_ _642_/a_38_114# 0
C17885 net44 _642_/a_324_432# 0.00291f
C17886 _645_/a_741_93# _056_ 0
C17887 _230_ _159_ 0
C17888 net156 _688_/a_2002_114# 0
C17889 baud_inst.counter\[13\] net40 0.01783f
C17890 hold74/a_326_118# _639_/a_1583_191# 0
C17891 _414_/a_165_412# _204_ 0
C17892 net128 _011_ 0
C17893 baud_inst.counter\[12\] _684_/a_38_114# 0
C17894 _295_ _163_ 0.00244f
C17895 _479_/a_22_110# _166_ 0
C17896 hold103/a_438_182# _296_ 0
C17897 _264_ _647_/a_1583_191# 0
C17898 FILLER_24_229/a_32_246# _638_/a_324_432# 0
C17899 _154_ _264_ 0.03166f
C17900 hold88/a_438_182# _684_/a_843_236# 0
C17901 _170_ _138_ 0.15523f
C17902 VPWR _474_/a_120_432# 0
C17903 FILLER_17_94/a_40_246# _686_/a_324_432# 0
C17904 _661_/a_681_505# _148_ 0
C17905 _661_/a_1583_191# net171 0
C17906 net79 _489_/a_494_160# 0
C17907 clk tx_inst.data_reg\[3\] 0.08054f
C17908 net44 _686_/a_324_432# 0.00508f
C17909 _538_/a_81_118# baud_inst.counter\[23\] 0.03555f
C17910 _167_ _433_/a_550_140# 0
C17911 _170_ _232_ 1.05536f
C17912 net55 _655_/a_324_432# 0.00846f
C17913 _678_/a_38_114# _678_/a_132_114# -0
C17914 _644_/a_1840_334# _159_ 0.00505f
C17915 _644_/a_843_236# _134_ 0.00192f
C17916 _546_/a_192_429# clknet_0_clk 0.00355f
C17917 baud_inst.counter\[25\] _308_ 0.015f
C17918 hold115/a_56_118# _038_ 0
C17919 hold115/a_326_118# _287_ 0
C17920 _081_ _121_ 0
C17921 _344_/a_354_412# baud_inst.counter\[24\] 0
C17922 hold172/a_438_182# net22 0
C17923 _685_/a_38_114# net130 0.03751f
C17924 _685_/a_298_337# clknet_4_9_0_clk 0.0021f
C17925 _227_ _423_/a_165_412# 0.00144f
C17926 _697_/a_1489_191# clknet_0_clk 0.00381f
C17927 _216_ _403_/a_22_110# 0.00106f
C17928 _180_ hold91/a_438_182# 0.00331f
C17929 net173 net43 0
C17930 net173 hold173/a_326_118# 0.0104f
C17931 tx_busy _704_/a_1583_191# 0.02085f
C17932 hold63/a_326_118# _205_ 0.0069f
C17933 _642_/a_38_114# clknet_0_clk 0.00615f
C17934 _346_/a_150_412# VPWR 0
C17935 rx_inst.bit_index\[1\] net25 0.17634f
C17936 tx_inst.data_reg\[6\] _175_ 0
C17937 net69 VPWR 0.10768f
C17938 FILLER_22_133/a_40_246# clknet_4_14_0_clk 0
C17939 _089_ _493_/a_45_160# 0.07042f
C17940 _689_/a_38_114# net158 0.0268f
C17941 _163_ clknet_4_2_0_clk 0.00293f
C17942 _671_/a_38_114# clknet_0_clk 0.01343f
C17943 clknet_4_12_0_clk _669_/a_1583_191# 0
C17944 _053_ _669_/a_2250_412# 0
C17945 _132_ _669_/a_1840_334# 0
C17946 hold64/a_56_118# net12 0.03063f
C17947 net43 _666_/a_2250_412# 0.00193f
C17948 tx_busy net43 0
C17949 _645_/a_1583_191# _159_ 0.01442f
C17950 _640_/a_298_337# _698_/a_38_114# 0
C17951 _640_/a_38_114# _698_/a_298_337# 0
C17952 _415_/a_170_412# VPWR 0
C17953 net123 FILLER_12_106/a_40_246# 0.00412f
C17954 _098_ VPWR 0.20781f
C17955 clknet_0_clk _686_/a_38_114# 0.01178f
C17956 VPWR hold180/a_326_118# 0.00572f
C17957 _046_ FILLER_19_228/a_40_246# 0
C17958 net34 _400_/a_435_412# 0.00118f
C17959 _191_ _669_/a_1840_334# 0
C17960 fanout32/a_40_152# _235_ 0
C17961 rx_inst.state\[2\] _449_/a_229_118# 0
C17962 _302_ _692_/a_843_236# 0.00111f
C17963 hold113/a_438_182# baud_inst.counter\[29\] 0
C17964 net55 _654_/a_2250_412# 0.03633f
C17965 _651_/a_132_114# _142_ 0
C17966 _230_ _640_/a_843_236# 0
C17967 tx _487_/a_146_122# 0
C17968 baud_inst.counter\[13\] _670_/a_38_114# 0.02597f
C17969 FILLER_18_169/a_40_246# _247_ 0.02841f
C17970 FILLER_24_218/a_40_246# rx_inst.data_reg\[6\] 0.00846f
C17971 _178_ _701_/a_612_127# 0
C17972 tx_inst.data_reg\[6\] net165 0
C17973 net39 _684_/a_38_114# 0
C17974 _080_ net63 0.07304f
C17975 _551_/a_76_160# net105 0
C17976 _463_/a_22_110# clknet_4_15_0_clk 0
C17977 tx_busy _707_/a_843_236# 0.00291f
C17978 _639_/a_298_337# hold73/a_56_118# 0
C17979 net6 _655_/a_843_236# 0.00158f
C17980 _286_ _289_ 0.0031f
C17981 net177 _519_/a_277_118# 0.00163f
C17982 hold136/a_56_118# _087_ 0
C17983 _659_/a_1489_191# clknet_4_4_0_clk 0.00476f
C17984 hold108/a_438_182# net108 0
C17985 _692_/a_1583_191# FILLER_22_22/a_32_246# 0
C17986 net177 hold88/a_326_118# 0.00143f
C17987 _632_/a_298_337# rx_inst.data_reg\[6\] 0
C17988 net155 _657_/a_324_432# 0
C17989 _206_ _657_/a_741_93# 0
C17990 _639_/a_1489_191# _266_ 0
C17991 _690_/a_298_337# baud_inst.counter\[17\] 0
C17992 net32 _442_/a_146_122# 0
C17993 _672_/a_2002_114# _181_ 0
C17994 _658_/a_298_337# VPWR 0.00714f
C17995 hold156/a_56_118# VPWR 0.01413f
C17996 _519_/a_81_118# FILLER_16_56/a_32_246# 0
C17997 hold78/a_438_182# rx_data[1] 0
C17998 _160_ _264_ 0.55243f
C17999 _039_ _681_/a_741_93# 0.0012f
C18000 net116 _681_/a_843_236# 0.00133f
C18001 _637_/a_550_127# net72 0
C18002 hold184/a_56_118# _172_ 0
C18003 _634_/a_324_432# rx_inst.data_reg\[5\] 0
C18004 _313_ _700_/a_550_127# 0
C18005 net76 clknet_4_10_0_clk 0
C18006 _707_/a_1583_191# _121_ 0
C18007 hold177/a_326_118# _684_/a_1583_191# 0.00367f
C18008 _412_/a_120_432# net49 0
C18009 FILLER_7_146/a_32_246# net43 0
C18010 _439_/a_252_412# _251_ 0.00142f
C18011 baud_inst.counter\[21\] _694_/a_324_432# 0.00965f
C18012 _641_/a_843_236# hold176/a_326_118# 0
C18013 _641_/a_741_93# hold176/a_438_182# 0
C18014 clknet_0_clk _385_/a_46_156# 0
C18015 _118_ _705_/a_2250_412# 0
C18016 baud_inst.counter\[27\] FILLER_19_75/a_40_246# 0
C18017 FILLER_5_156/a_32_246# tx_inst.data_reg\[3\] 0
C18018 hold102/a_56_118# _101_ 0
C18019 _691_/a_1785_429# net163 0.00138f
C18020 hold112/a_326_118# _223_ 0
C18021 tx_inst.bit_index\[1\] _070_ 0
C18022 _697_/a_324_432# clknet_4_9_0_clk 0.00522f
C18023 _292_ _520_/a_155_412# 0
C18024 net118 _000_ 0
C18025 tx_inst.bit_index\[2\] hold145/a_56_118# 0.00968f
C18026 _704_/a_324_432# hold51/a_56_118# 0
C18027 net67 hold59/a_326_118# 0.02433f
C18028 clknet_4_4_0_clk _664_/a_612_127# 0.00834f
C18029 _343_/a_257_140# net27 0
C18030 net178 _292_ 0
C18031 _643_/a_741_93# _264_ 0.00576f
C18032 _153_ _458_/a_279_412# 0
C18033 _126_ _061_ 0
C18034 net69 _127_ 0
C18035 _349_/a_146_122# net38 0
C18036 _649_/a_1840_334# _648_/a_2250_412# 0
C18037 _677_/a_2250_412# VPWR 0.0043f
C18038 _430_/a_170_412# _246_ 0.00167f
C18039 input4/a_40_152# tx_data[1] 0.03112f
C18040 hold96/a_326_118# FILLER_8_63/a_40_246# 0
C18041 _530_/a_155_412# _103_ 0.00961f
C18042 _640_/a_132_114# _051_ 0
C18043 _266_ _474_/a_120_432# 0.00505f
C18044 hold159/a_56_118# _070_ 0
C18045 baud_inst.counter\[26\] _311_ 0.02127f
C18046 _177_ baud_inst.counter\[25\] 0.0214f
C18047 _089_ _670_/a_741_93# 0
C18048 _690_/a_843_236# _103_ 0.00337f
C18049 _690_/a_324_432# clknet_4_8_0_clk 0.00569f
C18050 net49 _296_ 0.00123f
C18051 _686_/a_324_432# _685_/a_1583_191# 0
C18052 net87 _687_/a_38_114# 0.00928f
C18053 _686_/a_1583_191# _685_/a_324_432# 0
C18054 hold74/a_56_118# net73 0
C18055 _024_ VPWR 0.14801f
C18056 hold168/a_438_182# _171_ 0
C18057 net179 _200_ 0.03209f
C18058 _425_/a_268_412# _224_ 0.00372f
C18059 _178_ net99 0
C18060 _466_/a_22_110# _650_/a_843_236# 0
C18061 VPWR _247_ 0.05547f
C18062 hold146/a_438_182# _215_ 0
C18063 _228_ FILLER_18_148/a_40_246# 0
C18064 _083_ hold128/a_326_118# 0
C18065 net2 _650_/a_612_127# 0
C18066 FILLER_16_221/a_32_246# net30 0.00298f
C18067 net74 _264_ 0.03245f
C18068 net111 net24 0
C18069 _206_ net170 0.07617f
C18070 _198_ _664_/a_2250_412# 0
C18071 FILLER_12_0/a_32_246# _299_ 0.01983f
C18072 net56 _666_/a_38_114# 0
C18073 _514_/a_257_140# clknet_0_clk 0
C18074 hold51/a_56_118# net19 0.01281f
C18075 net69 _266_ 0
C18076 _019_ FILLER_2_81/a_32_246# 0.00238f
C18077 _119_ VPWR 0.025f
C18078 _038_ net38 0
C18079 _515_/a_76_160# _189_ 0
C18080 net9 _388_/a_59_156# 0
C18081 net31 rx_inst.bit_index\[2\] 0.19497f
C18082 net145 hold137/a_326_118# 0
C18083 _278_ net43 0
C18084 net105 _700_/a_741_93# 0
C18085 hold151/a_438_182# FILLER_26_141/a_40_246# 0
C18086 _155_ _649_/a_1583_191# 0.00192f
C18087 net124 _649_/a_1840_334# 0
C18088 clknet_4_5_0_clk clknet_4_4_0_clk 0.0392f
C18089 _013_ baud_inst.counter\[14\] 0.06419f
C18090 baud_inst.counter\[16\] _014_ 0
C18091 net44 clknet_4_9_0_clk 1.07785f
C18092 _512_/a_279_412# VPWR 0
C18093 fanout30/a_40_152# _153_ 0
C18094 hold163/a_56_118# net49 0.04257f
C18095 _656_/a_324_432# VPWR 0.004f
C18096 _680_/a_324_432# _093_ 0.03024f
C18097 net79 _092_ 0
C18098 _232_ _237_ 0.00122f
C18099 baud_inst.counter\[24\] _308_ 1.47108f
C18100 _178_ hold75/a_438_182# 0
C18101 _672_/a_38_114# hold61/a_56_118# 0.02058f
C18102 net116 _505_/a_76_160# 0
C18103 net92 baud_inst.counter\[5\] 0
C18104 _705_/a_1583_191# VPWR 0.00835f
C18105 _081_ clknet_0_clk 0.01884f
C18106 _680_/a_741_93# _183_ 0
C18107 _680_/a_843_236# baud_inst.counter\[10\] 0
C18108 _534_/a_46_156# _302_ 0.00249f
C18109 rx_inst.data_reg\[0\] clkbuf_4_13_0_clk/a_27_118# 0
C18110 _099_ _686_/a_550_127# 0
C18111 FILLER_16_203/a_32_246# _647_/a_1840_334# 0
C18112 _472_/a_22_110# _272_ 0.00282f
C18113 hold159/a_326_118# clknet_4_1_0_clk 0
C18114 _642_/a_324_432# _697_/a_2250_412# 0
C18115 rx_data[6] net18 0.10514f
C18116 rx_inst.state\[2\] _418_/a_46_156# 0
C18117 hold99/a_326_118# net99 0.00765f
C18118 net12 rx_inst.data_reg\[6\] 0
C18119 hold64/a_56_118# _632_/a_1583_191# 0.00364f
C18120 net12 _632_/a_324_432# 0.00164f
C18121 _226_ _449_/a_229_118# 0.00447f
C18122 _016_ _522_/a_380_412# 0
C18123 _225_ hold180/a_326_118# 0.00176f
C18124 _642_/a_1583_191# _261_ 0
C18125 _248_ hold139/a_326_118# 0
C18126 hold63/a_56_118# _374_/a_244_412# 0
C18127 net36 net180 0
C18128 hold121/a_56_118# hold147/a_56_118# 0
C18129 net79 _033_ 0.05264f
C18130 _206_ _479_/a_120_432# 0.00165f
C18131 _671_/a_550_127# _168_ 0
C18132 _671_/a_1489_191# net62 0.00169f
C18133 clknet_0_clk net130 0
C18134 net48 FILLER_18_210/a_32_246# 0.01829f
C18135 hold110/a_438_182# VPWR 0.00606f
C18136 _078_ _666_/a_741_93# 0
C18137 _186_ _683_/a_741_93# 0.00158f
C18138 net105 hold106/a_56_118# 0.07976f
C18139 hold169/a_438_182# net27 0
C18140 _191_ FILLER_11_134/a_32_246# 0
C18141 _230_ _427_/a_248_122# 0
C18142 _659_/a_1583_191# clknet_0_clk 0
C18143 _695_/a_843_236# VPWR 0.003f
C18144 _032_ _701_/a_1583_191# 0
C18145 net58 _701_/a_2250_412# 0
C18146 net31 _243_ 0.01629f
C18147 net42 _394_/a_120_432# 0
C18148 _213_ net38 0.01898f
C18149 net119 _647_/a_550_127# 0
C18150 net45 FILLER_24_19/a_40_246# 0.0119f
C18151 _128_ clknet_0_clk 0
C18152 _059_ hold127/a_438_182# 0
C18153 _293_ _685_/a_324_432# 0
C18154 _663_/a_843_236# net50 0
C18155 baud_inst.counter\[3\] _504_/a_209_168# 0
C18156 net77 _648_/a_843_236# 0.00549f
C18157 _272_ _648_/a_741_93# 0
C18158 VPWR _701_/a_1489_191# 0
C18159 hold76/a_56_118# FILLER_22_43/a_40_246# 0.00786f
C18160 hold101/a_438_182# net101 0
C18161 hold164/a_326_118# _530_/a_155_412# 0
C18162 net37 _257_ 0.03482f
C18163 FILLER_8_171/a_32_246# _195_ 0.01797f
C18164 _269_ _647_/a_1583_191# 0.00198f
C18165 net149 _106_ 0.05305f
C18166 baud_inst.counter\[3\] hold60/a_56_118# 0.03811f
C18167 hold132/a_438_182# _232_ 0.00143f
C18168 _195_ _218_ 1.19104f
C18169 hold109/a_326_118# net29 0
C18170 hold166/a_326_118# clknet_4_9_0_clk 0
C18171 _233_ _204_ 0
C18172 hold96/a_326_118# VPWR 0.00742f
C18173 baud_inst.counter\[12\] _684_/a_1840_334# 0.00209f
C18174 net128 _684_/a_1583_191# 0
C18175 clknet_4_8_0_clk clknet_0_clk 0.08658f
C18176 hold171/a_438_182# _212_ 0.0035f
C18177 _346_/a_252_412# hold114/a_56_118# 0
C18178 _001_ _666_/a_298_337# 0
C18179 clknet_4_14_0_clk net2 0.02621f
C18180 VPWR _122_ 0.04053f
C18181 _307_ clknet_4_10_0_clk 0
C18182 _431_/a_81_118# clkbuf_4_12_0_clk/a_27_118# 0
C18183 net49 _425_/a_46_156# 0
C18184 _468_/a_22_110# _650_/a_1583_191# 0
C18185 _027_ net113 0
C18186 _307_ _687_/a_843_236# 0
C18187 net44 _686_/a_2250_412# 0.00288f
C18188 baud_inst.counter\[21\] baud_inst.counter\[22\] 0.19083f
C18189 FILLER_8_35/a_32_246# _681_/a_1583_191# 0
C18190 _167_ _247_ 0.60177f
C18191 net55 _655_/a_2250_412# 0.00488f
C18192 hold74/a_56_118# net118 0
C18193 _644_/a_612_127# _134_ 0
C18194 hold59/a_438_182# _702_/a_843_236# 0
C18195 net43 _386_/a_559_412# 0
C18196 net51 _404_/a_268_412# 0
C18197 _186_ _185_ 0.01268f
C18198 _177_ baud_inst.counter\[24\] 0.01993f
C18199 baud_inst.counter\[27\] _309_ 0
C18200 _685_/a_1583_191# clknet_4_9_0_clk 0.00429f
C18201 _636_/a_843_236# hold81/a_56_118# 0
C18202 _227_ _241_ 0
C18203 _636_/a_741_93# hold81/a_326_118# 0
C18204 _170_ hold131/a_438_182# 0
C18205 FILLER_12_171/a_40_246# net43 0
C18206 net2 _639_/a_843_236# 0.00957f
C18207 _156_ _647_/a_132_114# 0
C18208 _642_/a_1840_334# clknet_0_clk 0.00217f
C18209 tx_busy _704_/a_2002_114# 0
C18210 _206_ net11 0
C18211 _549_/a_155_412# baud_inst.counter\[29\] 0
C18212 _663_/a_298_337# net168 0
C18213 _062_ _651_/a_843_236# 0.00181f
C18214 _704_/a_741_93# net43 0
C18215 _356_/a_350_122# _296_ 0
C18216 _684_/a_681_505# clknet_4_2_0_clk 0
C18217 _358_/a_72_436# clknet_0_clk 0
C18218 fanout31/a_40_152# net51 0
C18219 _645_/a_2002_114# _159_ 0
C18220 _155_ hold127/a_438_182# 0
C18221 clknet_4_10_0_clk FILLER_25_25/a_40_246# 0
C18222 _689_/a_741_93# _688_/a_324_432# 0
C18223 rx_inst.state\[3\] baud_inst.counter\[4\] 0.00116f
C18224 _536_/a_192_429# VPWR 0.00719f
C18225 clknet_0_clk _686_/a_1840_334# 0.00144f
C18226 net34 _221_ 0.03093f
C18227 _229_ _260_ 0.00374f
C18228 _646_/a_843_236# FILLER_17_199/a_40_246# 0
C18229 VPWR baud_inst.counter\[25\] 0.48588f
C18230 tx _152_ 0
C18231 _360_/a_382_118# net34 0
C18232 VPWR _669_/a_324_432# 0.0044f
C18233 net82 _124_ 0.67457f
C18234 net55 tx_inst.state\[2\] 0
C18235 _486_/a_358_436# hold180/a_326_118# 0
C18236 _486_/a_115_308# hold180/a_438_182# 0
C18237 _538_/a_277_118# _301_ 0.00167f
C18238 _048_ hold72/a_56_118# 0
C18239 _707_/a_843_236# _704_/a_741_93# 0
C18240 _707_/a_741_93# _704_/a_843_236# 0
C18241 net39 _684_/a_1840_334# 0
C18242 FILLER_0_130/a_32_246# net171 0.00152f
C18243 net6 _655_/a_612_127# 0
C18244 _704_/a_1840_334# net19 0
C18245 _134_ _256_ 0.01878f
C18246 net177 _295_ 0.01251f
C18247 _638_/a_298_337# net65 0
C18248 net55 FILLER_0_174/a_32_246# 0.00152f
C18249 tx_inst.data_reg\[5\] clknet_4_4_0_clk 0.27886f
C18250 baud_inst.counter\[15\] _686_/a_843_236# 0
C18251 baud_inst.counter\[14\] _686_/a_741_93# 0.01913f
C18252 clkbuf_4_5_0_clk/a_27_118# _664_/a_1840_334# 0
C18253 _489_/a_115_308# hold136/a_56_118# 0.00139f
C18254 rx_inst.data_reg\[4\] VPWR 0.0886f
C18255 _678_/a_132_114# net29 0
C18256 _690_/a_1583_191# baud_inst.counter\[17\] 0.00808f
C18257 hold77/a_56_118# net13 0.03185f
C18258 _658_/a_1583_191# VPWR 0.0065f
C18259 _707_/a_298_337# net43 0.00101f
C18260 _644_/a_298_337# clknet_4_14_0_clk 0.00186f
C18261 _044_ _123_ 0.0202f
C18262 _286_ net135 0.0359f
C18263 _519_/a_81_118# baud_inst.counter\[13\] 0
C18264 _228_ _405_/a_27_156# 0
C18265 _061_ _235_ 0
C18266 net37 _416_/a_248_122# 0.00157f
C18267 _048_ net17 0
C18268 clk _706_/a_2250_412# 0
C18269 _171_ _665_/a_298_337# 0
C18270 _499_/a_177_436# _183_ 0.00232f
C18271 _231_ net49 0.02518f
C18272 _523_/a_155_412# clknet_4_2_0_clk 0
C18273 baud_inst.counter\[21\] _694_/a_2250_412# 0
C18274 net53 net52 0
C18275 _656_/a_1489_191# tx_inst.data_reg\[0\] 0.00164f
C18276 hold160/a_438_182# baud_inst.counter\[19\] 0
C18277 _431_/a_81_118# net32 0.01914f
C18278 _472_/a_22_110# _648_/a_298_337# 0
C18279 _292_ _297_ 0
C18280 net106 FILLER_27_46/a_32_246# 0
C18281 clkbuf_4_9_0_clk/a_27_118# FILLER_17_96/a_32_246# 0.00571f
C18282 net69 _461_/a_22_110# 0.00239f
C18283 hold66/a_438_182# _632_/a_741_93# 0.00404f
C18284 clknet_4_4_0_clk _005_ 0.03117f
C18285 _678_/a_38_114# net40 0.02379f
C18286 net27 _651_/a_298_337# 0
C18287 _358_/a_72_436# _182_ 0.03607f
C18288 FILLER_16_56/a_32_246# _014_ 0.02847f
C18289 _643_/a_1785_429# _264_ 0.00308f
C18290 _376_/a_170_160# clknet_0_clk 0
C18291 net177 clknet_4_2_0_clk 0
C18292 _021_ _692_/a_298_337# 0
C18293 net148 _692_/a_324_432# 0
C18294 _374_/a_244_412# clknet_0_clk 0
C18295 net97 clkbuf_4_2_0_clk/a_27_118# 0
C18296 _528_/a_175_118# net103 0
C18297 hold86/a_56_118# hold60/a_438_182# 0.00113f
C18298 _091_ _678_/a_298_337# 0.02517f
C18299 _018_ _103_ 0.23481f
C18300 _264_ _140_ 0
C18301 _164_ clknet_4_8_0_clk 0.51737f
C18302 _266_ _122_ 0.03686f
C18303 _390_/a_382_118# _209_ 0
C18304 _690_/a_612_127# _103_ 0
C18305 _686_/a_741_93# _685_/a_1489_191# 0
C18306 net87 _687_/a_1840_334# 0.00623f
C18307 net27 _166_ 0.09846f
C18308 net74 _269_ 0.12296f
C18309 net71 _637_/a_843_236# 0.00316f
C18310 net45 _701_/a_681_505# 0
C18311 _294_ _684_/a_324_432# 0
C18312 FILLER_15_89/a_32_246# net29 0.00202f
C18313 hold87/a_56_118# _696_/a_324_432# 0.00352f
C18314 _646_/a_38_114# _223_ 0
C18315 net13 _633_/a_741_93# 0.00633f
C18316 hold163/a_56_118# hold121/a_56_118# 0
C18317 net99 net162 0.00355f
C18318 _703_/a_38_114# _313_ 0.00173f
C18319 _246_ net29 0
C18320 hold153/a_326_118# net154 0.01987f
C18321 net2 rx_inst.state\[4\] 0.0057f
C18322 _503_/a_279_412# net95 0.00488f
C18323 net28 _458_/a_279_412# 0
C18324 _076_ tx_inst.state\[2\] 0.02172f
C18325 net2 net119 0
C18326 net44 net164 0.0106f
C18327 hold126/a_326_118# _264_ 0.00767f
C18328 net145 _657_/a_741_93# 0
C18329 hold174/a_326_118# net27 0.06834f
C18330 net58 baud_inst.counter\[29\] 0
C18331 _463_/a_120_432# clknet_0_clk 0
C18332 _386_/a_382_118# _211_ 0.01622f
C18333 net51 _168_ 0.06095f
C18334 net44 _687_/a_741_93# 0.01081f
C18335 net28 _647_/a_298_337# 0
C18336 clknet_4_6_0_clk _668_/a_681_505# 0
C18337 _060_ net32 0
C18338 input9/a_40_152# _146_ 0
C18339 net33 VPWR 0.20229f
C18340 hold161/a_56_118# _101_ 0
C18341 net16 hold119/a_438_182# 0
C18342 net111 net30 0.00763f
C18343 _641_/a_741_93# baud_inst.counter\[25\] 0.00287f
C18344 _675_/a_324_432# FILLER_1_28/a_40_246# 0
C18345 _656_/a_2250_412# VPWR 0.00579f
C18346 hold183/a_56_118# net183 0
C18347 _646_/a_38_114# _240_ 0.00207f
C18348 net45 FILLER_22_86/a_32_246# 0
C18349 _126_ _156_ 0.05324f
C18350 hold164/a_56_118# _692_/a_741_93# 0.00709f
C18351 hold164/a_326_118# _692_/a_324_432# 0
C18352 clknet_4_11_0_clk net46 0.16604f
C18353 _672_/a_324_432# net61 0
C18354 _672_/a_741_93# _033_ 0.00286f
C18355 hold158/a_326_118# baud_inst.counter\[17\] 0
C18356 hold129/a_56_118# VPWR 0.00887f
C18357 baud_inst.counter\[31\] _554_/a_350_122# 0
C18358 _179_ _554_/a_146_122# 0
C18359 hold177/a_326_118# baud_inst.counter\[13\] 0.00297f
C18360 FILLER_1_30/a_32_246# net38 0
C18361 _072_ hold159/a_56_118# 0.00514f
C18362 _198_ FILLER_5_213/a_32_246# 0.00406f
C18363 _697_/a_550_127# net142 0
C18364 _414_/a_165_412# VPWR 0
C18365 net12 _632_/a_2250_412# 0.0521f
C18366 net141 net90 0
C18367 clknet_0_clk _687_/a_324_432# 0
C18368 _661_/a_681_505# _151_ 0
C18369 _661_/a_1840_334# _206_ 0
C18370 _642_/a_2002_114# _261_ 0
C18371 _644_/a_681_505# _170_ 0
C18372 _642_/a_1489_191# _262_ 0
C18373 _655_/a_38_114# clknet_0_clk 0
C18374 hold115/a_56_118# hold116/a_438_182# 0
C18375 hold115/a_438_182# hold116/a_56_118# 0
C18376 hold115/a_326_118# hold116/a_326_118# 0.00134f
C18377 _079_ _374_/a_550_140# 0
C18378 _460_/a_22_110# _650_/a_1583_191# 0
C18379 rx_inst.data_reg\[4\] _266_ 0.02055f
C18380 net28 fanout30/a_40_152# 0
C18381 _388_/a_59_156# net171 0.00294f
C18382 _206_ _006_ 0
C18383 _186_ _683_/a_1785_429# 0.00187f
C18384 _184_ _683_/a_1489_191# 0
C18385 baud_inst.counter\[26\] _108_ 0
C18386 _110_ _686_/a_38_114# 0
C18387 _467_/a_22_110# net84 0.02176f
C18388 _267_ net72 0
C18389 _341_/a_1453_124# net41 0
C18390 net48 _636_/a_741_93# 0
C18391 _128_ _048_ 0
C18392 _076_ _197_ 0
C18393 _059_ _272_ 0.0047f
C18394 VPWR baud_inst.counter\[24\] 0.47254f
C18395 _695_/a_612_127# VPWR 0
C18396 rx_inst.data_reg\[4\] _647_/a_741_93# 0
C18397 _645_/a_843_236# _170_ 0
C18398 _660_/a_1583_191# _660_/a_2250_412# 0
C18399 hold115/a_326_118# net181 0
C18400 FILLER_15_116/a_40_246# net29 0.00631f
C18401 FILLER_17_201/a_32_246# FILLER_17_199/a_40_246# 0.0524f
C18402 net132 _056_ 0.00163f
C18403 _159_ _272_ 0.00312f
C18404 _216_ clkbuf_4_4_0_clk/a_27_118# 0
C18405 net92 clknet_0_clk 0.03313f
C18406 net75 net49 0.0194f
C18407 _240_ _473_/a_120_432# 0.00442f
C18408 hold137/a_56_118# _142_ 0
C18409 _686_/a_324_432# _686_/a_843_236# -0
C18410 _057_ _647_/a_38_114# 0
C18411 net49 net68 0
C18412 _207_ _390_/a_382_118# 0
C18413 net55 _390_/a_559_412# 0.00511f
C18414 _097_ hold109/a_56_118# 0
C18415 baud_inst.counter\[3\] _287_ 0
C18416 baud_inst.counter\[7\] _499_/a_209_168# 0.00143f
C18417 clknet_4_6_0_clk _667_/a_741_93# 0.02444f
C18418 rx_inst.state\[3\] hold123/a_56_118# 0.00175f
C18419 hold102/a_326_118# VPWR 0.00525f
C18420 net77 _648_/a_612_127# 0
C18421 clknet_4_0_0_clk _087_ 0.08927f
C18422 _153_ _417_/a_120_432# 0.00456f
C18423 _275_ _665_/a_1489_191# 0
C18424 output21/a_40_152# _705_/a_324_432# 0
C18425 baud_inst.counter\[1\] hold181/a_56_118# 0.0027f
C18426 net30 _047_ 0.02148f
C18427 _680_/a_1583_191# _289_ 0
C18428 _513_/a_192_429# _180_ 0
C18429 net15 FILLER_19_228/a_40_246# 0.00128f
C18430 baud_inst.counter\[31\] hold114/a_326_118# 0
C18431 baud_inst.counter\[28\] hold114/a_438_182# 0.00177f
C18432 baud_inst.counter\[30\] hold114/a_56_118# 0
C18433 _699_/a_1840_334# _165_ 0
C18434 _700_/a_298_337# net134 0
C18435 net35 _419_/a_154_118# 0.00351f
C18436 _398_/a_115_308# VPWR 0.00606f
C18437 _270_ _650_/a_2250_412# 0
C18438 hold150/a_438_182# _633_/a_38_114# 0
C18439 _635_/a_324_432# _632_/a_741_93# 0
C18440 _635_/a_741_93# _632_/a_324_432# 0
C18441 _307_ _687_/a_612_127# 0
C18442 hold77/a_438_182# VPWR 0.00362f
C18443 net3 _380_/a_382_118# 0.01971f
C18444 net184 net26 0
C18445 net42 _668_/a_38_114# 0
C18446 _081_ net43 0.00303f
C18447 clknet_4_13_0_clk _049_ 0
C18448 net92 _510_/a_248_122# 0
C18449 net33 FILLER_7_234/a_32_246# 0.00524f
C18450 net132 _134_ 0
C18451 hold140/a_56_118# _052_ 0
C18452 rx_data[6] hold71/a_326_118# 0
C18453 rx_inst.state\[2\] _641_/a_1489_191# 0
C18454 VPWR FILLER_15_42/a_40_246# 0.16919f
C18455 _170_ _649_/a_843_236# 0
C18456 net49 _701_/a_324_432# 0.02953f
C18457 _500_/a_257_140# net181 0
C18458 net2 _639_/a_612_127# 0.01493f
C18459 _433_/a_244_140# net139 0
C18460 _156_ _647_/a_1489_191# 0.00556f
C18461 FILLER_25_198/a_32_246# _060_ 0
C18462 hold123/a_438_182# clknet_0_clk 0
C18463 net48 hold81/a_326_118# 0.00354f
C18464 hold68/a_326_118# VPWR 0.00488f
C18465 _027_ baud_inst.counter\[29\] 0.17794f
C18466 hold121/a_438_182# _693_/a_741_93# 0
C18467 hold121/a_326_118# _693_/a_843_236# 0
C18468 _152_ _665_/a_324_432# 0
C18469 _513_/a_435_412# _292_ 0.00415f
C18470 FILLER_16_70/a_40_246# _014_ 0
C18471 net37 _238_ 0
C18472 _062_ _651_/a_612_127# 0.00146f
C18473 net48 _436_/a_244_412# 0
C18474 net92 _182_ 0.06838f
C18475 _689_/a_2250_412# _688_/a_741_93# 0
C18476 _689_/a_1840_334# _688_/a_843_236# 0
C18477 _206_ _392_/a_59_156# 0.0459f
C18478 _432_/a_146_122# net25 0.00503f
C18479 hold71/a_326_118# rx_inst.data_reg\[5\] 0
C18480 _302_ net164 0.40286f
C18481 hold132/a_326_118# _255_ 0.00304f
C18482 _049_ net65 0.16538f
C18483 clk _002_ 0.00118f
C18484 _453_/a_170_412# _451_/a_155_412# 0
C18485 hold155/a_56_118# net38 0
C18486 _169_ rx_inst.state\[4\] 0.05905f
C18487 _234_ VPWR 0.23364f
C18488 _692_/a_1583_191# clknet_4_8_0_clk 0
C18489 clk _146_ 0.07531f
C18490 _190_ fanout29/a_40_152# 0.02688f
C18491 _360_/a_810_118# net34 0
C18492 VPWR _669_/a_2250_412# 0.0072f
C18493 clknet_4_11_0_clk _313_ 0.00434f
C18494 hold52/a_56_118# rx_inst.bit_index\[0\] 0.08561f
C18495 hold113/a_326_118# net46 0.02825f
C18496 hold52/a_326_118# clknet_4_14_0_clk 0.01011f
C18497 baud_inst.counter\[22\] _301_ 0
C18498 _031_ _550_/a_209_168# 0.01254f
C18499 VPWR _633_/a_681_505# 0.00153f
C18500 output13/a_40_152# _158_ 0
C18501 _707_/a_1583_191# _704_/a_1583_191# 0.00926f
C18502 hold170/a_56_118# net55 0.01775f
C18503 _040_ _202_ 0.0012f
C18504 _073_ _203_ 0.0241f
C18505 net6 _145_ 0.89243f
C18506 _467_/a_22_110# _635_/a_741_93# 0
C18507 _219_ _142_ 0.00303f
C18508 baud_inst.counter\[14\] _686_/a_1785_429# 0
C18509 _206_ _068_ 0.17989f
C18510 _632_/a_1583_191# _632_/a_2250_412# -0
C18511 net29 hold95/a_56_118# 0.00714f
C18512 hold97/a_56_118# _292_ 0.01183f
C18513 hold97/a_326_118# net109 0.00141f
C18514 _690_/a_2002_114# baud_inst.counter\[17\] 0
C18515 _658_/a_2002_114# VPWR 0
C18516 _644_/a_1583_191# clknet_4_14_0_clk 0.01166f
C18517 net116 net117 0.29846f
C18518 _143_ _339_/a_382_118# 0.00145f
C18519 _295_ _188_ 0
C18520 net128 baud_inst.counter\[13\] 0.51879f
C18521 rx_inst.state\[2\] _224_ 0.18961f
C18522 _248_ hold180/a_56_118# 0
C18523 _307_ _308_ 0.07676f
C18524 _201_ _275_ 0
C18525 _202_ _006_ 0
C18526 net136 _681_/a_741_93# 0
C18527 _036_ _183_ 0
C18528 _284_ FILLER_12_106/a_40_246# 0
C18529 _158_ net24 0
C18530 _264_ _649_/a_38_114# 0
C18531 _298_ clknet_4_2_0_clk 0.00165f
C18532 net23 VPWR 0.10685f
C18533 _052_ hold176/a_438_182# 0
C18534 net176 hold176/a_326_118# 0
C18535 baud_inst.counter\[28\] _551_/a_76_160# 0.03427f
C18536 baud_inst.counter\[22\] _694_/a_1489_191# 0.01015f
C18537 _673_/a_38_114# _086_ 0.06116f
C18538 net86 net38 0.17167f
C18539 hold98/a_326_118# _681_/a_1840_334# 0
C18540 net26 net169 0.07014f
C18541 hold98/a_438_182# _681_/a_1583_191# 0
C18542 net98 _681_/a_741_93# 0
C18543 FILLER_16_166/a_32_246# _235_ 0
C18544 _314_ clknet_4_8_0_clk 0
C18545 tx_inst.data_reg\[2\] tx_inst.data_reg\[0\] 2.40936f
C18546 _123_ _648_/a_38_114# 0
C18547 clk _656_/a_298_337# 0.03762f
C18548 net21 _120_ 0
C18549 _642_/a_843_236# clknet_4_9_0_clk 0
C18550 _646_/a_324_432# clknet_0_clk 0.03086f
C18551 net69 _638_/a_1489_191# 0
C18552 hold69/a_326_118# net70 0
C18553 FILLER_10_147/a_32_246# tx_inst.bit_index\[2\] 0
C18554 net89 _521_/a_170_412# 0
C18555 hold89/a_438_182# net88 0.01422f
C18556 hold89/a_326_118# _014_ 0.01075f
C18557 hold74/a_438_182# rx_inst.data_reg\[4\] 0
C18558 net74 hold138/a_326_118# 0
C18559 _644_/a_741_93# _242_ 0
C18560 net66 _632_/a_132_114# 0
C18561 _357_/a_354_412# _186_ 0
C18562 _180_ _184_ 0
C18563 net27 _651_/a_1583_191# 0.04671f
C18564 net100 _698_/a_681_505# 0
C18565 _703_/a_741_93# clknet_0_clk 0
C18566 _344_/a_150_412# clknet_0_clk 0
C18567 hold64/a_438_182# _635_/a_1840_334# 0.00107f
C18568 _682_/a_132_114# net117 0
C18569 _682_/a_843_236# baud_inst.counter\[9\] 0
C18570 _436_/a_244_412# _250_ 0.00416f
C18571 FILLER_7_82/a_32_246# _162_ 0
C18572 hold109/a_326_118# _288_ 0.00487f
C18573 rx_inst.bit_index\[0\] _051_ 0
C18574 tx_inst.data_reg\[4\] hold165/a_438_182# 0.00954f
C18575 hold182/a_326_118# _670_/a_298_337# 0
C18576 hold65/a_56_118# _267_ 0.01076f
C18577 hold145/a_326_118# net41 0
C18578 _194_ _176_ 0
C18579 _173_ net27 0
C18580 _343_/a_257_140# _175_ 0
C18581 _686_/a_843_236# clknet_4_9_0_clk 0.00733f
C18582 net37 rx_data[4] 0
C18583 hold77/a_438_182# _266_ 0.00937f
C18584 FILLER_6_205/a_40_246# VPWR 0.1354f
C18585 _636_/a_1840_334# clkbuf_4_13_0_clk/a_27_118# 0
C18586 _059_ _648_/a_298_337# 0.00497f
C18587 _283_ FILLER_7_82/a_32_246# 0.00183f
C18588 net154 _036_ 0
C18589 net71 _637_/a_612_127# 0
C18590 _294_ _684_/a_2250_412# 0
C18591 net13 _633_/a_1785_429# 0
C18592 _021_ hold148/a_438_182# 0.01513f
C18593 hold183/a_438_182# clk 0
C18594 _696_/a_324_432# _544_/a_46_156# 0
C18595 hold66/a_438_182# net66 0.00432f
C18596 hold97/a_438_182# _096_ 0
C18597 baud_inst.counter\[20\] hold121/a_438_182# 0.01827f
C18598 _675_/a_2250_412# FILLER_2_46/a_40_246# 0.01012f
C18599 _159_ _648_/a_298_337# 0.00111f
C18600 _360_/a_382_118# _656_/a_741_93# 0
C18601 _360_/a_71_118# _656_/a_1583_191# 0
C18602 _291_ _282_ 0.0037f
C18603 _632_/a_1489_191# FILLER_21_229/a_32_246# 0
C18604 clkbuf_4_12_0_clk/a_27_118# _257_ 0.00142f
C18605 rx_inst.state\[4\] _084_ 0.04111f
C18606 _002_ _409_/a_167_412# 0
C18607 _268_ clknet_0_clk 0.00182f
C18608 FILLER_25_198/a_32_246# _649_/a_741_93# 0
C18609 net174 _192_ 0
C18610 clkbuf_4_7_0_clk/a_27_118# VPWR 0.1054f
C18611 output20/a_40_152# VPWR 0.00191f
C18612 FILLER_15_162/a_40_246# net29 0.00211f
C18613 _110_ clknet_4_8_0_clk 0
C18614 net36 net37 0
C18615 clknet_4_6_0_clk _668_/a_550_127# 0
C18616 _380_/a_285_412# _208_ 0
C18617 _380_/a_382_118# _150_ 0
C18618 VPWR _504_/a_177_436# 0
C18619 net49 hold105/a_326_118# 0.00172f
C18620 clknet_0_clk _473_/a_22_110# 0.01434f
C18621 hold74/a_326_118# _047_ 0.00297f
C18622 net44 hold91/a_56_118# 0
C18623 VPWR hold60/a_326_118# 0.00928f
C18624 output16/a_40_152# _650_/a_843_236# 0
C18625 tx hold55/a_438_182# 0.01214f
C18626 _646_/a_1840_334# _240_ 0.00469f
C18627 net40 net29 2.69367f
C18628 FILLER_7_121/a_40_246# clknet_0_clk 0
C18629 clknet_4_5_0_clk _215_ 0
C18630 tx_inst.bit_index\[2\] _142_ 0.00675f
C18631 hold169/a_56_118# net168 0.01084f
C18632 _694_/a_681_505# _107_ 0
C18633 net177 FILLER_14_70/a_40_246# 0
C18634 hold136/a_438_182# _279_ 0.00139f
C18635 _002_ net2 0.21717f
C18636 _234_ _167_ 0
C18637 _233_ VPWR 0.13427f
C18638 _053_ _697_/a_1840_334# 0
C18639 _132_ _697_/a_1583_191# 0.00243f
C18640 _028_ FILLER_28_53/a_32_246# 0.00411f
C18641 _089_ clknet_4_2_0_clk 0
C18642 _387_/a_268_412# _212_ 0
C18643 baud_inst.counter\[28\] _700_/a_741_93# 0
C18644 clknet_4_5_0_clk hold146/a_326_118# 0
C18645 _166_ hold50/a_326_118# 0
C18646 rx_inst.state\[2\] _409_/a_269_412# 0.004f
C18647 clknet_4_12_0_clk _131_ 0.06521f
C18648 rx_inst.bit_index\[2\] _262_ 0.00108f
C18649 net28 _405_/a_27_156# 0.00285f
C18650 baud_inst.counter\[18\] _296_ 0.05962f
C18651 net79 tx_data[1] 0
C18652 hold135/a_326_118# VPWR 0.00563f
C18653 _079_ _204_ 0.10013f
C18654 _265_ _650_/a_2250_412# 0.00106f
C18655 VPWR net137 0.41689f
C18656 clknet_4_7_0_clk FILLER_12_208/a_32_246# 0
C18657 hold121/a_56_118# net75 0.00255f
C18658 net121 _537_/a_192_429# 0.00169f
C18659 _155_ _648_/a_298_337# 0
C18660 _186_ _096_ 0.02485f
C18661 _184_ baud_inst.counter\[11\] 0.06362f
C18662 net31 _418_/a_46_156# 0
C18663 _656_/a_843_236# tx_data[6] 0.00162f
C18664 _656_/a_741_93# net9 0.02576f
C18665 net79 _503_/a_279_412# 0
C18666 _228_ net49 0.05183f
C18667 hold113/a_326_118# _313_ 0
C18668 _660_/a_38_114# net54 0.03383f
C18669 _674_/a_550_127# _030_ 0
C18670 _341_/a_1377_160# net41 0
C18671 _111_ net99 0.00109f
C18672 net4 input10/a_40_152# 0.00305f
C18673 _374_/a_244_412# net43 0.02263f
C18674 net76 VPWR 0.03074f
C18675 net182 net40 0.0471f
C18676 FILLER_26_229/a_32_246# VPWR 0.06768f
C18677 rx_inst.data_reg\[4\] _647_/a_1785_429# 0
C18678 baud_inst.counter\[15\] _687_/a_681_505# 0
C18679 baud_inst.counter\[14\] _687_/a_843_236# 0
C18680 _662_/a_324_432# _073_ 0.00732f
C18681 _660_/a_843_236# clknet_4_5_0_clk 0.00703f
C18682 _226_ _224_ 0.47726f
C18683 clknet_0_clk _450_/a_127_96# 0
C18684 _240_ _273_ 0.00753f
C18685 _089_ _676_/a_298_337# 0.0136f
C18686 _057_ _647_/a_1840_334# 0
C18687 baud_inst.counter\[28\] hold106/a_56_118# 0
C18688 clknet_4_7_0_clk net146 0
C18689 _058_ _136_ 0.02427f
C18690 _444_/a_244_412# FILLER_24_156/a_32_246# 0
C18691 clknet_4_3_0_clk _036_ 0
C18692 FILLER_7_121/a_40_246# _386_/a_59_156# 0
C18693 _278_ net123 0
C18694 _411_/a_115_308# _002_ 0
C18695 _489_/a_115_308# clknet_4_0_0_clk 0.00162f
C18696 _692_/a_132_114# net164 0
C18697 _692_/a_681_505# clknet_4_10_0_clk 0
C18698 _680_/a_1489_191# _287_ 0
C18699 _153_ _140_ 0.01713f
C18700 net32 _257_ 0.02797f
C18701 _275_ tx_inst.state\[3\] 0.21799f
C18702 _673_/a_1583_191# _673_/a_2250_412# 0
C18703 _673_/a_741_93# _673_/a_1489_191# 0
C18704 _339_/a_308_118# clknet_4_4_0_clk 0
C18705 net32 _256_ 0
C18706 clknet_4_0_0_clk _681_/a_324_432# 0.01821f
C18707 _643_/a_1583_191# net65 0.01127f
C18708 _689_/a_681_505# _101_ 0
C18709 hold78/a_56_118# net47 0.01705f
C18710 VPWR FILLER_17_199/a_40_246# 0.13638f
C18711 _678_/a_741_93# clknet_4_1_0_clk 0.02947f
C18712 net108 _280_ 0
C18713 _170_ _424_/a_142_412# 0.01017f
C18714 _680_/a_1583_191# net135 0
C18715 _505_/a_76_160# _683_/a_38_114# 0
C18716 _216_ VPWR 0.26047f
C18717 _394_/a_22_110# net27 0.01385f
C18718 _541_/a_209_168# net46 0.00301f
C18719 hold148/a_56_118# clknet_4_10_0_clk 0.06236f
C18720 net85 _632_/a_324_432# 0
C18721 net28 _372_/a_22_110# 0.00207f
C18722 net35 _242_ 0.00537f
C18723 baud_inst.counter\[26\] _697_/a_324_432# 0
C18724 hold153/a_326_118# baud_inst.counter\[5\] 0.00991f
C18725 _284_ _351_/a_268_412# 0
C18726 net49 _701_/a_2250_412# 0.00801f
C18727 clkbuf_4_6_0_clk/a_27_118# _651_/a_1840_334# 0
C18728 _685_/a_38_114# net91 0
C18729 net45 _180_ 0.02509f
C18730 _285_ net86 0
C18731 net2 net81 0.26501f
C18732 _411_/a_358_436# rx_inst.state\[2\] 0.01726f
C18733 _116_ hold59/a_326_118# 0.01071f
C18734 hold101/a_326_118# clknet_4_2_0_clk 0
C18735 net182 _670_/a_38_114# 0
C18736 hold162/a_438_182# _696_/a_741_93# 0
C18737 hold162/a_326_118# _696_/a_843_236# 0
C18738 _637_/a_38_114# VPWR 0.00106f
C18739 input5/a_40_152# net5 0.01001f
C18740 _011_ _292_ 0.07514f
C18741 _698_/a_38_114# _263_ 0
C18742 net109 _684_/a_38_114# 0
C18743 net48 _250_ 0.02741f
C18744 _127_ FILLER_26_229/a_32_246# 0.00129f
C18745 net32 _420_/a_350_122# 0
C18746 net66 _635_/a_324_432# 0
C18747 _270_ _264_ 0.14485f
C18748 hold161/a_326_118# VPWR 0.00692f
C18749 hold164/a_56_118# _021_ 0
C18750 _177_ _554_/a_350_122# 0
C18751 _680_/a_1840_334# baud_inst.counter\[8\] 0
C18752 net158 _688_/a_38_114# 0.03508f
C18753 _689_/a_38_114# net161 0
C18754 _675_/a_681_505# net38 0.00101f
C18755 clknet_4_14_0_clk hold127/a_326_118# 0
C18756 _244_ _424_/a_244_140# 0
C18757 clk FILLER_14_148/a_40_246# 0.00834f
C18758 tx_inst.bit_index\[0\] hold169/a_326_118# 0
C18759 _261_ net175 0.13183f
C18760 _062_ _217_ 0
C18761 _233_ _167_ 0.00658f
C18762 net184 net34 0.5807f
C18763 _224_ _434_/a_252_412# 0
C18764 _707_/a_1840_334# _704_/a_1489_191# 0
C18765 _707_/a_1489_191# _704_/a_1840_334# 0
C18766 net51 _704_/a_741_93# 0
C18767 FILLER_15_116/a_40_246# _670_/a_741_93# 0
C18768 _363_/a_22_110# hold184/a_438_182# 0
C18769 hold142/a_56_118# _696_/a_1489_191# 0
C18770 _515_/a_76_160# clknet_0_clk 0
C18771 rx_data[3] _156_ 0.00151f
C18772 _638_/a_1489_191# _122_ 0
C18773 baud_inst.counter\[4\] _282_ 0.08182f
C18774 net26 _651_/a_2250_412# 0.00388f
C18775 _265_ _639_/a_324_432# 0.02688f
C18776 _676_/a_1583_191# _063_ 0.00109f
C18777 net44 baud_inst.counter\[26\] 0.21945f
C18778 _644_/a_2002_114# clknet_4_14_0_clk 0
C18779 clknet_4_3_0_clk _652_/a_38_114# 0.01408f
C18780 _220_ _667_/a_1583_191# 0
C18781 _527_/a_192_429# _522_/a_209_168# 0
C18782 net30 clknet_4_15_0_clk 0.46026f
C18783 _674_/a_1840_334# _672_/a_38_114# 0
C18784 _674_/a_1583_191# _672_/a_324_432# 0
C18785 _646_/a_298_337# _058_ 0
C18786 net136 _681_/a_1785_429# 0
C18787 hold184/a_56_118# net174 0
C18788 net166 _191_ 0
C18789 net32 _416_/a_248_122# 0.00445f
C18790 FILLER_0_163/a_32_246# VPWR 0.06551f
C18791 _264_ _649_/a_1840_334# 0.00677f
C18792 hold144/a_438_182# _057_ 0.00773f
C18793 clknet_4_0_0_clk _490_/a_45_160# 0.00169f
C18794 baud_inst.counter\[30\] net105 0
C18795 _200_ _665_/a_38_114# 0.03615f
C18796 _491_/a_192_429# FILLER_0_54/a_40_246# 0.00542f
C18797 net79 hold79/a_326_118# 0.03019f
C18798 FILLER_0_117/a_32_246# net171 0
C18799 _662_/a_324_432# net41 0.03173f
C18800 _194_ _276_ 0
C18801 clk _656_/a_1583_191# 0.00886f
C18802 _646_/a_2250_412# clknet_0_clk 0.05215f
C18803 net69 net18 0.07528f
C18804 _550_/a_209_168# _313_ 0.02624f
C18805 clknet_0_clk _435_/a_72_436# 0.0203f
C18806 _645_/a_1489_191# clknet_4_14_0_clk 0.02653f
C18807 net179 _369_/a_146_122# 0
C18808 _485_/a_22_110# _667_/a_132_114# 0
C18809 net27 _651_/a_2002_114# 0
C18810 _190_ _186_ 0.42615f
C18811 net122 _667_/a_741_93# 0.00917f
C18812 net37 _667_/a_324_432# 0.0047f
C18813 _158_ net30 0.1232f
C18814 _029_ hold107/a_438_182# 0.03245f
C18815 net100 _698_/a_550_127# 0
C18816 _707_/a_298_337# net51 0.01172f
C18817 rx_inst.state\[2\] FILLER_19_139/a_40_246# 0.0016f
C18818 tx_inst.data_reg\[6\] clknet_4_4_0_clk 1.15281f
C18819 _534_/a_268_412# clknet_4_10_0_clk 0
C18820 FILLER_15_173/a_40_246# _235_ 0.01465f
C18821 baud_inst.counter\[27\] clknet_0_clk 0.11565f
C18822 hold155/a_438_182# _210_ 0
C18823 _361_/a_248_122# VPWR 0
C18824 _266_ FILLER_17_199/a_40_246# 0
C18825 VPWR _349_/a_146_122# 0
C18826 _177_ hold114/a_326_118# 0.00259f
C18827 baud_inst.counter\[21\] hold147/a_326_118# 0.00173f
C18828 net34 _651_/a_324_432# 0
C18829 _686_/a_612_127# clknet_4_9_0_clk 0
C18830 _307_ VPWR 0.28297f
C18831 _293_ baud_inst.counter\[4\] 0
C18832 _339_/a_295_385# clknet_0_clk 0.00219f
C18833 net27 FILLER_5_192/a_40_246# 0
C18834 _444_/a_142_412# _134_ -0
C18835 _206_ _388_/a_382_118# 0.01554f
C18836 VPWR _666_/a_843_236# 0.00872f
C18837 _527_/a_435_412# _300_ 0.00149f
C18838 net71 net72 0.0168f
C18839 _059_ _648_/a_1583_191# 0
C18840 _677_/a_324_432# _089_ 0
C18841 _261_ _161_ 0.03045f
C18842 _452_/a_257_140# net175 0
C18843 input5/a_40_152# tx_data[2] 0.03267f
C18844 clknet_4_5_0_clk _120_ 0.0221f
C18845 hold158/a_56_118# _101_ 0.00181f
C18846 _696_/a_741_93# _025_ 0.00776f
C18847 hold111/a_56_118# VPWR 0.00597f
C18848 _696_/a_843_236# _310_ 0.05713f
C18849 _680_/a_843_236# FILLER_7_40/a_32_246# 0
C18850 _092_ baud_inst.counter\[6\] 0
C18851 FILLER_18_65/a_40_246# _109_ 0.00355f
C18852 FILLER_17_199/a_40_246# _647_/a_741_93# 0.00104f
C18853 _360_/a_886_118# _656_/a_1840_334# 0
C18854 _363_/a_120_432# net34 0.00922f
C18855 net34 net169 0
C18856 hold55/a_438_182# _665_/a_324_432# 0
C18857 net145 _068_ 1.11295f
C18858 net51 hold51/a_438_182# 0.00398f
C18859 _637_/a_38_114# _266_ 0
C18860 _637_/a_324_432# net30 0
C18861 _528_/a_81_118# _521_/a_170_412# 0
C18862 hold55/a_56_118# _166_ 0
C18863 hold124/a_438_182# rx_inst.data_reg\[5\] 0.01497f
C18864 _113_ VPWR 0.13543f
C18865 net170 _208_ 0.07495f
C18866 VPWR _038_ 0.20028f
C18867 hold173/a_326_118# _222_ 0
C18868 hold173/a_56_118# _141_ 0
C18869 _697_/a_324_432# _109_ 0
C18870 _254_ _242_ 1.03688f
C18871 VPWR FILLER_25_25/a_40_246# 0.17585f
C18872 clknet_4_5_0_clk _664_/a_741_93# 0.00799f
C18873 _175_ hold174/a_326_118# 0.00281f
C18874 clknet_4_7_0_clk _705_/a_298_337# 0
C18875 _082_ net91 0
C18876 net16 _650_/a_1840_334# 0
C18877 rx_data[4] _650_/a_1583_191# 0
C18878 _052_ baud_inst.counter\[25\] 0.09178f
C18879 _271_ rx_inst.data_reg\[5\] 0.00241f
C18880 hold183/a_326_118# tx_inst.bit_index\[1\] 0.00541f
C18881 _699_/a_843_236# _547_/a_81_118# 0
C18882 hold136/a_56_118# _674_/a_843_236# 0
C18883 hold136/a_438_182# _674_/a_324_432# 0
C18884 hold136/a_326_118# _674_/a_741_93# 0
C18885 FILLER_15_127/a_32_246# _669_/a_1840_334# 0
C18886 net2 FILLER_14_148/a_40_246# 0.00451f
C18887 _690_/a_298_337# VPWR 0.00462f
C18888 _256_ FILLER_25_150/a_32_246# 0.01801f
C18889 _493_/a_45_160# net40 0.00149f
C18890 net49 _434_/a_150_412# 0
C18891 _633_/a_1489_191# net30 0.00105f
C18892 hold68/a_56_118# net45 0
C18893 _029_ _694_/a_843_236# 0
C18894 FILLER_27_194/a_40_246# _648_/a_843_236# 0
C18895 _171_ _203_ 0
C18896 _642_/a_741_93# _053_ 0
C18897 _642_/a_38_114# clknet_4_12_0_clk 0.00317f
C18898 _642_/a_324_432# _132_ 0.04438f
C18899 _549_/a_155_412# _312_ 0
C18900 baud_inst.counter\[28\] _700_/a_1785_429# 0.00142f
C18901 hold154/a_438_182# _676_/a_38_114# 0
C18902 net42 net37 0
C18903 hold69/a_56_118# hold71/a_56_118# 0
C18904 hold112/a_326_118# _136_ 0
C18905 net12 rx_data[6] 0.02221f
C18906 net45 net120 0
C18907 rx_data[4] hold84/a_326_118# 0
C18908 net12 hold84/a_56_118# 0
C18909 net60 hold60/a_56_118# 0.05564f
C18910 clknet_0_clk net91 0.03932f
C18911 _155_ _648_/a_1583_191# 0
C18912 net124 _648_/a_1840_334# 0.00745f
C18913 _302_ FILLER_25_36/a_32_246# 0.01921f
C18914 net121 _305_ 0.01647f
C18915 net94 baud_inst.counter\[4\] 0
C18916 net92 net152 0.05503f
C18917 FILLER_17_96/a_32_246# _099_ 0.00138f
C18918 _656_/a_1785_429# net9 0.00377f
C18919 net156 _684_/a_132_114# 0
C18920 _697_/a_38_114# VPWR 0.00129f
C18921 _660_/a_1840_334# net54 0
C18922 tx_inst.data_reg\[4\] tx_inst.data_reg\[0\] 0.0618f
C18923 FILLER_12_117/a_40_246# baud_inst.counter\[4\] 0.03231f
C18924 _223_ _458_/a_279_412# 0
C18925 _164_ FILLER_17_0/a_40_246# 0
C18926 _264_ _471_/a_22_110# 0.00803f
C18927 hold56/a_438_182# _651_/a_324_432# 0
C18928 _485_/a_22_110# net37 0.00142f
C18929 VPWR _453_/a_170_412# 0
C18930 net49 baud_inst.counter\[29\] 0.03231f
C18931 _013_ hold91/a_326_118# 0.0062f
C18932 _223_ _647_/a_298_337# 0
C18933 FILLER_20_65/a_32_246# clkbuf_4_10_0_clk/a_27_118# 0
C18934 _643_/a_324_432# clkbuf_4_15_0_clk/a_27_118# 0
C18935 _662_/a_1583_191# _040_ 0
C18936 baud_inst.counter\[25\] FILLER_20_95/a_40_246# 0.00434f
C18937 _375_/a_170_412# VPWR 0
C18938 net44 _109_ 0.01304f
C18939 hold121/a_56_118# _695_/a_298_337# 0
C18940 VPWR _213_ 0.13807f
C18941 _216_ _400_/a_155_160# 0
C18942 _118_ clknet_0_clk 0
C18943 baud_inst.counter\[14\] hold91/a_326_118# 0
C18944 _265_ _264_ 0.00856f
C18945 hold56/a_326_118# _007_ 0.00194f
C18946 _041_ _483_/a_22_110# 0.00388f
C18947 _696_/a_741_93# FILLER_17_79/a_40_246# 0.00392f
C18948 _554_/a_350_122# VPWR 0
C18949 _705_/a_741_93# _166_ 0
C18950 net48 net143 0
C18951 _677_/a_2250_412# _063_ 0
C18952 _047_ hold73/a_56_118# 0.00138f
C18953 _692_/a_1489_191# net164 0
C18954 _670_/a_1840_334# net29 0.00123f
C18955 net49 _303_ 0
C18956 _673_/a_843_236# clknet_4_1_0_clk 0.00944f
C18957 hold118/a_56_118# net19 0.00135f
C18958 input10/a_40_152# net40 0
C18959 _655_/a_612_127# net181 0
C18960 clknet_4_0_0_clk _681_/a_2250_412# 0.02134f
C18961 _483_/a_120_432# _169_ 0
C18962 _643_/a_324_432# FILLER_21_192/a_40_246# 0
C18963 _689_/a_550_127# _101_ 0
C18964 _189_ _684_/a_741_93# 0.02452f
C18965 _240_ _647_/a_298_337# 0.0021f
C18966 net42 _670_/a_843_236# 0
C18967 _691_/a_324_432# _690_/a_741_93# 0
C18968 _687_/a_298_337# _687_/a_38_114# 0
C18969 _691_/a_741_93# _690_/a_324_432# 0
C18970 hold111/a_326_118# net30 0.00348f
C18971 hold111/a_56_118# _266_ 0.00404f
C18972 _678_/a_1785_429# clknet_4_1_0_clk 0
C18973 _118_ _077_ 0
C18974 net156 _523_/a_257_140# 0.00441f
C18975 _377_/a_46_156# _066_ 0
C18976 tx_inst.data_reg\[7\] hold145/a_326_118# 0.03577f
C18977 hold123/a_326_118# baud_inst.counter\[4\] 0.00428f
C18978 fanout30/a_40_152# _223_ 0.00171f
C18979 output15/a_40_152# net138 0.00154f
C18980 _036_ baud_inst.counter\[5\] 0
C18981 net173 hold57/a_56_118# 0
C18982 FILLER_7_121/a_40_246# net43 0.00193f
C18983 net92 hold115/a_438_182# 0
C18984 _193_ net168 0
C18985 _277_ _235_ 0
C18986 net28 _140_ 0.01125f
C18987 hold171/a_326_118# VPWR 0.00933f
C18988 _109_ _517_/a_380_412# 0
C18989 _170_ net127 0
C18990 _685_/a_1840_334# net91 0
C18991 _270_ _269_ 0.00406f
C18992 _230_ rx_inst.state\[2\] 0.06818f
C18993 hold160/a_438_182# baud_inst.counter\[16\] 0.03502f
C18994 _224_ _455_/a_155_412# 0
C18995 _637_/a_1840_334# VPWR 0
C18996 clknet_4_14_0_clk net77 0.03912f
C18997 net121 _693_/a_1489_191# 0.00609f
C18998 _292_ _684_/a_1583_191# 0.01831f
C18999 _280_ clknet_4_9_0_clk 0
C19000 net32 _238_ 0.17749f
C19001 net111 _054_ 0
C19002 _081_ net51 0.07278f
C19003 baud_inst.counter\[22\] _112_ 0
C19004 net36 _454_/a_257_140# 0.00114f
C19005 _288_ net40 0.01541f
C19006 fanout30/a_40_152# _240_ 0.02677f
C19007 _534_/a_46_156# fanout44/a_40_152# 0
C19008 _448_/a_142_412# _223_ 0
C19009 _675_/a_550_127# net38 0
C19010 FILLER_12_46/a_32_246# _096_ 0
C19011 net29 _682_/a_1785_429# 0
C19012 _118_ _704_/a_298_337# 0
C19013 hold65/a_56_118# net71 0
C19014 net47 _633_/a_298_337# 0
C19015 hold86/a_326_118# net86 0.01166f
C19016 hold86/a_438_182# net181 0
C19017 _688_/a_324_432# _688_/a_741_93# -0
C19018 hold157/a_56_118# net160 0.01105f
C19019 hold114/a_326_118# VPWR 0.00673f
C19020 _092_ _679_/a_843_236# 0
C19021 net2 hold80/a_438_182# 0.00399f
C19022 _482_/a_154_118# _235_ 0
C19023 net28 net49 0.42578f
C19024 FILLER_0_103/a_32_246# _209_ 0
C19025 _098_ _089_ 0
C19026 _652_/a_741_93# net137 0
C19027 baud_inst.counter\[20\] _538_/a_277_118# 0.00112f
C19028 _511_/a_354_412# _183_ 0
C19029 _062_ _667_/a_843_236# 0
C19030 output15/a_40_152# _047_ 0.00116f
C19031 net176 net140 0
C19032 baud_inst.counter\[26\] hold141/a_438_182# 0.00132f
C19033 _225_ _407_/a_146_122# 0.00153f
C19034 _073_ _366_/a_170_412# 0
C19035 _657_/a_324_432# _070_ 0.00691f
C19036 FILLER_5_207/a_32_246# _664_/a_1583_191# 0
C19037 net97 _508_/a_209_168# 0.00725f
C19038 hold153/a_326_118# clknet_0_clk 0
C19039 _650_/a_1840_334# _668_/a_741_93# 0
C19040 _650_/a_1583_191# _668_/a_843_236# 0
C19041 FILLER_0_42/a_32_246# net38 0
C19042 FILLER_2_14/a_40_246# _088_ 0.00413f
C19043 FILLER_2_110/a_32_246# net38 0.01972f
C19044 _500_/a_155_412# _285_ 0.00197f
C19045 _500_/a_257_140# _283_ 0
C19046 _129_ _639_/a_1840_334# 0.00429f
C19047 _265_ _639_/a_2250_412# 0.02165f
C19048 _159_ _056_ 0.00659f
C19049 hold113/a_56_118# _546_/a_192_429# 0
C19050 hold181/a_438_182# _181_ 0
C19051 hold99/a_56_118# _697_/a_1583_191# 0
C19052 clknet_4_1_0_clk FILLER_5_84/a_40_246# 0
C19053 _004_ net2 0
C19054 VPWR FILLER_18_210/a_32_246# 0.08155f
C19055 clknet_4_3_0_clk _652_/a_1840_334# 0.00153f
C19056 _527_/a_192_429# _296_ 0
C19057 _483_/a_120_432# _084_ 0
C19058 _174_ _206_ 0
C19059 hold54/a_56_118# net33 0.01771f
C19060 net42 _667_/a_1489_191# 0
C19061 _013_ _515_/a_272_160# 0.00144f
C19062 net44 _691_/a_843_236# 0.00473f
C19063 _155_ hold70/a_326_118# 0
C19064 _384_/a_59_156# _209_ 0
C19065 _200_ _665_/a_1840_334# 0
C19066 _181_ FILLER_0_54/a_40_246# 0.00456f
C19067 _169_ FILLER_14_148/a_40_246# 0
C19068 hold151/a_438_182# net151 0.02979f
C19069 hold166/a_56_118# VPWR 0.01088f
C19070 _460_/a_120_432# net118 0.00102f
C19071 _515_/a_272_160# baud_inst.counter\[14\] 0
C19072 _112_ FILLER_22_54/a_40_246# 0.00187f
C19073 _132_ clknet_4_9_0_clk 0
C19074 hold131/a_326_118# net150 0
C19075 _055_ _242_ 0
C19076 net31 _224_ 0.64262f
C19077 net55 FILLER_4_100/a_40_246# 0.01002f
C19078 _217_ FILLER_8_191/a_32_246# 0.0054f
C19079 rx_inst.data_reg\[2\] clknet_4_14_0_clk 0.00113f
C19080 _673_/a_324_432# _672_/a_1583_191# 0
C19081 _673_/a_1583_191# _672_/a_324_432# 0
C19082 baud_inst.counter\[6\] hold92/a_326_118# 0.00256f
C19083 hold97/a_326_118# baud_inst.counter\[8\] 0
C19084 net122 _667_/a_1785_429# 0.00246f
C19085 net37 _667_/a_2250_412# 0
C19086 _432_/a_350_122# _246_ 0
C19087 baud_inst.counter\[30\] hold58/a_438_182# 0.00257f
C19088 net79 baud_inst.counter\[2\] 0.00625f
C19089 _664_/a_741_93# _005_ 0
C19090 _664_/a_38_114# tx_inst.state\[2\] 0
C19091 _707_/a_1583_191# net51 0
C19092 _044_ _264_ 0
C19093 input5/a_40_152# _210_ 0
C19094 _655_/a_741_93# net38 0
C19095 _652_/a_38_114# baud_inst.counter\[5\] 0.04011f
C19096 _191_ clknet_4_9_0_clk 0.07385f
C19097 baud_inst.counter\[24\] FILLER_20_95/a_40_246# 0
C19098 FILLER_21_96/a_40_246# net140 0
C19099 rx_data[0] hold69/a_56_118# 0.01977f
C19100 _346_/a_252_412# baud_inst.counter\[28\] 0.00454f
C19101 net174 net168 0.06548f
C19102 net132 FILLER_25_150/a_32_246# 0
C19103 net44 _641_/a_324_432# 0.00465f
C19104 net2 _669_/a_1583_191# 0
C19105 _538_/a_81_118# net75 0
C19106 _675_/a_843_236# baud_inst.counter\[3\] 0
C19107 _339_/a_500_118# clknet_0_clk 0.00121f
C19108 _143_ _652_/a_324_432# 0
C19109 _159_ _134_ 0.03612f
C19110 net79 _673_/a_1489_191# 0
C19111 VPWR _666_/a_612_127# 0.00593f
C19112 _079_ VPWR 0.05498f
C19113 net50 _201_ 0
C19114 _677_/a_2250_412# _089_ 0
C19115 _009_ hold109/a_56_118# 0
C19116 _657_/a_741_93# clknet_4_1_0_clk 0.06084f
C19117 clknet_4_4_0_clk net183 0
C19118 _696_/a_1785_429# _025_ 0.00164f
C19119 _696_/a_612_127# _310_ 0
C19120 _552_/a_155_412# _028_ 0
C19121 net54 _654_/a_741_93# 0
C19122 _360_/a_382_118# _067_ 0
C19123 _360_/a_805_385# clknet_4_4_0_clk 0.00503f
C19124 _360_/a_1453_124# tx_inst.data_reg\[2\] 0.00882f
C19125 _173_ _175_ 0.00299f
C19126 hold153/a_326_118# _182_ 0
C19127 net36 net26 0
C19128 _646_/a_843_236# net48 0.0031f
C19129 baud_inst.counter\[20\] _694_/a_324_432# 0.01756f
C19130 net54 _664_/a_1583_191# 0
C19131 hold109/a_326_118# clknet_4_2_0_clk 0.01625f
C19132 net84 hold84/a_56_118# 0
C19133 clknet_4_11_0_clk hold58/a_56_118# 0.01451f
C19134 clknet_4_5_0_clk _654_/a_132_114# 0
C19135 _658_/a_132_114# _148_ 0
C19136 _660_/a_1840_334# _065_ 0.02694f
C19137 _660_/a_1583_191# _144_ 0.03525f
C19138 _648_/a_843_236# rx_inst.data_reg\[5\] 0
C19139 net51 _671_/a_1840_334# 0
C19140 net55 net9 0.01263f
C19141 _226_ _230_ 0.14619f
C19142 net36 net32 0
C19143 _641_/a_38_114# clknet_0_clk 0.00747f
C19144 hold118/a_56_118# _636_/a_1583_191# 0
C19145 _549_/a_257_140# clknet_0_clk 0.00143f
C19146 hold184/a_438_182# _341_/a_1377_160# 0
C19147 tx_inst.state\[1\] _705_/a_132_114# 0
C19148 clknet_4_7_0_clk _705_/a_1583_191# 0.00325f
C19149 _207_ FILLER_0_103/a_32_246# 0
C19150 FILLER_15_17/a_40_246# _690_/a_324_432# 0
C19151 fanout26/a_40_152# VPWR 0.01813f
C19152 _000_ clknet_0_clk 0
C19153 rx_data[4] _650_/a_2002_114# 0
C19154 hold170/a_56_118# _660_/a_324_432# 0
C19155 net1 VPWR 0.96354f
C19156 net3 _071_ 0.03759f
C19157 _197_ _664_/a_38_114# 0
C19158 _078_ _475_/a_170_412# 0
C19159 _288_ _682_/a_741_93# 0.00214f
C19160 _395_/a_248_122# VPWR 0
C19161 _690_/a_1583_191# VPWR 0.02918f
C19162 _246_ _170_ 0.00962f
C19163 _680_/a_1583_191# hold116/a_56_118# 0
C19164 FILLER_1_30/a_32_246# VPWR 0.06914f
C19165 net31 _235_ 0
C19166 _642_/a_1840_334# clknet_4_12_0_clk 0.00389f
C19167 _642_/a_1583_191# rx_inst.bit_index\[2\] 0
C19168 _642_/a_2250_412# _132_ 0.01551f
C19169 _691_/a_38_114# _692_/a_324_432# 0
C19170 _155_ _134_ 0
C19171 _120_ _199_ 0
C19172 _181_ net135 0.00574f
C19173 net60 _287_ 0.03311f
C19174 net156 _299_ 0.0399f
C19175 rx_inst.data_reg\[3\] rx_inst.data_reg\[0\] 0
C19176 net3 FILLER_0_154/a_40_246# 0.02251f
C19177 clkbuf_4_11_0_clk/a_27_118# _698_/a_1489_191# 0
C19178 _662_/a_843_236# _706_/a_324_432# 0
C19179 _662_/a_741_93# _706_/a_741_93# 0
C19180 _064_ net41 0.00162f
C19181 _266_ FILLER_18_210/a_32_246# 0
C19182 hold64/a_438_182# _264_ 0.00269f
C19183 _244_ _253_ 0
C19184 net55 _384_/a_285_412# 0.00198f
C19185 _155_ _648_/a_2002_114# 0
C19186 FILLER_14_72/a_32_246# net40 0
C19187 _170_ _258_ 0.33322f
C19188 _067_ net9 0.05057f
C19189 _697_/a_1840_334# VPWR 0.00231f
C19190 _660_/a_1489_191# _214_ 0
C19191 rx_inst.data_reg\[0\] _638_/a_38_114# 0
C19192 _672_/a_324_432# net40 0
C19193 hold108/a_326_118# VPWR 0.00622f
C19194 _659_/a_1583_191# _339_/a_71_118# 0.00251f
C19195 net97 FILLER_8_63/a_40_246# 0.00293f
C19196 clknet_4_4_0_clk _653_/a_741_93# 0.02333f
C19197 net153 _162_ 0.00621f
C19198 hold182/a_326_118# net39 0.00518f
C19199 net73 _129_ 0.00133f
C19200 FILLER_19_178/a_40_246# hold139/a_326_118# 0.00204f
C19201 _339_/a_295_385# net43 0.00158f
C19202 net54 _478_/a_229_118# 0
C19203 _116_ _699_/a_2250_412# 0
C19204 _660_/a_38_114# VPWR 0.00845f
C19205 net92 _035_ 0
C19206 _283_ net153 0.05179f
C19207 hold58/a_56_118# _703_/a_1840_334# 0
C19208 clknet_4_11_0_clk _700_/a_1489_191# 0.00426f
C19209 rx net22 0
C19210 _374_/a_244_412# net51 0.00131f
C19211 hold90/a_438_182# net90 0.00423f
C19212 _653_/a_132_114# net137 0
C19213 net102 baud_inst.counter\[16\] 0.00348f
C19214 _661_/a_38_114# clknet_4_1_0_clk 0
C19215 VPWR _700_/a_324_432# 0
C19216 _673_/a_612_127# clknet_4_1_0_clk 0.00712f
C19217 _145_ net181 0.00301f
C19218 _657_/a_132_114# net41 0
C19219 _004_ _169_ 0.04377f
C19220 _691_/a_843_236# _302_ 0
C19221 _691_/a_741_93# _164_ 0
C19222 FILLER_21_165/a_40_246# _257_ 0.00634f
C19223 hold142/a_438_182# baud_inst.counter\[25\] 0.00811f
C19224 net7 FILLER_0_117/a_32_246# 0
C19225 _189_ _684_/a_1785_429# 0
C19226 _240_ _647_/a_1583_191# 0.00634f
C19227 _489_/a_115_308# _093_ 0
C19228 _125_ hold138/a_56_118# 0.00129f
C19229 hold141/a_326_118# VPWR 0.0082f
C19230 _224_ _404_/a_46_156# 0.08569f
C19231 _230_ _434_/a_252_412# -0
C19232 _479_/a_22_110# _006_ 0.00675f
C19233 clknet_4_3_0_clk _653_/a_612_127# 0
C19234 VPWR hold82/a_56_118# 0.05279f
C19235 baud_inst.counter\[26\] _546_/a_341_118# 0
C19236 net128 net29 0.17696f
C19237 FILLER_21_194/a_32_246# _264_ 0
C19238 _093_ _681_/a_324_432# 0
C19239 clknet_0_clk FILLER_23_83/a_32_246# 0
C19240 _400_/a_192_429# clknet_0_clk 0
C19241 _448_/a_244_412# clknet_0_clk 0
C19242 _678_/a_1840_334# _090_ 0
C19243 _678_/a_2250_412# net39 0.0023f
C19244 hold158/a_326_118# VPWR 0.00697f
C19245 _657_/a_843_236# _068_ 0.00385f
C19246 net37 _670_/a_1583_191# 0.00141f
C19247 net133 _700_/a_298_337# 0.01856f
C19248 FILLER_22_86/a_32_246# _025_ 0
C19249 clknet_4_9_0_clk hold91/a_438_182# 0.00247f
C19250 net155 FILLER_0_117/a_32_246# 0
C19251 _531_/a_209_168# _527_/a_192_429# 0
C19252 _178_ _546_/a_192_429# 0
C19253 hold98/a_438_182# net29 0
C19254 _224_ _130_ 0
C19255 _246_ hold139/a_438_182# 0
C19256 net49 _440_/a_244_140# 0
C19257 _171_ FILLER_6_191/a_32_246# 0
C19258 clknet_4_4_0_clk _652_/a_1583_191# 0
C19259 net156 _187_ 0.06259f
C19260 clkbuf_4_8_0_clk/a_27_118# clknet_0_clk 0.05454f
C19261 _644_/a_38_114# FILLER_26_151/a_32_246# 0
C19262 _694_/a_741_93# _693_/a_2250_412# 0.00387f
C19263 _645_/a_741_93# net150 0
C19264 net131 _633_/a_38_114# 0.00329f
C19265 _240_ FILLER_20_198/a_40_246# 0.00274f
C19266 output14/a_40_152# FILLER_29_221/a_32_246# 0.00401f
C19267 baud_inst.counter\[17\] _688_/a_1489_191# 0.01596f
C19268 _170_ _444_/a_244_412# 0
C19269 _160_ _223_ 0.00714f
C19270 hold168/a_326_118# _076_ 0
C19271 clknet_4_14_0_clk _253_ 0
C19272 _143_ _653_/a_681_505# 0
C19273 _162_ _280_ 0.27869f
C19274 net182 net128 0
C19275 net47 _633_/a_1583_191# 0.00262f
C19276 net36 hold175/a_438_182# 0
C19277 _488_/a_177_436# _287_ 0
C19278 _092_ _679_/a_612_127# 0
C19279 net48 FILLER_17_201/a_32_246# 0.00202f
C19280 hold65/a_56_118# _273_ 0.03486f
C19281 hold155/a_56_118# VPWR 0.04764f
C19282 clknet_4_8_0_clk _687_/a_1489_191# 0.00214f
C19283 _545_/a_248_122# _310_ 0
C19284 _283_ _280_ 0.09195f
C19285 _118_ net43 0.52252f
C19286 baud_inst.counter\[20\] baud_inst.counter\[22\] 0.37509f
C19287 _071_ _150_ 0.01355f
C19288 hold184/a_326_118# _217_ 0
C19289 hold184/a_56_118# _218_ 0.00115f
C19290 _036_ clknet_0_clk 0.00552f
C19291 hold184/a_438_182# _195_ 0.00379f
C19292 _668_/a_298_337# rx_inst.state\[4\] 0.002f
C19293 _013_ VPWR 0.0672f
C19294 clkbuf_4_1_0_clk/a_27_118# net137 0.06124f
C19295 _640_/a_324_432# net100 0
C19296 _641_/a_1583_191# _261_ 0.00306f
C19297 FILLER_8_35/a_32_246# _288_ 0.00133f
C19298 FILLER_13_137/a_32_246# net122 0
C19299 _061_ _668_/a_38_114# 0
C19300 _646_/a_2250_412# clkbuf_4_13_0_clk/a_27_118# 0
C19301 rx_inst.bit_index\[1\] _242_ 0.04917f
C19302 net40 _682_/a_550_127# 0
C19303 _300_ _522_/a_209_168# 0
C19304 _526_/a_350_122# _296_ 0
C19305 _687_/a_741_93# _540_/a_45_160# 0
C19306 net44 FILLER_20_106/a_32_246# 0.00402f
C19307 hold116/a_438_182# VPWR 0.00376f
C19308 baud_inst.counter\[14\] VPWR 0.21423f
C19309 hold144/a_326_118# _223_ 0.00289f
C19310 _019_ net6 0
C19311 net92 _286_ 1.03217f
C19312 _090_ net29 0
C19313 net67 _702_/a_324_432# 0.05005f
C19314 _160_ _240_ 0.02006f
C19315 net60 clkbuf_4_0_0_clk/a_27_118# 0.00217f
C19316 _223_ _417_/a_120_432# 0
C19317 _206_ _658_/a_324_432# 0
C19318 net155 _658_/a_38_114# 0
C19319 _080_ FILLER_11_134/a_32_246# 0.00135f
C19320 hold149/a_438_182# clknet_4_10_0_clk 0
C19321 net31 FILLER_23_158/a_40_246# 0
C19322 baud_inst.counter\[2\] _672_/a_741_93# 0
C19323 _674_/a_843_236# clknet_4_0_0_clk 0.03896f
C19324 _004_ _084_ 0.03287f
C19325 hold102/a_326_118# net157 0
C19326 _636_/a_741_93# VPWR 0.0161f
C19327 net44 _691_/a_612_127# 0.00353f
C19328 _230_ FILLER_19_149/a_40_246# 0.00127f
C19329 _632_/a_843_236# _264_ 0.03139f
C19330 _654_/a_324_432# _144_ 0.00732f
C19331 _654_/a_741_93# _065_ 0.00219f
C19332 _654_/a_298_337# tx_inst.data_reg\[0\] 0
C19333 hold96/a_438_182# _092_ 0.00159f
C19334 net97 VPWR 0.31208f
C19335 _265_ _153_ 0.00353f
C19336 _129_ net118 0.39992f
C19337 _065_ _664_/a_1583_191# 0
C19338 tx_inst.data_reg\[0\] _664_/a_843_236# 0
C19339 VPWR net86 0.29345f
C19340 _673_/a_1840_334# _672_/a_1840_334# 0
C19341 _467_/a_22_110# FILLER_19_228/a_40_246# 0
C19342 _661_/a_843_236# net41 0
C19343 _664_/a_1840_334# tx_inst.state\[2\] 0.00808f
C19344 _692_/a_681_505# VPWR 0
C19345 baud_inst.counter\[10\] _505_/a_76_160# 0
C19346 _374_/a_550_140# _204_ 0
C19347 net87 _684_/a_324_432# 0
C19348 _643_/a_741_93# _240_ 0
C19349 clknet_4_6_0_clk rx_inst.state\[4\] 1.30028f
C19350 clknet_4_8_0_clk _520_/a_155_412# 0
C19351 _303_ FILLER_24_4/a_40_246# 0
C19352 VPWR FILLER_0_128/a_40_246# 0.12409f
C19353 _046_ rx_inst.data_reg\[0\] 0.00344f
C19354 hold144/a_326_118# _240_ 0
C19355 _655_/a_1785_429# net38 0
C19356 _422_/a_146_122# _140_ 0
C19357 hold66/a_56_118# _264_ 0.05066f
C19358 baud_inst.counter\[28\] baud_inst.counter\[30\] 1.10529f
C19359 _663_/a_324_432# _666_/a_1583_191# 0.00107f
C19360 _292_ baud_inst.counter\[13\] 0.11747f
C19361 net48 FILLER_29_179/a_40_246# 0.00324f
C19362 _698_/a_2250_412# FILLER_22_86/a_32_246# 0.01061f
C19363 _686_/a_681_505# net91 0
C19364 output19/a_40_152# net30 0.00341f
C19365 baud_inst.counter\[21\] _305_ 2.26874f
C19366 _143_ _652_/a_2250_412# 0
C19367 VPWR _685_/a_1489_191# 0
C19368 net16 FILLER_16_203/a_32_246# 0.02166f
C19369 _264_ _648_/a_38_114# 0.0017f
C19370 _032_ _551_/a_76_160# 0
C19371 _556_/a_192_429# _314_ 0.02784f
C19372 _657_/a_1785_429# clknet_4_1_0_clk 0
C19373 VPWR _689_/a_1489_191# 0.00312f
C19374 _191_ _162_ 0.10161f
C19375 hold148/a_56_118# VPWR 0.01332f
C19376 _224_ net62 0.01535f
C19377 _659_/a_324_432# VPWR 0
C19378 net27 _479_/a_120_432# 0.00623f
C19379 _036_ _182_ 0
C19380 _024_ _310_ 0
C19381 hold157/a_438_182# clknet_4_2_0_clk 0
C19382 _315_ _028_ 0.09576f
C19383 tx_inst.bit_index\[1\] _656_/a_1489_191# 0
C19384 _360_/a_1377_160# tx_inst.data_reg\[2\] 0.0287f
C19385 _360_/a_308_118# clknet_4_4_0_clk 0
C19386 _516_/a_279_412# net29 0
C19387 FILLER_13_102/a_32_246# _685_/a_1583_191# 0
C19388 net2 _404_/a_268_412# 0
C19389 _079_ _486_/a_358_436# 0
C19390 _538_/a_81_118# _695_/a_298_337# 0
C19391 baud_inst.counter\[20\] _694_/a_2250_412# 0
C19392 hold142/a_438_182# baud_inst.counter\[24\] 0
C19393 _242_ FILLER_22_152/a_32_246# 0
C19394 _658_/a_1489_191# _148_ 0
C19395 _660_/a_550_127# tx_inst.data_reg\[0\] 0
C19396 output14/a_40_152# hold83/a_56_118# 0.00117f
C19397 _641_/a_1840_334# clknet_0_clk 0.00241f
C19398 _645_/a_324_432# _440_/a_244_412# 0
C19399 _698_/a_741_93# net99 0
C19400 _698_/a_38_114# baud_inst.counter\[25\] 0
C19401 clknet_4_7_0_clk _705_/a_2002_114# 0
C19402 _083_ _003_ 0.0011f
C19403 VPWR hold81/a_326_118# 0.0065f
C19404 _634_/a_38_114# clknet_4_15_0_clk 0
C19405 hold155/a_438_182# net159 0
C19406 fanout31/a_40_152# net2 0
C19407 input4/a_40_152# baud_inst.counter\[0\] 0
C19408 tx_inst.data_reg\[6\] _660_/a_843_236# 0.03915f
C19409 VPWR _664_/a_298_337# 0.00734f
C19410 _222_ _476_/a_146_122# 0
C19411 _646_/a_2250_412# hold143/a_326_118# 0.00119f
C19412 _646_/a_1840_334# hold143/a_438_182# 0
C19413 _646_/a_843_236# net143 0
C19414 _114_ _535_/a_248_122# 0
C19415 _206_ _656_/a_843_236# 0.00177f
C19416 VPWR _436_/a_244_412# 0.00115f
C19417 baud_inst.counter\[22\] _701_/a_298_337# 0.00354f
C19418 baud_inst.counter\[23\] _701_/a_38_114# 0
C19419 hold86/a_56_118# _085_ 0
C19420 hold86/a_326_118# net38 0
C19421 FILLER_5_164/a_40_246# _360_/a_886_118# 0
C19422 _288_ _682_/a_1785_429# 0.00324f
C19423 _690_/a_2002_114# VPWR 0.00113f
C19424 _699_/a_1785_429# net113 0
C19425 _678_/a_843_236# _677_/a_843_236# 0
C19426 net42 net26 0.72357f
C19427 net16 net73 0.00329f
C19428 _691_/a_741_93# _692_/a_1583_191# 0
C19429 clknet_0_clk _647_/a_1840_334# 0.00191f
C19430 _691_/a_324_432# _692_/a_1840_334# 0
C19431 FILLER_25_198/a_32_246# _648_/a_741_93# 0
C19432 _089_ hold129/a_56_118# 0
C19433 net14 _634_/a_298_337# 0
C19434 output14/a_40_152# _634_/a_741_93# 0.0011f
C19435 clknet_4_14_0_clk _444_/a_550_140# 0
C19436 hold123/a_438_182# net123 0
C19437 hold101/a_438_182# net156 0
C19438 _244_ FILLER_24_156/a_32_246# 0
C19439 net173 _172_ 0
C19440 tx_inst.state\[4\] VPWR 0.13802f
C19441 clkbuf_4_15_0_clk/a_27_118# _649_/a_298_337# 0
C19442 VPWR _546_/a_155_160# 0
C19443 _680_/a_843_236# hold115/a_326_118# 0
C19444 net55 net171 1.67143f
C19445 _699_/a_741_93# baud_inst.counter\[29\] 0.00239f
C19446 _228_ net25 0.00195f
C19447 _636_/a_741_93# _266_ 0
C19448 _636_/a_843_236# net30 0.01517f
C19449 clknet_4_14_0_clk _648_/a_132_114# 0
C19450 net45 hold114/a_56_118# 0
C19451 tx_inst.bit_index\[0\] _651_/a_1489_191# 0
C19452 _642_/a_741_93# VPWR 0.03448f
C19453 VPWR _387_/a_46_156# 0.00353f
C19454 _672_/a_1840_334# _086_ 0
C19455 _672_/a_2250_412# net40 0.00189f
C19456 _343_/a_257_140# clknet_4_4_0_clk 0
C19457 net29 rx_inst.state\[4\] 0.70022f
C19458 _054_ clknet_4_15_0_clk 0.00782f
C19459 hold162/a_326_118# baud_inst.counter\[25\] 0.00174f
C19460 net33 _665_/a_1583_191# 0.01845f
C19461 net62 _235_ 0
C19462 _403_/a_22_110# clkbuf_4_4_0_clk/a_27_118# 0
C19463 _513_/a_192_429# net108 0
C19464 input2/a_40_152# _121_ 0
C19465 _412_/a_22_110# net37 0
C19466 rx_inst.data_reg\[0\] _043_ 0.02679f
C19467 net54 _364_/a_257_140# 0
C19468 net37 fanout32/a_40_152# 0.00171f
C19469 _643_/a_550_127# clknet_4_15_0_clk 0
C19470 _671_/a_741_93# VPWR 0.0211f
C19471 _529_/a_45_160# _301_ 0.04706f
C19472 _672_/a_298_337# _672_/a_324_432# -0
C19473 net42 hold62/a_326_118# 0
C19474 hold131/a_326_118# _158_ 0.00915f
C19475 _660_/a_1840_334# VPWR 0.00612f
C19476 hold182/a_438_182# _676_/a_741_93# 0
C19477 hold182/a_326_118# _676_/a_843_236# 0
C19478 _405_/a_229_118# clknet_0_clk 0
C19479 hold143/a_438_182# _273_ 0
C19480 net34 _401_/a_120_432# 0.00406f
C19481 hold56/a_326_118# _195_ 0.00459f
C19482 _188_ FILLER_15_42/a_40_246# 0
C19483 VPWR _686_/a_741_93# 0.01465f
C19484 _637_/a_298_337# _634_/a_741_93# 0
C19485 net65 _649_/a_550_127# 0
C19486 clknet_4_5_0_clk _196_ 0
C19487 _083_ _670_/a_132_114# 0
C19488 _249_ _435_/a_72_436# 0.05684f
C19489 _534_/a_268_412# VPWR 0
C19490 net14 net47 0.00131f
C19491 _652_/a_38_114# _182_ 0
C19492 baud_inst.counter\[30\] _703_/a_843_236# 0.00106f
C19493 baud_inst.counter\[31\] _703_/a_681_505# 0
C19494 _179_ _703_/a_741_93# 0
C19495 net111 _257_ 0
C19496 _067_ net171 0
C19497 tx_data[0] _388_/a_382_118# 0.01552f
C19498 net3 _388_/a_59_156# 0
C19499 _661_/a_1840_334# clknet_4_1_0_clk 0
C19500 _402_/a_154_118# _274_ 0
C19501 VPWR _700_/a_2250_412# 0.00571f
C19502 baud_inst.counter\[27\] _347_/a_248_122# 0
C19503 _097_ baud_inst.counter\[12\] 0
C19504 _657_/a_1489_191# net41 0
C19505 hold104/a_438_182# net103 0
C19506 _240_ _647_/a_2002_114# 0
C19507 VPWR clkbuf_4_2_0_clk/a_27_118# 0.01386f
C19508 _691_/a_324_432# _103_ 0
C19509 _691_/a_298_337# clknet_4_8_0_clk 0
C19510 clknet_4_8_0_clk baud_inst.counter\[19\] 0.01899f
C19511 _640_/a_298_337# clknet_4_14_0_clk 0.00129f
C19512 _000_ net43 0
C19513 _044_ hold78/a_326_118# 0.00957f
C19514 _694_/a_1840_334# _701_/a_38_114# 0
C19515 _101_ _688_/a_681_505# 0
C19516 _178_ clknet_4_8_0_clk 0.008f
C19517 _646_/a_324_432# clknet_4_12_0_clk 0.0406f
C19518 hold169/a_326_118# _666_/a_38_114# 0
C19519 hold169/a_438_182# _666_/a_298_337# 0
C19520 _494_/a_279_412# net40 0.00104f
C19521 VPWR hold72/a_438_182# 0.00317f
C19522 hold159/a_326_118# _209_ 0.01304f
C19523 _093_ _681_/a_2250_412# 0.00135f
C19524 hold76/a_438_182# baud_inst.counter\[23\] 0
C19525 hold76/a_326_118# baud_inst.counter\[22\] 0.00889f
C19526 net153 clkbuf_4_3_0_clk/a_27_118# 0
C19527 net48 FILLER_18_169/a_40_246# 0.01875f
C19528 _657_/a_612_127# _068_ 0
C19529 _246_ _433_/a_550_140# 0
C19530 _635_/a_1840_334# hold84/a_438_182# 0.00197f
C19531 _097_ net88 0
C19532 baud_inst.counter\[13\] FILLER_12_106/a_40_246# 0
C19533 net2 _168_ 0.05346f
C19534 net133 _700_/a_1583_191# 0
C19535 hold132/a_438_182# _444_/a_244_412# 0
C19536 tx_inst.data_reg\[0\] FILLER_2_208/a_40_246# 0.00127f
C19537 _378_/a_59_156# _209_ 0.04143f
C19538 _117_ FILLER_13_228/a_40_246# 0
C19539 _423_/a_165_412# clknet_0_clk 0
C19540 hold133/a_438_182# _700_/a_843_236# 0.00148f
C19541 net30 hold81/a_438_182# 0.03126f
C19542 net37 _456_/a_257_140# 0.00304f
C19543 hold162/a_438_182# _180_ 0.03547f
C19544 FILLER_26_229/a_32_246# net18 0.00111f
C19545 _522_/a_209_168# net160 0.00599f
C19546 hold166/a_326_118# clkbuf_0_clk/a_116_82# 0.00514f
C19547 _227_ fanout28/a_40_152# 0.00536f
C19548 clknet_4_11_0_clk _703_/a_324_432# 0.03214f
C19549 net35 FILLER_23_186/a_40_246# 0
C19550 _295_ net40 0
C19551 hold119/a_56_118# net119 0.00297f
C19552 _650_/a_741_93# _650_/a_1583_191# -0
C19553 hold119/a_326_118# _061_ 0.00216f
C19554 _107_ _693_/a_324_432# 0.00311f
C19555 _663_/a_741_93# clknet_0_clk 0.02388f
C19556 _645_/a_1785_429# net150 0
C19557 clknet_4_14_0_clk FILLER_24_156/a_32_246# 0
C19558 _499_/a_209_168# baud_inst.counter\[4\] 0
C19559 _499_/a_177_436# net152 0.00138f
C19560 _643_/a_843_236# clknet_0_clk 0.04f
C19561 net31 _230_ 1.54611f
C19562 _119_ _203_ 0.0343f
C19563 _167_ _436_/a_244_412# 0.0395f
C19564 net32 _159_ 0
C19565 _143_ _653_/a_550_127# 0
C19566 hold153/a_326_118# net152 0
C19567 hold153/a_56_118# baud_inst.counter\[4\] 0.00436f
C19568 _170_ FILLER_18_160/a_32_246# 0
C19569 _675_/a_681_505# VPWR 0.00173f
C19570 _688_/a_38_114# net161 0.03196f
C19571 _680_/a_550_127# net38 0
C19572 _092_ net96 0.07161f
C19573 tx tx_start 0.11133f
C19574 _404_/a_268_412# _169_ 0
C19575 hold121/a_438_182# _022_ 0
C19576 _698_/a_324_432# net140 0
C19577 _641_/a_38_114# _110_ 0
C19578 _641_/a_298_337# net142 0
C19579 baud_inst.counter\[25\] _310_ 0.21913f
C19580 _063_ net137 0
C19581 _097_ net39 0.01703f
C19582 clknet_4_12_0_clk _473_/a_22_110# 0.03049f
C19583 _642_/a_741_93# _641_/a_741_93# 0
C19584 _642_/a_324_432# _641_/a_843_236# 0
C19585 _660_/a_1583_191# net179 0.00377f
C19586 net16 net118 0
C19587 hold119/a_438_182# _264_ 0.00113f
C19588 _641_/a_1489_191# _262_ 0.00437f
C19589 net108 _184_ 0.02694f
C19590 _390_/a_285_118# net38 0.00122f
C19591 hold159/a_326_118# _069_ 0
C19592 _680_/a_681_505# net38 0
C19593 net40 clknet_4_2_0_clk 0.48695f
C19594 _300_ _296_ 0.02999f
C19595 _411_/a_358_436# net62 0
C19596 _687_/a_843_236# _308_ 0
C19597 _060_ clknet_4_15_0_clk 0.0615f
C19598 _064_ tx_inst.data_reg\[7\] 0
C19599 clknet_4_6_0_clk net168 0.00454f
C19600 _671_/a_2250_412# _459_/a_27_156# 0
C19601 net67 _702_/a_2250_412# 0
C19602 fanout31/a_40_152# _169_ 0
C19603 _223_ _140_ 0.00387f
C19604 clknet_4_7_0_clk net23 0.02635f
C19605 _699_/a_1840_334# net99 0
C19606 _674_/a_612_127# clknet_4_0_0_clk 0.0101f
C19607 _662_/a_741_93# _200_ 0
C19608 net178 _688_/a_843_236# 0
C19609 _127_ hold72/a_438_182# 0
C19610 FILLER_8_118/a_32_246# VPWR 0.06793f
C19611 fanout34/a_40_152# _220_ 0
C19612 _632_/a_612_127# _264_ 0.00489f
C19613 _654_/a_1583_191# tx_inst.data_reg\[0\] 0.00457f
C19614 hold101/a_438_182# hold102/a_56_118# 0
C19615 _671_/a_741_93# _167_ 0
C19616 hold115/a_56_118# VPWR 0.00474f
C19617 hold154/a_326_118# net154 0.00389f
C19618 net48 VPWR 2.36804f
C19619 _679_/a_38_114# net29 0
C19620 FILLER_8_171/a_32_246# net168 0
C19621 _642_/a_324_432# _260_ 0
C19622 FILLER_18_169/a_40_246# _250_ 0.00159f
C19623 _217_ _200_ 0.00252f
C19624 VPWR FILLER_7_210/a_40_246# 0.14438f
C19625 hold148/a_438_182# _106_ 0.00452f
C19626 _673_/a_741_93# baud_inst.counter\[0\] 0
C19627 _673_/a_843_236# clknet_4_0_0_clk 0
C19628 clkbuf_4_3_0_clk/a_27_118# _280_ 0.06628f
C19629 _160_ _447_/a_81_118# 0
C19630 _265_ hold80/a_56_118# 0
C19631 hold162/a_326_118# baud_inst.counter\[24\] 0.01391f
C19632 _692_/a_550_127# VPWR 0
C19633 _379_/a_46_156# net41 0.01623f
C19634 _512_/a_165_412# baud_inst.counter\[9\] 0
C19635 _678_/a_550_127# baud_inst.counter\[6\] 0
C19636 clknet_4_8_0_clk _297_ 0.00409f
C19637 rx_data[4] FILLER_16_221/a_32_246# 0
C19638 clk FILLER_7_146/a_32_246# 0.00324f
C19639 _486_/a_494_160# net166 0
C19640 _691_/a_38_114# hold164/a_438_182# 0
C19641 _691_/a_324_432# hold164/a_326_118# 0
C19642 net12 net69 0.00197f
C19643 rx_inst.state\[2\] net180 0.49352f
C19644 _240_ _140_ 0.37259f
C19645 net108 FILLER_9_72/a_32_246# 0.01264f
C19646 _663_/a_741_93# _666_/a_1489_191# 0.00158f
C19647 _663_/a_1583_191# _666_/a_2250_412# 0
C19648 net49 _223_ 0.04276f
C19649 clkload1/Y VPWR 0.09869f
C19650 _686_/a_550_127# net91 0
C19651 _316_ _314_ 0
C19652 rx_inst.bit_index\[2\] _450_/a_127_436# 0.00478f
C19653 _264_ _648_/a_1840_334# 0.02856f
C19654 _378_/a_59_156# _207_ 0.06228f
C19655 net48 _239_ 0
C19656 _068_ clknet_4_1_0_clk 0.03439f
C19657 net42 net50 0
C19658 VPWR baud_inst.counter\[17\] 0.4713f
C19659 _135_ net24 0
C19660 _180_ _025_ 0.01346f
C19661 net60 net181 0.13741f
C19662 hold160/a_56_118# baud_inst.counter\[18\] 0.00187f
C19663 _644_/a_843_236# _158_ 0.00636f
C19664 _045_ FILLER_28_204/a_32_246# 0.00193f
C19665 _659_/a_2250_412# VPWR 0.0031f
C19666 net27 _006_ 0.05774f
C19667 net45 _700_/a_38_114# 0.00275f
C19668 net173 FILLER_5_156/a_32_246# 0
C19669 FILLER_20_177/a_32_246# net25 0
C19670 net54 _065_ 0.00491f
C19671 tx_inst.bit_index\[1\] tx_inst.data_reg\[2\] 0.06457f
C19672 net184 _067_ 0
C19673 hold168/a_56_118# clknet_0_clk 0.00104f
C19674 clknet_4_7_0_clk clkbuf_4_7_0_clk/a_27_118# 0.06058f
C19675 output20/a_40_152# clknet_4_7_0_clk 0
C19676 output19/a_40_152# _647_/a_2250_412# 0
C19677 hold130/a_438_182# fanout29/a_40_152# 0
C19678 baud_inst.counter\[21\] _695_/a_38_114# 0.00583f
C19679 net13 _463_/a_120_432# 0
C19680 net144 net48 0.41942f
C19681 hold161/a_326_118# net157 0.00985f
C19682 net8 _384_/a_285_118# 0
C19683 _500_/a_155_412# VPWR 0.07691f
C19684 tx_data[3] input7/a_40_152# 0
C19685 clknet_4_5_0_clk tx_inst.data_reg\[0\] 0.08558f
C19686 output21/a_40_152# _077_ 0
C19687 hold98/a_326_118# net116 0
C19688 hold98/a_56_118# _039_ 0.00342f
C19689 hold98/a_438_182# _288_ 0.00609f
C19690 _699_/a_1583_191# _180_ 0.00389f
C19691 net49 _240_ 0
C19692 net36 hold180/a_438_182# 0
C19693 _304_ fanout45/a_40_152# 0
C19694 net16 hold138/a_56_118# 0
C19695 _645_/a_741_93# _158_ 0
C19696 net35 net52 0
C19697 _698_/a_1840_334# baud_inst.counter\[25\] 0
C19698 _654_/a_741_93# VPWR 0.00564f
C19699 tx_inst.state\[1\] net22 0.03383f
C19700 _634_/a_1840_334# clknet_4_15_0_clk 0.00457f
C19701 FILLER_24_133/a_32_246# _236_ 0
C19702 net36 FILLER_21_165/a_40_246# 0
C19703 tx_inst.data_reg\[6\] _660_/a_612_127# 0.00589f
C19704 VPWR _664_/a_1583_191# 0.00988f
C19705 tx_inst.data_reg\[1\] _211_ 0.00989f
C19706 _222_ _274_ 0.00405f
C19707 _663_/a_324_432# _215_ 0
C19708 _707_/a_2250_412# VPWR 0
C19709 clknet_0_clk _684_/a_741_93# 0
C19710 FILLER_15_89/a_32_246# _098_ 0.00138f
C19711 _206_ _656_/a_612_127# 0
C19712 _196_ _005_ 0
C19713 _177_ clknet_4_10_0_clk 0.01136f
C19714 VPWR _250_ 0.17263f
C19715 net39 _670_/a_843_236# 0
C19716 net184 _076_ 0
C19717 hold152/a_56_118# VPWR 0.00888f
C19718 _246_ hold180/a_326_118# 0
C19719 _434_/a_150_412# net25 0
C19720 _206_ input6/a_40_152# 0
C19721 baud_inst.counter\[12\] net90 0.0023f
C19722 clknet_4_8_0_clk FILLER_17_24/a_32_246# 0.00342f
C19723 _191_ clkbuf_4_3_0_clk/a_27_118# 0
C19724 _696_/a_38_114# net90 0
C19725 _691_/a_1840_334# _692_/a_2250_412# 0
C19726 net120 _105_ 0
C19727 hold179/a_326_118# FILLER_2_208/a_40_246# 0
C19728 net98 _682_/a_38_114# 0.02427f
C19729 _166_ _666_/a_298_337# 0.03071f
C19730 _009_ _682_/a_324_432# 0.03215f
C19731 _248_ FILLER_17_162/a_32_246# 0
C19732 _169_ _168_ 0.66714f
C19733 net14 _634_/a_1583_191# 0.01242f
C19734 tx_busy net2 0.09351f
C19735 clk FILLER_1_173/a_32_246# 0.00145f
C19736 hold154/a_326_118# clknet_4_3_0_clk 0.00106f
C19737 clknet_4_15_0_clk _649_/a_741_93# 0.03738f
C19738 _473_/a_120_432# net64 0.00396f
C19739 _073_ _706_/a_324_432# 0
C19740 _662_/a_324_432# _119_ 0.00127f
C19741 _163_ baud_inst.counter\[14\] 0
C19742 _518_/a_45_160# _187_ 0.03954f
C19743 net87 _356_/a_350_122# 0
C19744 _206_ _382_/a_285_118# 0.00179f
C19745 _126_ net19 0.01246f
C19746 _462_/a_22_110# _049_ 0.00124f
C19747 tx tx_busy 0
C19748 _117_ hold50/a_326_118# 0.006f
C19749 _636_/a_1785_429# _266_ 0
C19750 _543_/a_146_122# baud_inst.counter\[24\] 0.00399f
C19751 clknet_4_14_0_clk _648_/a_1489_191# 0
C19752 clknet_4_11_0_clk clkload2/Y 0.01238f
C19753 _682_/a_741_93# clknet_4_2_0_clk 0.03111f
C19754 net33 _665_/a_2002_114# 0
C19755 hold122/a_56_118# rx_inst.state\[3\] 0
C19756 net48 _266_ 0.10339f
C19757 _025_ net140 0.00867f
C19758 _310_ baud_inst.counter\[24\] 0.78846f
C19759 _392_/a_559_412# net41 0
C19760 hold161/a_326_118# _298_ 0
C19761 _671_/a_1785_429# VPWR 0.00305f
C19762 net49 _690_/a_741_93# 0.00262f
C19763 _358_/a_268_436# VPWR 0.00115f
C19764 net89 FILLER_15_42/a_40_246# 0
C19765 net48 _167_ 0.00737f
C19766 hold88/a_56_118# hold177/a_438_182# 0
C19767 _267_ _638_/a_324_432# 0.00177f
C19768 VPWR net38 2.22251f
C19769 _390_/a_59_156# _655_/a_1583_191# 0
C19770 clknet_4_5_0_clk _365_/a_155_412# 0.00314f
C19771 net34 _142_ 0.06123f
C19772 net118 _668_/a_741_93# 0
C19773 _153_ _668_/a_324_432# 0
C19774 _180_ FILLER_17_79/a_40_246# 0.01729f
C19775 _637_/a_741_93# _634_/a_1583_191# 0
C19776 _637_/a_324_432# _634_/a_1840_334# 0
C19777 _632_/a_38_114# net65 0.00336f
C19778 net48 _647_/a_741_93# 0.02402f
C19779 FILLER_25_198/a_32_246# _155_ 0.01237f
C19780 _481_/a_120_432# _176_ 0
C19781 _170_ FILLER_17_160/a_40_246# 0.02091f
C19782 _641_/a_324_432# FILLER_19_118/a_32_246# 0
C19783 clknet_4_14_0_clk FILLER_27_194/a_40_246# 0
C19784 _159_ FILLER_25_150/a_32_246# 0
C19785 _698_/a_2250_412# _180_ 0
C19786 hold143/a_56_118# net30 0.00126f
C19787 FILLER_22_133/a_40_246# FILLER_24_133/a_32_246# 0
C19788 baud_inst.counter\[30\] _703_/a_612_127# 0.00121f
C19789 _177_ baud_inst.counter\[31\] 0.02505f
C19790 baud_inst.counter\[27\] _179_ 0
C19791 input3/a_40_152# _146_ 0.11091f
C19792 net79 _672_/a_1489_191# 0.0019f
C19793 _661_/a_1583_191# _072_ 0
C19794 _661_/a_843_236# tx_inst.data_reg\[7\] 0.00436f
C19795 _192_ net41 0
C19796 _287_ FILLER_6_54/a_32_246# 0.00101f
C19797 net26 _650_/a_741_93# 0
C19798 FILLER_16_176/a_40_246# _157_ 0.00236f
C19799 FILLER_19_77/a_32_246# net162 0.01562f
C19800 tx_inst.data_reg\[3\] net41 0.00327f
C19801 hold174/a_326_118# clknet_4_4_0_clk 0
C19802 fanout27/a_40_152# _671_/a_324_432# 0
C19803 hold104/a_438_182# net101 0
C19804 net37 _061_ 0.06275f
C19805 _002_ net29 0.16659f
C19806 _226_ net180 0.09015f
C19807 _691_/a_1583_191# clknet_4_8_0_clk 0.00382f
C19808 hold179/a_56_118# _654_/a_1840_334# 0
C19809 hold86/a_56_118# baud_inst.counter\[3\] 0
C19810 _488_/a_209_168# net86 0.03245f
C19811 net179 _654_/a_324_432# 0
C19812 net94 _680_/a_1840_334# 0
C19813 _640_/a_1583_191# clknet_4_14_0_clk 0.02007f
C19814 _198_ _665_/a_324_432# 0
C19815 clknet_4_8_0_clk net162 0.04143f
C19816 hold183/a_326_118# _219_ 0
C19817 _652_/a_38_114# net43 0
C19818 _646_/a_2250_412# clknet_4_12_0_clk 0
C19819 _176_ net27 0.50499f
C19820 net32 _427_/a_248_122# 0.00524f
C19821 fanout40/a_40_152# _688_/a_843_236# 0
C19822 clknet_4_12_0_clk _435_/a_72_436# 0.01651f
C19823 _655_/a_324_432# _145_ 0.00705f
C19824 rx_inst.state\[3\] FILLER_12_128/a_40_246# 0.00536f
C19825 net26 _670_/a_1583_191# 0
C19826 _531_/a_209_168# _300_ 0
C19827 _068_ _147_ 0.04099f
C19828 baud_inst.counter\[10\] net117 0
C19829 hold128/a_56_118# _685_/a_324_432# 0.00131f
C19830 _246_ _247_ 0.01122f
C19831 hold65/a_56_118# _638_/a_741_93# 0
C19832 hold65/a_326_118# _638_/a_324_432# 0
C19833 _635_/a_1583_191# _264_ 0.01097f
C19834 _264_ hold70/a_438_182# 0.0066f
C19835 _556_/a_192_429# _703_/a_298_337# 0
C19836 _677_/a_324_432# net40 0
C19837 _241_ clknet_0_clk 0.03121f
C19838 hold131/a_56_118# clknet_0_clk 0
C19839 _659_/a_1489_191# tx_inst.data_reg\[1\] 0.00917f
C19840 clknet_4_3_0_clk hold92/a_56_118# 0.01851f
C19841 _073_ _152_ 0
C19842 _168_ _084_ 0.01747f
C19843 _058_ hold144/a_56_118# 0
C19844 VPWR _383_/a_268_412# 0
C19845 _679_/a_741_93# hold95/a_56_118# 0.0015f
C19846 _679_/a_324_432# hold95/a_326_118# 0
C19847 net160 _296_ 0.13073f
C19848 _650_/a_298_337# _061_ 0.00725f
C19849 hold77/a_56_118# _470_/a_22_110# 0.0413f
C19850 _267_ net126 0.01607f
C19851 hold135/a_438_182# _092_ 0.00145f
C19852 net47 clknet_0_clk 0.02469f
C19853 _663_/a_1785_429# clknet_0_clk 0.00138f
C19854 _036_ net152 0.00481f
C19855 _216_ _651_/a_741_93# 0
C19856 net128 FILLER_14_72/a_32_246# 0
C19857 net45 net105 0.07832f
C19858 _167_ _250_ 0.11394f
C19859 FILLER_15_185/a_32_246# _156_ 0
C19860 _132_ net24 0
C19861 _113_ hold134/a_326_118# 0.00284f
C19862 _254_ net52 0
C19863 rx_inst.bit_index\[2\] net175 0.01126f
C19864 _675_/a_550_127# VPWR 0
C19865 FILLER_4_108/a_40_246# _382_/a_382_118# 0
C19866 _136_ _647_/a_298_337# 0
C19867 _249_ _647_/a_38_114# 0
C19868 _044_ _633_/a_38_114# 0.02197f
C19869 _157_ _647_/a_843_236# 0.01237f
C19870 hold56/a_438_182# _142_ 0
C19871 net176 _697_/a_1583_191# 0.01231f
C19872 _052_ _697_/a_1840_334# 0
C19873 _216_ _007_ 0.01697f
C19874 _225_ _250_ 0
C19875 clknet_4_5_0_clk hold179/a_326_118# 0.03861f
C19876 _660_/a_2002_114# net179 0
C19877 _650_/a_38_114# _264_ 0
C19878 _291_ _186_ 0
C19879 hold153/a_438_182# net153 0.01177f
C19880 hold153/a_326_118# _035_ 0.05909f
C19881 net156 _528_/a_175_118# 0.00383f
C19882 _008_ FILLER_0_40/a_40_246# 0.01168f
C19883 _657_/a_741_93# FILLER_3_123/a_32_246# 0.00112f
C19884 hold172/a_326_118# VPWR 0.00735f
C19885 hold110/a_56_118# net29 0.00821f
C19886 VPWR FILLER_0_42/a_32_246# 0.06583f
C19887 FILLER_2_110/a_32_246# VPWR 0.09794f
C19888 hold126/a_438_182# clknet_0_clk 0
C19889 _675_/a_843_236# net60 0
C19890 _675_/a_741_93# _181_ 0
C19891 net12 _122_ 0.00676f
C19892 _030_ clknet_4_0_0_clk 0.03291f
C19893 FILLER_14_164/a_32_246# hold62/a_438_182# 0.00985f
C19894 hold65/a_56_118# _154_ 0
C19895 hold76/a_56_118# _107_ 0
C19896 hold171/a_438_182# net171 0
C19897 hold171/a_56_118# _148_ 0
C19898 _679_/a_1583_191# net95 0
C19899 _679_/a_1840_334# net29 0
C19900 _234_ _416_/a_350_122# 0
C19901 _642_/a_2250_412# _260_ 0.00605f
C19902 _174_ _208_ 0
C19903 _676_/a_1840_334# _142_ 0
C19904 net10 tx_data[4] 0.00434f
C19905 net55 net7 0.36432f
C19906 _690_/a_1583_191# _523_/a_155_412# 0
C19907 fanout30/a_40_152# _136_ 0
C19908 net18 _637_/a_1840_334# 0.02843f
C19909 hold183/a_326_118# tx_inst.bit_index\[2\] 0
C19910 _683_/a_550_127# net29 0
C19911 net42 _676_/a_1840_334# 0
C19912 hold173/a_56_118# _221_ 0
C19913 hold173/a_438_182# net183 0
C19914 _129_ net80 0
C19915 clknet_4_10_0_clk VPWR 0.99148f
C19916 _010_ baud_inst.counter\[9\] 0
C19917 _511_/a_354_412# _182_ 0
C19918 _431_/a_81_118# FILLER_18_158/a_40_246# 0.00671f
C19919 clknet_4_1_0_clk hold94/a_326_118# 0.00284f
C19920 VPWR _687_/a_843_236# 0.00609f
C19921 net143 VPWR 0.08001f
C19922 rx_inst.state\[3\] _652_/a_1489_191# 0
C19923 hold178/a_438_182# net178 0
C19924 _126_ _636_/a_1583_191# 0.00517f
C19925 net74 _636_/a_132_114# 0
C19926 _163_ clkbuf_4_2_0_clk/a_27_118# 0.01236f
C19927 net70 clknet_0_clk 0
C19928 _655_/a_741_93# VPWR 0.0459f
C19929 hold74/a_438_182# net48 0.01328f
C19930 net166 _409_/a_73_118# 0
C19931 rx_inst.bit_index\[2\] _161_ 0.02067f
C19932 net155 net55 0.02486f
C19933 _519_/a_277_118# net128 0
C19934 _519_/a_81_118# _295_ 0.03895f
C19935 net92 _353_/a_146_122# 0
C19936 _663_/a_741_93# net43 0.00128f
C19937 hold88/a_326_118# net128 0
C19938 hold88/a_438_182# baud_inst.counter\[12\] 0
C19939 VPWR FILLER_5_207/a_32_246# 0.08468f
C19940 _644_/a_612_127# _158_ 0
C19941 net132 _440_/a_142_412# 0.00402f
C19942 hold112/a_56_118# _154_ 0
C19943 baud_inst.counter\[13\] _099_ 0
C19944 _646_/a_1840_334# net64 0
C19945 _646_/a_1583_191# _273_ 0
C19946 _448_/a_142_412# _136_ 0
C19947 hold57/a_56_118# _222_ 0
C19948 hold57/a_438_182# net56 0.00834f
C19949 VPWR _688_/a_132_114# 0
C19950 FILLER_14_70/a_40_246# net40 0
C19951 hold142/a_438_182# _697_/a_38_114# 0
C19952 net55 _074_ 0.51035f
C19953 _652_/a_38_114# net152 0
C19954 _652_/a_298_337# baud_inst.counter\[4\] 0
C19955 _306_ _695_/a_843_236# 0
C19956 baud_inst.counter\[22\] _695_/a_681_505# 0
C19957 net49 _692_/a_38_114# 0
C19958 baud_inst.counter\[28\] _556_/a_341_118# 0
C19959 _315_ net49 0
C19960 _346_/a_354_412# _316_ 0.00147f
C19961 _179_ _556_/a_192_429# 0
C19962 _285_ VPWR 0.10705f
C19963 clknet_4_6_0_clk FILLER_14_148/a_40_246# 0
C19964 hold170/a_326_118# net54 0.00262f
C19965 _633_/a_324_432# _272_ 0
C19966 _633_/a_741_93# net77 0.0019f
C19967 hold59/a_326_118# _313_ 0
C19968 net79 _679_/a_298_337# 0
C19969 _499_/a_380_412# _280_ 0.00177f
C19970 _542_/a_155_412# _100_ 0
C19971 hold88/a_438_182# net88 0.00177f
C19972 FILLER_19_139/a_40_246# _262_ 0.00118f
C19973 hold153/a_438_182# _280_ 0.00656f
C19974 _646_/a_298_337# _647_/a_298_337# 0.00269f
C19975 VPWR _664_/a_2002_114# 0
C19976 _519_/a_81_118# clknet_4_2_0_clk 0.00277f
C19977 _451_/a_257_140# net24 0.00166f
C19978 _058_ _647_/a_1489_191# 0
C19979 _365_/a_155_412# _005_ 0.06097f
C19980 _280_ hold93/a_56_118# 0
C19981 clknet_0_clk _684_/a_1785_429# 0
C19982 baud_inst.counter\[20\] hold147/a_326_118# 0.03949f
C19983 _361_/a_248_122# _363_/a_22_110# 0
C19984 baud_inst.counter\[31\] VPWR 0.68507f
C19985 baud_inst.counter\[27\] hold113/a_56_118# 0.08245f
C19986 net92 _284_ 0
C19987 _427_/a_146_122# _242_ 0.00168f
C19988 net27 clkbuf_4_6_0_clk/a_27_118# 0.00211f
C19989 _656_/a_1583_191# _380_/a_59_156# 0
C19990 _283_ hold93/a_438_182# 0.00339f
C19991 net49 _447_/a_81_118# 0
C19992 _653_/a_843_236# net43 0.0337f
C19993 _095_ _682_/a_38_114# 0.04862f
C19994 _663_/a_2250_412# hold146/a_326_118# 0
C19995 _521_/a_170_412# _014_ 0
C19996 _544_/a_268_412# net46 0
C19997 _166_ _666_/a_1583_191# 0.01564f
C19998 FILLER_16_154/a_32_246# _241_ 0
C19999 _256_ _158_ 0
C20000 rx _704_/a_843_236# 0
C20001 net2 _704_/a_741_93# 0.00232f
C20002 input2/a_40_152# _704_/a_1583_191# 0
C20003 net14 _634_/a_2002_114# 0
C20004 _551_/a_272_160# net49 0.00158f
C20005 clknet_4_13_0_clk _632_/a_1840_334# 0
C20006 _505_/a_272_160# _287_ 0.00121f
C20007 hold128/a_326_118# clknet_0_clk 0.00761f
C20008 clknet_4_15_0_clk _649_/a_1785_429# 0
C20009 net121 net147 0.07662f
C20010 net64 _273_ 0.09402f
C20011 _662_/a_1583_191# _042_ 0.00161f
C20012 _040_ _706_/a_1583_191# 0.01214f
C20013 net121 net46 0.02565f
C20014 _279_ net135 0.02483f
C20015 _206_ _149_ 0.0129f
C20016 _481_/a_22_110# net26 0.01739f
C20017 net7 _389_/a_46_156# 0.08684f
C20018 _695_/a_38_114# _301_ 0
C20019 clknet_4_14_0_clk rx_inst.data_reg\[5\] 0
C20020 _053_ VPWR 0.19502f
C20021 hold149/a_438_182# VPWR 0.00994f
C20022 net44 hold142/a_326_118# 0
C20023 _098_ net40 0.07389f
C20024 _412_/a_22_110# net26 0.00175f
C20025 net26 fanout32/a_40_152# 0.00742f
C20026 _699_/a_324_432# net46 0.00704f
C20027 net54 VPWR 1.08063f
C20028 tx_inst.data_reg\[5\] _339_/a_1377_160# 0
C20029 output21/a_40_152# net43 0.01942f
C20030 _248_ _436_/a_142_412# 0.00502f
C20031 net50 FILLER_10_222/a_32_246# 0
C20032 clkbuf_4_9_0_clk/a_27_118# net29 0
C20033 rx_data[4] _047_ 0.0588f
C20034 net92 FILLER_9_79/a_32_246# 0
C20035 net49 _690_/a_1785_429# 0.00115f
C20036 hold53/a_326_118# VPWR 0.01556f
C20037 clkbuf_4_11_0_clk/a_27_118# net100 0
C20038 _672_/a_1583_191# _672_/a_2250_412# 0
C20039 fanout32/a_40_152# net32 0.01118f
C20040 hold78/a_56_118# _123_ 0.03241f
C20041 _173_ clknet_4_4_0_clk 0.72621f
C20042 _390_/a_382_118# _655_/a_1489_191# 0
C20043 hold154/a_326_118# baud_inst.counter\[5\] 0
C20044 _048_ _634_/a_298_337# 0.03105f
C20045 _637_/a_1840_334# _634_/a_2250_412# 0
C20046 net48 _647_/a_1785_429# 0
C20047 _171_ _192_ 0.08323f
C20048 _276_ net27 0.1497f
C20049 net2 _707_/a_298_337# 0
C20050 rx _707_/a_38_114# 0
C20051 net143 _266_ 0.00537f
C20052 VPWR _364_/a_257_140# 0
C20053 _675_/a_38_114# _087_ 0.00114f
C20054 baud_inst.counter\[30\] net59 0.43248f
C20055 _399_/a_154_118# net183 0
C20056 hold156/a_56_118# net40 0.0144f
C20057 _702_/a_843_236# _115_ 0
C20058 hold142/a_56_118# clknet_0_clk 0.0032f
C20059 _008_ clknet_4_0_0_clk 0
C20060 net79 baud_inst.counter\[0\] 0.42101f
C20061 _661_/a_612_127# tx_inst.data_reg\[7\] 0.00166f
C20062 hold145/a_56_118# _067_ 0
C20063 hold55/a_56_118# net11 0
C20064 hold153/a_438_182# _191_ 0
C20065 FILLER_15_127/a_32_246# clknet_4_9_0_clk 0
C20066 _643_/a_38_114# hold112/a_438_182# 0
C20067 _117_ _705_/a_741_93# 0.00246f
C20068 hold144/a_56_118# hold112/a_326_118# 0
C20069 tx_inst.data_reg\[4\] tx_inst.bit_index\[1\] 0.01345f
C20070 FILLER_14_148/a_40_246# net29 0
C20071 net104 _300_ 0.00786f
C20072 FILLER_16_203/a_32_246# _650_/a_324_432# 0
C20073 FILLER_2_46/a_40_246# _087_ 0.00241f
C20074 _163_ baud_inst.counter\[17\] 0
C20075 _691_/a_2002_114# clknet_4_8_0_clk 0
C20076 _116_ _702_/a_324_432# 0
C20077 _019_ net181 0.76147f
C20078 _177_ _308_ 0
C20079 _640_/a_2002_114# clknet_4_14_0_clk 0
C20080 _186_ baud_inst.counter\[4\] 0.02121f
C20081 _677_/a_1785_429# _142_ 0
C20082 FILLER_16_166/a_32_246# net37 0
C20083 _342_/a_170_412# net41 0.00127f
C20084 _652_/a_1840_334# net43 0.02843f
C20085 _170_ _244_ 1.50488f
C20086 _703_/a_298_337# FILLER_23_83/a_32_246# 0
C20087 hold168/a_56_118# _664_/a_324_432# 0
C20088 hold67/a_438_182# _702_/a_324_432# 0
C20089 _655_/a_1583_191# tx_inst.data_reg\[1\] 0
C20090 net55 _201_ 0.07243f
C20091 net2 hold51/a_438_182# 0.001f
C20092 FILLER_6_205/a_40_246# _203_ 0
C20093 net177 baud_inst.counter\[14\] 0
C20094 FILLER_15_116/a_40_246# _669_/a_324_432# 0
C20095 net15 _636_/a_38_114# 0
C20096 _048_ net47 0.66326f
C20097 net58 _703_/a_38_114# 0
C20098 _635_/a_2002_114# _264_ 0
C20099 tx_inst.data_reg\[6\] hold165/a_438_182# 0.00998f
C20100 rx_inst.bit_index\[2\] clkbuf_4_14_0_clk/a_27_118# 0.00647f
C20101 clknet_0_clk _649_/a_324_432# 0.05217f
C20102 VPWR _368_/a_155_412# 0.00134f
C20103 net100 _547_/a_81_118# 0
C20104 tx_inst.data_reg\[5\] tx_inst.data_reg\[1\] 0
C20105 _646_/a_843_236# VPWR 0.00737f
C20106 baud_inst.counter\[7\] _678_/a_741_93# 0
C20107 tx_start _665_/a_2250_412# 0
C20108 clknet_4_3_0_clk _678_/a_843_236# 0.0264f
C20109 net51 _000_ 0.0279f
C20110 net3 _656_/a_741_93# 0
C20111 _650_/a_132_114# net119 0
C20112 _650_/a_843_236# rx_inst.data_reg\[7\] 0
C20113 _287_ _502_/a_165_412# 0
C20114 _270_ _240_ 0
C20115 net84 _122_ 0
C20116 _062_ hold56/a_56_118# 0.00239f
C20117 _075_ clknet_0_clk 0.01817f
C20118 _216_ _651_/a_1785_429# 0
C20119 _204_ VPWR 0.02791f
C20120 _344_/a_354_412# VPWR 0
C20121 _292_ net29 0.44726f
C20122 _254_ FILLER_26_141/a_40_246# 0
C20123 hold85/a_438_182# _156_ 0.00767f
C20124 net48 _138_ 0.05037f
C20125 hold66/a_438_182# net111 0
C20126 _072_ FILLER_0_130/a_32_246# 0
C20127 tx_data[4] input8/a_40_152# 0.0111f
C20128 input7/a_40_152# tx_data[5] 0
C20129 clknet_4_0_0_clk _039_ 0
C20130 _004_ clknet_4_6_0_clk 0
C20131 net37 _156_ 0
C20132 _157_ _647_/a_612_127# 0
C20133 rx_data[0] clknet_4_15_0_clk 0
C20134 hold169/a_438_182# _215_ 0
C20135 net48 _232_ 0.68433f
C20136 _345_/a_150_412# VPWR 0
C20137 net176 _697_/a_2002_114# 0.00172f
C20138 hold126/a_326_118# net72 0
C20139 hold126/a_438_182# _048_ 0
C20140 _642_/a_324_432# net176 0.00191f
C20141 _132_ _641_/a_324_432# 0
C20142 _642_/a_741_93# _052_ 0
C20143 _642_/a_1489_191# _641_/a_1583_191# 0
C20144 _053_ _641_/a_741_93# 0.00295f
C20145 clknet_4_12_0_clk _641_/a_38_114# 0
C20146 _036_ _035_ 0
C20147 net54 FILLER_7_234/a_32_246# 0.02049f
C20148 _650_/a_1840_334# _264_ 0
C20149 _022_ _694_/a_324_432# 0
C20150 _341_/a_382_118# tx_inst.data_reg\[2\] 0.00525f
C20151 _341_/a_589_385# clknet_4_4_0_clk 0.00107f
C20152 _705_/a_741_93# net11 0
C20153 _170_ hold139/a_56_118# 0.04537f
C20154 VPWR _451_/a_155_412# 0.02594f
C20155 _243_ clkbuf_4_14_0_clk/a_27_118# 0.01185f
C20156 net49 hold106/a_438_182# 0.00141f
C20157 net156 net103 0.00597f
C20158 rx_inst.state\[2\] net37 0
C20159 _538_/a_277_118# _108_ 0
C20160 _633_/a_324_432# _648_/a_298_337# 0
C20161 hold53/a_438_182# _641_/a_324_432# 0
C20162 _230_ _262_ 0.17932f
C20163 tx_inst.bit_index\[1\] _386_/a_285_412# 0
C20164 hold145/a_56_118# _143_ 0
C20165 _083_ _676_/a_741_93# 0.0015f
C20166 net16 net80 0
C20167 hold143/a_438_182# _160_ 0.0014f
C20168 _206_ input8/a_40_152# 0
C20169 baud_inst.counter\[13\] _685_/a_843_236# 0.00677f
C20170 _646_/a_843_236# net144 0
C20171 _073_ net168 0.01133f
C20172 _511_/a_252_412# _291_ 0.00101f
C20173 net182 _292_ 0.00139f
C20174 net35 _452_/a_155_412# 0
C20175 _643_/a_132_114# net48 0
C20176 clknet_4_12_0_clk _647_/a_38_114# 0.0084f
C20177 _487_/a_146_122# net146 0
C20178 net45 _026_ 0
C20179 clk _654_/a_38_114# 0.00678f
C20180 hold103/a_56_118# clknet_4_8_0_clk 0
C20181 _076_ _201_ 0.0021f
C20182 net167 _670_/a_324_432# 0
C20183 _699_/a_324_432# _313_ 0.01818f
C20184 _699_/a_741_93# _312_ 0
C20185 _198_ _370_/a_154_118# 0.00176f
C20186 _676_/a_132_114# _281_ 0
C20187 hold122/a_438_182# net43 0.02462f
C20188 _690_/a_1583_191# _298_ 0
C20189 baud_inst.counter\[18\] net87 0
C20190 _264_ hold84/a_438_182# 0.00255f
C20191 net70 _048_ 0
C20192 net35 clknet_0_clk 0.12213f
C20193 hold170/a_56_118# _144_ 0.01474f
C20194 _133_ _259_ 0.08259f
C20195 _275_ net172 0.21208f
C20196 _703_/a_132_114# net59 0
C20197 _170_ clknet_4_14_0_clk 0.21731f
C20198 _230_ rx_inst.state\[3\] 0
C20199 FILLER_8_116/a_40_246# _652_/a_38_114# 0
C20200 net84 rx_inst.data_reg\[4\] 0.00109f
C20201 VPWR _687_/a_612_127# 0
C20202 net74 _636_/a_1489_191# 0.00273f
C20203 hold163/a_326_118# baud_inst.counter\[20\] 0.00551f
C20204 net44 _698_/a_298_337# 0
C20205 _186_ _492_/a_170_412# 0
C20206 hold156/a_56_118# _682_/a_741_93# 0
C20207 _184_ _162_ 0.13467f
C20208 hold76/a_438_182# hold147/a_56_118# 0
C20209 clknet_4_13_0_clk _635_/a_843_236# 0.06703f
C20210 _655_/a_1785_429# VPWR 0
C20211 hold85/a_56_118# clknet_4_13_0_clk 0.01542f
C20212 _346_/a_150_412# _165_ 0
C20213 _488_/a_209_168# net38 0.00284f
C20214 net44 hold101/a_56_118# 0
C20215 _178_ baud_inst.counter\[27\] 0.00876f
C20216 hold158/a_56_118# _299_ 0.0626f
C20217 hold158/a_326_118# net157 0.00646f
C20218 net128 _295_ 0.03843f
C20219 VPWR hold91/a_326_118# 0.00483f
C20220 _307_ _310_ 0
C20221 input5/a_40_152# _384_/a_382_118# 0
C20222 tx_inst.data_reg\[7\] tx_inst.data_reg\[3\] 0.08798f
C20223 _510_/a_146_122# _505_/a_76_160# 0
C20224 _283_ _184_ 0
C20225 _663_/a_1785_429# net43 0.0014f
C20226 hold155/a_326_118# net171 0
C20227 FILLER_17_131/a_32_246# net29 0
C20228 net132 _158_ 0.00396f
C20229 _679_/a_2250_412# _091_ 0
C20230 net158 baud_inst.counter\[16\] 0
C20231 hold134/a_438_182# _700_/a_38_114# 0
C20232 hold134/a_326_118# _700_/a_324_432# 0
C20233 fanout34/a_40_152# net27 0.00196f
C20234 VPWR _688_/a_1489_191# 0.00499f
C20235 net57 _141_ 0.0217f
C20236 _306_ _695_/a_612_127# 0
C20237 baud_inst.counter\[22\] _695_/a_550_127# 0
C20238 baud_inst.counter\[23\] _695_/a_1489_191# 0.02221f
C20239 hold136/a_56_118# net136 0.0045f
C20240 _004_ net29 0
C20241 baud_inst.counter\[30\] _032_ 0.06616f
C20242 _179_ _316_ 0.14693f
C20243 net49 _692_/a_1840_334# 0.03429f
C20244 _633_/a_1785_429# net77 0
C20245 _660_/a_1489_191# clk 0
C20246 _295_ _014_ 0
C20247 _065_ VPWR 0.26885f
C20248 _203_ _369_/a_248_122# 0
C20249 hold55/a_326_118# _275_ 0.00294f
C20250 _635_/a_741_93# _122_ 0.00171f
C20251 _081_ net2 0.00524f
C20252 _244_ _237_ 0
C20253 tx_inst.data_reg\[0\] FILLER_1_201/a_40_246# 0
C20254 FILLER_5_32/a_40_246# net181 0
C20255 net44 hold162/a_56_118# 0
C20256 _646_/a_843_236# _647_/a_741_93# 0
C20257 _646_/a_741_93# _647_/a_843_236# 0
C20258 baud_inst.counter\[26\] hold99/a_56_118# 0.03756f
C20259 baud_inst.counter\[27\] hold99/a_326_118# 0
C20260 _662_/a_38_114# net55 0.03875f
C20261 hold98/a_56_118# net98 0
C20262 hold98/a_326_118# _009_ 0.00524f
C20263 _305_ FILLER_21_31/a_40_246# 0.00633f
C20264 hold184/a_56_118# _171_ 0
C20265 _286_ _036_ 0
C20266 hold144/a_326_118# _136_ 0.0032f
C20267 net55 tx_inst.state\[3\] 0.00761f
C20268 baud_inst.counter\[20\] _537_/a_192_429# 0.01663f
C20269 _283_ FILLER_9_72/a_32_246# 0
C20270 _041_ _671_/a_324_432# 0
C20271 _661_/a_1840_334# net165 0
C20272 hold86/a_326_118# VPWR 0.0064f
C20273 FILLER_12_171/a_40_246# _084_ 0.02472f
C20274 clknet_4_8_0_clk baud_inst.counter\[16\] 0
C20275 hold126/a_56_118# _267_ 0.00254f
C20276 _246_ _234_ 0
C20277 _678_/a_612_127# net154 0
C20278 _075_ hold146/a_56_118# 0
C20279 _481_/a_22_110# FILLER_5_181/a_32_246# 0
C20280 _166_ _666_/a_2002_114# 0
C20281 rx_inst.bit_index\[2\] FILLER_18_148/a_40_246# 0
C20282 hold121/a_438_182# _302_ 0
C20283 net2 _704_/a_1785_429# 0.00187f
C20284 _515_/a_76_160# _297_ 0
C20285 VPWR _308_ 0.0719f
C20286 _637_/a_1840_334# hold71/a_326_118# 0
C20287 _637_/a_1583_191# hold71/a_438_182# 0
C20288 _637_/a_2250_412# hold71/a_56_118# 0.00101f
C20289 net118 _650_/a_324_432# 0
C20290 _153_ _650_/a_38_114# 0.01928f
C20291 _669_/a_1583_191# net29 0.00201f
C20292 _170_ hold132/a_56_118# 0.01574f
C20293 _674_/a_324_432# net135 0
C20294 VPWR clkbuf_4_4_0_clk/a_27_118# 0.04193f
C20295 net173 net174 0
C20296 net58 clknet_4_11_0_clk 0.057f
C20297 FILLER_17_201/a_32_246# VPWR 0.06473f
C20298 _040_ _706_/a_2002_114# 0
C20299 FILLER_12_106/a_40_246# net29 0
C20300 _671_/a_38_114# _169_ 0
C20301 _639_/a_38_114# _264_ 0
C20302 net48 hold73/a_326_118# 0.01931f
C20303 _634_/a_843_236# hold72/a_56_118# 0
C20304 _634_/a_1840_334# hold82/a_326_118# 0
C20305 hold110/a_56_118# _288_ 0.0013f
C20306 hold56/a_56_118# FILLER_7_176/a_32_246# 0
C20307 VPWR _508_/a_209_168# 0.00764f
C20308 _226_ net37 0
C20309 _697_/a_298_337# _025_ 0.00476f
C20310 _699_/a_2250_412# net46 0.05391f
C20311 FILLER_4_183/a_40_246# _214_ 0
C20312 _141_ _400_/a_341_118# 0
C20313 net56 net183 0.00782f
C20314 _432_/a_248_122# _248_ -0
C20315 _248_ _157_ 0.68194f
C20316 net71 net126 0.00162f
C20317 _225_ _451_/a_155_412# 0
C20318 rx_inst.bit_index\[1\] net52 0
C20319 net41 net168 0
C20320 _009_ net39 0.0501f
C20321 net49 _103_ 0.0068f
C20322 _227_ _231_ 0.09517f
C20323 _672_/a_741_93# baud_inst.counter\[0\] 0
C20324 _672_/a_843_236# clknet_4_0_0_clk 0.00855f
C20325 net28 hold119/a_438_182# 0.01601f
C20326 _125_ clknet_0_clk 0
C20327 _390_/a_559_412# _145_ 0
C20328 _089_ hold108/a_326_118# 0
C20329 _048_ _634_/a_1583_191# 0.0011f
C20330 net17 _634_/a_843_236# 0
C20331 _496_/a_170_412# hold92/a_56_118# 0
C20332 clk _374_/a_244_412# 0
C20333 rx _707_/a_1840_334# 0.04578f
C20334 net2 _707_/a_1583_191# 0.03202f
C20335 hold124/a_326_118# clknet_4_15_0_clk 0
C20336 net176 clknet_4_9_0_clk 0
C20337 rx_inst.data_reg\[4\] _635_/a_741_93# 0
C20338 _215_ _166_ 0.05452f
C20339 _675_/a_1840_334# _087_ 0
C20340 _705_/a_843_236# _275_ 0
C20341 net182 FILLER_12_106/a_40_246# 0.03256f
C20342 _438_/a_350_122# net24 0
C20343 _702_/a_612_127# _115_ 0.00279f
C20344 net26 _061_ 0.00213f
C20345 _170_ rx_inst.state\[4\] 0
C20346 clknet_4_14_0_clk _263_ 0.00719f
C20347 _646_/a_298_337# _160_ 0
C20348 net143 _647_/a_1785_429# 0
C20349 hold146/a_326_118# _166_ 0.04416f
C20350 net32 _061_ 0
C20351 clknet_4_11_0_clk hold133/a_326_118# 0.00561f
C20352 hold179/a_438_182# tx_inst.data_reg\[0\] 0.00491f
C20353 _655_/a_298_337# _066_ 0.02726f
C20354 VPWR FILLER_29_179/a_40_246# 0.13919f
C20355 _129_ _121_ 0.00139f
C20356 net106 _701_/a_132_114# 0
C20357 _029_ _701_/a_681_505# 0
C20358 FILLER_4_172/a_32_246# clknet_4_4_0_clk 0.00133f
C20359 net179 tx_inst.state\[2\] 0.00566f
C20360 clknet_4_14_0_clk _237_ 0.0675f
C20361 _421_/a_354_412# VPWR 0
C20362 hold160/a_326_118# _301_ 0
C20363 net44 net141 0.03242f
C20364 hold163/a_56_118# net163 0
C20365 clknet_4_10_0_clk FILLER_22_43/a_40_246# 0
C20366 _511_/a_252_412# baud_inst.counter\[4\] 0
C20367 _511_/a_150_412# _282_ 0.00758f
C20368 output14/a_40_152# _124_ 0.01299f
C20369 _032_ _703_/a_132_114# 0
C20370 _633_/a_298_337# _123_ 0.00515f
C20371 hold77/a_438_182# _648_/a_843_236# 0
C20372 hold62/a_56_118# rx_inst.state\[4\] 0.02752f
C20373 hold89/a_56_118# baud_inst.counter\[15\] 0.00625f
C20374 net37 FILLER_15_173/a_40_246# 0.0067f
C20375 _174_ net27 0
C20376 _175_ _176_ 0.64471f
C20377 _289_ net29 0
C20378 hold154/a_326_118# clknet_0_clk 0.02064f
C20379 net39 _676_/a_38_114# 0.03302f
C20380 net2 _671_/a_1840_334# 0
C20381 _387_/a_268_412# net171 0.00377f
C20382 _097_ net109 0.00322f
C20383 hold101/a_56_118# _302_ 0
C20384 _187_ baud_inst.counter\[15\] 0.00183f
C20385 _188_ baud_inst.counter\[14\] 0
C20386 _646_/a_612_127# VPWR 0.00219f
C20387 clknet_4_3_0_clk _678_/a_612_127# 0
C20388 _671_/a_38_114# _084_ 0.02685f
C20389 VPWR _435_/a_268_436# 0
C20390 hold101/a_56_118# _690_/a_1840_334# 0
C20391 _178_ _556_/a_192_429# 0
C20392 hold140/a_438_182# net100 0
C20393 _663_/a_843_236# _078_ 0
C20394 _260_ _450_/a_398_96# 0
C20395 net39 _683_/a_38_114# 0
C20396 FILLER_23_204/a_40_246# _268_ 0
C20397 output16/a_40_152# _168_ 0
C20398 _177_ VPWR 0.11789f
C20399 net41 _146_ 0
C20400 _635_/a_1489_191# _156_ 0
C20401 _425_/a_46_156# _242_ 0
C20402 net26 _433_/a_142_412# 0
C20403 _421_/a_354_412# _239_ 0
C20404 _360_/a_382_118# hold165/a_56_118# 0
C20405 _206_ clknet_0_clk 0.25327f
C20406 FILLER_1_30/a_32_246# net61 0.01417f
C20407 _292_ _493_/a_45_160# 0
C20408 _269_ _650_/a_1840_334# 0
C20409 FILLER_17_201/a_32_246# _266_ 0
C20410 _157_ net139 0
C20411 _637_/a_298_337# _124_ 0
C20412 _233_ _246_ 0
C20413 _170_ _433_/a_244_412# 0.00182f
C20414 hold163/a_438_182# _104_ 0
C20415 _680_/a_550_127# VPWR 0
C20416 _216_ _195_ 0.04318f
C20417 FILLER_8_189/a_40_246# net26 0.01103f
C20418 _539_/a_139_160# baud_inst.counter\[23\] 0
C20419 _132_ _641_/a_2250_412# 0
C20420 clknet_4_12_0_clk _641_/a_1840_334# 0.00273f
C20421 _394_/a_22_110# _666_/a_1583_191# 0
C20422 _117_ hold80/a_56_118# 0
C20423 _305_ _693_/a_741_93# 0
C20424 _023_ _693_/a_324_432# 0
C20425 net75 _693_/a_843_236# 0
C20426 _341_/a_1023_118# clknet_4_4_0_clk 0
C20427 _341_/a_810_118# tx_inst.data_reg\[2\] 0
C20428 net48 hold131/a_438_182# 0.00919f
C20429 baud_inst.counter\[28\] net45 0.65149f
C20430 FILLER_17_160/a_40_246# _247_ 0
C20431 hold113/a_56_118# FILLER_23_83/a_32_246# 0.00123f
C20432 net177 baud_inst.counter\[17\] 0
C20433 _633_/a_1583_191# _648_/a_324_432# 0
C20434 FILLER_22_118/a_32_246# net52 0
C20435 net53 _641_/a_681_505# 0
C20436 _699_/a_843_236# clknet_0_clk 0.004f
C20437 baud_inst.counter\[22\] _108_ 0.04961f
C20438 _350_/a_279_412# _039_ 0
C20439 hold151/a_56_118# net49 0.00407f
C20440 clknet_4_11_0_clk _027_ 0
C20441 _680_/a_681_505# VPWR 0
C20442 hold129/a_56_118# net40 0.00221f
C20443 hold164/a_326_118# net49 0.00106f
C20444 _390_/a_285_118# VPWR 0
C20445 net28 _667_/a_1583_191# 0
C20446 baud_inst.counter\[13\] _685_/a_612_127# 0
C20447 _206_ _077_ 0
C20448 _651_/a_1840_334# clknet_0_clk 0
C20449 _646_/a_612_127# net144 0
C20450 _646_/a_2250_412# rx_inst.data_reg\[3\] 0.00123f
C20451 hold132/a_438_182# clknet_4_14_0_clk 0.00141f
C20452 _191_ _652_/a_324_432# 0
C20453 clknet_0_clk _416_/a_146_122# 0
C20454 _152_ net146 0.13247f
C20455 rx_inst.bit_index\[2\] _154_ 0
C20456 _418_/a_46_156# net175 0
C20457 tx_data[1] _389_/a_46_156# 0
C20458 clk _654_/a_1840_334# 0
C20459 _393_/a_170_412# net50 0
C20460 _663_/a_38_114# _001_ 0.01839f
C20461 _650_/a_1583_191# _156_ 0
C20462 clknet_4_3_0_clk _037_ 0
C20463 hold154/a_326_118# _182_ 0
C20464 FILLER_8_63/a_40_246# VPWR 0.1354f
C20465 _699_/a_2250_412# _313_ 0
C20466 _093_ _030_ 0
C20467 clkbuf_4_8_0_clk/a_27_118# _687_/a_1489_191# 0
C20468 _287_ baud_inst.counter\[9\] 0
C20469 net45 hold149/a_326_118# 0.01601f
C20470 hold143/a_326_118# net47 0
C20471 tx_inst.data_reg\[6\] tx_inst.data_reg\[0\] 1.20469f
C20472 baud_inst.counter\[7\] FILLER_5_84/a_40_246# 0
C20473 _646_/a_324_432# _043_ 0
C20474 _206_ _386_/a_59_156# 0.00755f
C20475 hold165/a_56_118# net9 0.00753f
C20476 net39 baud_inst.counter\[6\] 0.00242f
C20477 net183 _476_/a_248_122# 0
C20478 clknet_0_clk hold92/a_56_118# 0.05947f
C20479 hold53/a_56_118# net45 0
C20480 tx_inst.state\[1\] _704_/a_843_236# 0
C20481 clknet_4_7_0_clk _704_/a_681_505# 0
C20482 _305_ _535_/a_350_122# -0
C20483 baud_inst.counter\[21\] net147 0.00271f
C20484 clknet_4_13_0_clk _635_/a_612_127# 0.00968f
C20485 _223_ net25 0.1362f
C20486 baud_inst.counter\[27\] net162 0
C20487 baud_inst.counter\[21\] net46 0.23214f
C20488 hold137/a_326_118# clknet_4_4_0_clk 0.0027f
C20489 _156_ hold84/a_326_118# 0.00288f
C20490 hold121/a_326_118# _692_/a_1583_191# 0
C20491 net121 _692_/a_324_432# 0
C20492 net150 _159_ 0.05724f
C20493 rx_data[5] clknet_4_15_0_clk 0
C20494 tx_data[2] _384_/a_496_118# 0
C20495 FILLER_16_56/a_32_246# clknet_4_8_0_clk 0
C20496 _075_ net43 0.01575f
C20497 net55 _380_/a_285_118# 0
C20498 _658_/a_324_432# clknet_4_1_0_clk 0.00541f
C20499 _661_/a_2250_412# _658_/a_324_432# 0
C20500 hold102/a_326_118# net40 0
C20501 _108_ FILLER_22_54/a_40_246# 0.00143f
C20502 net93 _183_ 0
C20503 _243_ _154_ 0
C20504 VPWR _438_/a_248_122# 0
C20505 hold142/a_56_118# _110_ 0.00342f
C20506 FILLER_7_121/a_40_246# _653_/a_38_114# 0
C20507 fanout37/a_40_152# _153_ 0
C20508 _216_ _401_/a_22_110# 0.0011f
C20509 _688_/a_843_236# baud_inst.counter\[16\] 0
C20510 _487_/a_248_122# _200_ 0.00395f
C20511 _241_ _249_ 0.00411f
C20512 output14/a_40_152# net82 0.06381f
C20513 rx_inst.bit_index\[2\] fanout36/a_40_152# 0
C20514 clkbuf_0_clk/a_116_82# _191_ 0.03776f
C20515 FILLER_18_169/a_40_246# VPWR 0.14464f
C20516 _698_/a_132_114# clknet_0_clk 0
C20517 _165_ baud_inst.counter\[25\] 0
C20518 hold162/a_326_118# hold141/a_326_118# 0.0024f
C20519 hold162/a_56_118# hold141/a_438_182# 0.00367f
C20520 hold162/a_438_182# hold141/a_56_118# 0.00367f
C20521 _240_ net25 0.00592f
C20522 _638_/a_324_432# _273_ 0.04021f
C20523 _638_/a_741_93# net64 0
C20524 net85 _122_ 0
C20525 FILLER_8_21/a_32_246# net117 0.0014f
C20526 tx_inst.state\[1\] _707_/a_38_114# 0
C20527 clknet_4_7_0_clk _707_/a_324_432# 0.03579f
C20528 hold98/a_56_118# _095_ 0
C20529 _043_ _473_/a_22_110# 0.00473f
C20530 clknet_4_6_0_clk _666_/a_324_432# 0.02704f
C20531 net180 net62 0
C20532 _646_/a_1583_191# _647_/a_1583_191# 0.0061f
C20533 _662_/a_1840_334# net55 0
C20534 hold54/a_326_118# _478_/a_27_156# 0
C20535 _639_/a_843_236# rx_inst.data_reg\[7\] 0.0013f
C20536 _531_/a_209_168# net163 0.01663f
C20537 _418_/a_46_156# _161_ 0.01209f
C20538 FILLER_1_67/a_40_246# _086_ 0.01988f
C20539 net109 net116 0
C20540 _292_ _288_ 0.02526f
C20541 _081_ _084_ 0
C20542 _464_/a_22_110# net30 0
C20543 _464_/a_120_432# _266_ 0.00698f
C20544 hold170/a_326_118# VPWR 0.03174f
C20545 _675_/a_843_236# hold61/a_56_118# 0.0028f
C20546 _675_/a_741_93# hold61/a_326_118# 0.00231f
C20547 _675_/a_324_432# hold61/a_438_182# 0
C20548 tx_inst.data_reg\[4\] _341_/a_382_118# 0
C20549 _225_ _435_/a_268_436# 0.00337f
C20550 baud_inst.counter\[20\] _305_ 3.03364f
C20551 tx_inst.data_reg\[5\] _653_/a_324_432# 0
C20552 clknet_4_6_0_clk FILLER_9_169/a_32_246# 0
C20553 hold87/a_56_118# clknet_4_8_0_clk 0.00237f
C20554 tx_inst.data_reg\[7\] _388_/a_285_118# 0
C20555 tx_inst.data_reg\[2\] _380_/a_382_118# 0
C20556 clk _222_ 0
C20557 net49 _688_/a_324_432# 0
C20558 net37 _277_ 0.00512f
C20559 _641_/a_843_236# net24 0.00187f
C20560 net39 _677_/a_741_93# 0.00784f
C20561 _090_ _677_/a_324_432# 0.01288f
C20562 _217_ _666_/a_741_93# 0
C20563 clknet_4_7_0_clk tx_inst.state\[4\] 0
C20564 hold100/a_326_118# baud_inst.counter\[25\] 0
C20565 net73 _639_/a_324_432# 0
C20566 hold104/a_326_118# _104_ 0
C20567 hold117/a_438_182# _681_/a_324_432# 0
C20568 hold117/a_326_118# _681_/a_741_93# 0.00316f
C20569 _153_ _650_/a_1840_334# 0.00244f
C20570 net118 _650_/a_2250_412# 0.0098f
C20571 _695_/a_38_114# FILLER_21_31/a_40_246# 0.00116f
C20572 _674_/a_2250_412# net135 0
C20573 _202_ clknet_0_clk 0
C20574 _218_ FILLER_9_169/a_32_246# 0
C20575 FILLER_15_162/a_40_246# _234_ 0.00222f
C20576 _339_/a_308_118# tx_inst.data_reg\[1\] 0.00104f
C20577 _168_ _668_/a_298_337# 0
C20578 _645_/a_38_114# hold151/a_56_118# 0
C20579 _112_ _701_/a_1785_429# 0
C20580 _643_/a_843_236# clknet_4_12_0_clk 0.00842f
C20581 net26 net172 0
C20582 _171_ net168 0.20992f
C20583 clknet_4_13_0_clk rx_inst.state\[1\] 0.00483f
C20584 rx_inst.data_reg\[1\] net78 0
C20585 _158_ _472_/a_22_110# 0.00431f
C20586 _694_/a_132_114# net46 0
C20587 _040_ fanout33/a_40_152# 0.01881f
C20588 net44 _538_/a_277_118# 0.00117f
C20589 clknet_4_12_0_clk hold144/a_438_182# 0
C20590 _352_/a_46_156# baud_inst.counter\[6\] 0.01098f
C20591 FILLER_8_118/a_32_246# _063_ 0
C20592 _459_/a_229_118# _000_ 0.00297f
C20593 _459_/a_27_156# net30 0.02434f
C20594 _531_/a_380_412# _104_ 0
C20595 _021_ fanout45/a_40_152# 0
C20596 hold86/a_56_118# net60 0.08316f
C20597 _657_/a_741_93# _209_ 0
C20598 _102_ _296_ 0
C20599 hold64/a_56_118# rx_inst.data_reg\[0\] 0
C20600 rx_inst.state\[2\] _454_/a_257_140# 0.00163f
C20601 _672_/a_612_127# clknet_4_0_0_clk 0
C20602 hold113/a_326_118# _027_ 0
C20603 net28 _650_/a_38_114# 0.01714f
C20604 net126 _273_ 0.02172f
C20605 FILLER_21_194/a_32_246# _223_ 0
C20606 _660_/a_741_93# _206_ 0.02852f
C20607 _077_ _202_ 0
C20608 net108 _502_/a_165_412# 0
C20609 net102 _526_/a_146_122# 0
C20610 hold102/a_56_118# net101 0.02862f
C20611 _466_/a_120_432# _157_ 0.00422f
C20612 net2 _707_/a_2002_114# 0
C20613 clknet_4_15_0_clk _648_/a_741_93# 0
C20614 net128 FILLER_14_70/a_40_246# 0
C20615 fanout31/a_40_152# net29 0.00564f
C20616 net85 rx_inst.data_reg\[4\] 0.00827f
C20617 hold138/a_438_182# _635_/a_1489_191# 0
C20618 _537_/a_341_118# _023_ 0.01311f
C20619 net50 hold50/a_438_182# 0.01388f
C20620 _252_ net24 0.07877f
C20621 net21 _665_/a_741_93# 0.03126f
C20622 net158 _016_ 0.27961f
C20623 baud_inst.counter\[17\] net157 0
C20624 _115_ net68 0.02201f
C20625 net55 net3 0.05325f
C20626 hold150/a_438_182# rx_data[1] 0
C20627 _175_ _276_ 0
C20628 tx_inst.bit_index\[1\] _211_ 0
C20629 _168_ clknet_4_6_0_clk 0.10302f
C20630 _692_/a_843_236# _105_ 0.00181f
C20631 _646_/a_1583_191# _160_ 0
C20632 _261_ net25 0.01192f
C20633 hold135/a_326_118# _673_/a_1583_191# 0
C20634 FILLER_16_166/a_32_246# net26 0
C20635 _658_/a_681_505# net41 0
C20636 _158_ _648_/a_741_93# 0
C20637 hold141/a_438_182# net141 0
C20638 hold141/a_326_118# _310_ 0.03604f
C20639 VPWR hold93/a_326_118# 0.00467f
C20640 _645_/a_843_236# net48 0.00941f
C20641 baud_inst.counter\[20\] _693_/a_1489_191# 0.00101f
C20642 input4/a_40_152# FILLER_0_80/a_40_246# 0.01226f
C20643 _096_ _682_/a_1583_191# 0.00574f
C20644 _646_/a_2250_412# _046_ 0
C20645 FILLER_16_166/a_32_246# net32 0.00737f
C20646 hold67/a_326_118# _115_ 0
C20647 _239_ VPWR 0.10785f
C20648 _089_ clkbuf_4_2_0_clk/a_27_118# 0
C20649 baud_inst.counter\[20\] _020_ 0
C20650 hold170/a_56_118# net179 0.00151f
C20651 tx_inst.data_reg\[6\] hold179/a_326_118# 0
C20652 hold159/a_56_118# _211_ 0
C20653 _045_ _634_/a_132_114# 0
C20654 _032_ _703_/a_1489_191# 0
C20655 hold69/a_326_118# _264_ 0.00445f
C20656 _374_/a_244_412# _169_ 0.00687f
C20657 _633_/a_1583_191# _123_ 0.00156f
C20658 _178_ FILLER_23_83/a_32_246# 0
C20659 net89 baud_inst.counter\[14\] 0.00199f
C20660 net151 net47 0.07987f
C20661 _069_ _657_/a_741_93# 0
C20662 hold153/a_326_118# _284_ 0
C20663 _152_ _705_/a_298_337# 0.00882f
C20664 net39 _676_/a_1840_334# 0
C20665 FILLER_18_169/a_40_246# _167_ 0.00499f
C20666 FILLER_25_177/a_40_246# VPWR 0.14058f
C20667 FILLER_16_203/a_32_246# _264_ 0.00187f
C20668 net144 VPWR 0.17728f
C20669 clknet_4_3_0_clk net93 0.00189f
C20670 net156 _522_/a_474_130# 0
C20671 hold156/a_438_182# _296_ 0
C20672 _514_/a_257_140# baud_inst.counter\[13\] 0.00205f
C20673 _671_/a_1840_334# _084_ -0
C20674 _421_/a_150_412# _236_ 0
C20675 net3 _067_ 0.00199f
C20676 net135 net29 0
C20677 baud_inst.counter\[18\] _690_/a_1785_429# 0
C20678 net36 _407_/a_248_122# 0
C20679 _178_ _316_ 0
C20680 _653_/a_1840_334# _222_ 0
C20681 net39 _683_/a_1840_334# 0
C20682 _550_/a_380_412# net133 -0
C20683 _550_/a_209_168# _028_ 0
C20684 hold178/a_56_118# _684_/a_324_432# 0
C20685 hold152/a_56_118# _063_ 0.07635f
C20686 _098_ net128 0.65315f
C20687 _639_/a_298_337# _050_ 0.01795f
C20688 FILLER_16_70/a_40_246# clknet_4_8_0_clk 0.00839f
C20689 _691_/a_681_505# VPWR 0
C20690 _165_ baud_inst.counter\[24\] 0
C20691 _160_ net64 0.01597f
C20692 _283_ _019_ 0.002f
C20693 baud_inst.counter\[17\] _298_ 0
C20694 _127_ VPWR 0.01322f
C20695 net136 clknet_4_0_0_clk 0.03549f
C20696 _691_/a_741_93# FILLER_17_24/a_32_246# 0
C20697 FILLER_22_133/a_40_246# net53 0
C20698 _099_ net29 0.00885f
C20699 _159_ _633_/a_132_114# 0
C20700 hold155/a_326_118# net155 0.003f
C20701 _683_/a_324_432# _683_/a_741_93# 0
C20702 _307_ _306_ 0.04865f
C20703 _053_ _052_ 0.00491f
C20704 _706_/a_741_93# _200_ 0
C20705 _265_ hold51/a_56_118# 0
C20706 FILLER_16_56/a_32_246# _687_/a_324_432# 0
C20707 net48 _649_/a_843_236# 0
C20708 _643_/a_298_337# net24 0.01261f
C20709 _013_ _310_ 0
C20710 _023_ _693_/a_2250_412# 0
C20711 tx_inst.bit_index\[2\] tx_inst.data_reg\[2\] 0.00279f
C20712 _093_ _039_ 0
C20713 _216_ _667_/a_741_93# 0
C20714 _233_ FILLER_15_162/a_40_246# 0.00383f
C20715 rx_inst.state\[2\] net26 1.3195f
C20716 _230_ _642_/a_1583_191# 0.00637f
C20717 baud_inst.counter\[8\] net95 0
C20718 _661_/a_38_114# _209_ 0.0035f
C20719 _452_/a_257_140# net25 0
C20720 _633_/a_1489_191# _648_/a_741_93# 0
C20721 _072_ FILLER_0_117/a_32_246# 0.00138f
C20722 tx_inst.bit_index\[0\] net26 0.00876f
C20723 _292_ FILLER_14_72/a_32_246# 0.00288f
C20724 net74 hold118/a_56_118# 0
C20725 baud_inst.counter\[14\] _310_ 0
C20726 _227_ _228_ 0.60384f
C20727 rx_inst.state\[2\] net32 0
C20728 baud_inst.counter\[13\] net130 0.00578f
C20729 fanout39/a_40_152# VPWR 0.07125f
C20730 _294_ FILLER_13_68/a_40_246# 0
C20731 VPWR FILLER_7_234/a_32_246# 0.07448f
C20732 net49 _703_/a_38_114# 0.01702f
C20733 _641_/a_741_93# VPWR 0.02653f
C20734 hold100/a_326_118# baud_inst.counter\[24\] 0
C20735 hold100/a_438_182# net140 0.00107f
C20736 _188_ baud_inst.counter\[17\] 0.01326f
C20737 _656_/a_1583_191# net41 0.00118f
C20738 _064_ net137 0.01527f
C20739 net73 _264_ 0.21954f
C20740 _168_ net29 0.01986f
C20741 VPWR _266_ 1.1717f
C20742 net4 _213_ 0.00457f
C20743 hold162/a_56_118# _546_/a_341_118# 0
C20744 net31 net37 0.40114f
C20745 VPWR _167_ 0.71439f
C20746 _148_ _383_/a_46_156# 0
C20747 _384_/a_496_118# _210_ 0.00111f
C20748 tx_inst.bit_index\[1\] _659_/a_1489_191# 0
C20749 hold126/a_56_118# net71 0.00299f
C20750 rx_inst.data_reg\[0\] _632_/a_324_432# 0.00255f
C20751 _643_/a_1489_191# net143 0
C20752 baud_inst.counter\[10\] _682_/a_2250_412# 0.00227f
C20753 _680_/a_741_93# _181_ 0.00104f
C20754 _657_/a_741_93# clknet_4_4_0_clk 0.00269f
C20755 _265_ _457_/a_120_432# 0.00119f
C20756 VPWR _647_/a_741_93# 0.02948f
C20757 clknet_4_7_0_clk clkload1/Y 0.01179f
C20758 net53 _111_ 0.02126f
C20759 _388_/a_382_118# net165 0.02581f
C20760 _215_ _394_/a_22_110# 0.00466f
C20761 tx_inst.state\[1\] _704_/a_612_127# 0
C20762 clknet_4_7_0_clk _704_/a_550_127# 0
C20763 output12/a_40_152# net17 0.00177f
C20764 _678_/a_843_236# clknet_0_clk 0.02807f
C20765 _225_ VPWR 0.18791f
C20766 net145 clknet_0_clk 0.26185f
C20767 _534_/a_46_156# _105_ 0.00503f
C20768 hold121/a_438_182# _692_/a_1489_191# 0
C20769 hold89/a_326_118# clknet_4_8_0_clk 0
C20770 hold76/a_56_118# _023_ 0.0389f
C20771 hold76/a_438_182# net75 0
C20772 net16 clknet_0_clk 0
C20773 _360_/a_805_385# tx_inst.data_reg\[0\] 0
C20774 _696_/a_324_432# _024_ 0.0019f
C20775 input6/a_40_152# tx_data[7] 0.00188f
C20776 net55 _150_ 0.02055f
C20777 _661_/a_1583_191# _658_/a_612_127# 0
C20778 _206_ _659_/a_843_236# 0.00297f
C20779 hold54/a_56_118# net54 0.001f
C20780 _239_ _167_ 0.00138f
C20781 hold109/a_438_182# _290_ 0.00321f
C20782 _206_ net43 0.0074f
C20783 net129 _294_ 0.10168f
C20784 net104 net163 0.03231f
C20785 _134_ FILLER_26_151/a_32_246# 0
C20786 rx_inst.bit_index\[1\] _452_/a_155_412# 0
C20787 _143_ _142_ 0.04705f
C20788 hold157/a_56_118# _690_/a_324_432# 0
C20789 _288_ _289_ 0.09935f
C20790 _286_ _511_/a_354_412# 0.00137f
C20791 hold156/a_326_118# net39 0.01427f
C20792 net146 net168 0
C20793 net50 net172 0.04149f
C20794 net42 _143_ 0.03963f
C20795 clkbuf_4_8_0_clk/a_27_118# _297_ 0.00483f
C20796 net45 FILLER_25_36/a_32_246# 0.00151f
C20797 _698_/a_1489_191# clknet_0_clk 0.0073f
C20798 _638_/a_2250_412# _273_ 0
C20799 _638_/a_1785_429# net64 0
C20800 net144 _167_ 0
C20801 _542_/a_155_412# _296_ 0.00275f
C20802 rx_inst.bit_index\[1\] clknet_0_clk 0.01662f
C20803 _638_/a_298_337# net30 0.00766f
C20804 _519_/a_277_118# _292_ 0.00317f
C20805 hold119/a_56_118# _168_ 0
C20806 hold139/a_56_118# _247_ 0
C20807 hold99/a_56_118# FILLER_20_106/a_32_246# 0
C20808 hold88/a_326_118# _292_ 0
C20809 _547_/a_81_118# net113 0.00808f
C20810 _640_/a_741_93# net52 0
C20811 net38 _681_/a_681_505# 0
C20812 _127_ _266_ 0.05835f
C20813 _206_ _664_/a_324_432# 0.02554f
C20814 net173 _218_ 1.73105f
C20815 hold55/a_56_118# FILLER_8_238/a_32_246# 0
C20816 _705_/a_324_432# hold50/a_326_118# 0
C20817 _705_/a_741_93# hold50/a_56_118# 0
C20818 _358_/a_72_436# baud_inst.counter\[13\] 0
C20819 baud_inst.counter\[15\] FILLER_17_79/a_40_246# 0.0321f
C20820 _428_/a_354_412# net24 0.00215f
C20821 tx_inst.data_reg\[4\] _341_/a_810_118# 0
C20822 _706_/a_324_432# _119_ 0.0057f
C20823 net28 fanout37/a_40_152# 0.00138f
C20824 _031_ _555_/a_474_130# 0
C20825 _112_ _695_/a_1840_334# 0
C20826 _651_/a_1840_334# net43 0
C20827 net31 _134_ 0
C20828 _661_/a_38_114# _207_ 0
C20829 _661_/a_741_93# net55 0.00631f
C20830 tx_inst.data_reg\[7\] _146_ 0
C20831 net145 _386_/a_59_156# 0.00164f
C20832 clknet_4_8_0_clk _544_/a_46_156# 0.00184f
C20833 _536_/a_192_429# _693_/a_298_337# 0
C20834 _447_/a_81_118# net25 0.03185f
C20835 clknet_4_12_0_clk _241_ 0
C20836 _556_/a_341_118# _032_ 0.01929f
C20837 net39 _677_/a_1785_429# 0.00103f
C20838 _090_ _677_/a_2250_412# 0
C20839 _678_/a_843_236# _182_ 0
C20840 rx_data[5] _637_/a_2250_412# 0
C20841 baud_inst.counter\[26\] net45 0.00255f
C20842 baud_inst.counter\[27\] _111_ 0
C20843 _217_ clkbuf_4_5_0_clk/a_27_118# 0
C20844 baud_inst.counter\[20\] _532_/a_257_140# 0.00438f
C20845 _125_ clkbuf_4_13_0_clk/a_27_118# 0.00219f
C20846 clknet_4_12_0_clk net47 0.05876f
C20847 _448_/a_550_140# VPWR 0
C20848 _173_ hold173/a_438_182# 0
C20849 net39 _357_/a_150_412# 0
C20850 _694_/a_324_432# _302_ 0.0131f
C20851 hold55/a_438_182# net146 0
C20852 hold161/a_326_118# net40 0
C20853 baud_inst.counter\[20\] _695_/a_38_114# 0.00449f
C20854 _645_/a_324_432# net151 0.00291f
C20855 _643_/a_612_127# clknet_4_12_0_clk 0.0026f
C20856 baud_inst.counter\[2\] hold60/a_438_182# 0
C20857 net109 _682_/a_1489_191# 0
C20858 _226_ net26 0.00467f
C20859 rx_inst.state\[3\] net180 0
C20860 _694_/a_1489_191# net46 0.00253f
C20861 _699_/a_38_114# clknet_4_8_0_clk 0.0016f
C20862 net44 baud_inst.counter\[22\] 0
C20863 _041_ _141_ 0.00799f
C20864 _343_/a_155_412# _005_ 0
C20865 net2 _450_/a_127_96# 0
C20866 _390_/a_382_118# _066_ 0
C20867 _673_/a_1840_334# _287_ 0.00394f
C20868 _673_/a_2250_412# net135 0
C20869 _226_ net32 0.00279f
C20870 net118 _264_ 0
C20871 tx_inst.data_reg\[7\] _656_/a_298_337# 0
C20872 _287_ hold95/a_326_118# 0
C20873 net20 _117_ 0
C20874 _379_/a_46_156# _656_/a_2250_412# 0
C20875 hold160/a_56_118# net160 0
C20876 net35 _249_ 0.10486f
C20877 _059_ _158_ 0
C20878 _232_ _421_/a_354_412# 0
C20879 _544_/a_46_156# _686_/a_1840_334# 0
C20880 hold175/a_438_182# rx_inst.state\[2\] 0.00439f
C20881 _217_ _395_/a_146_122# 0
C20882 net21 FILLER_8_236/a_40_246# 0
C20883 _218_ FILLER_7_146/a_32_246# 0
C20884 net79 hold181/a_326_118# 0.00611f
C20885 output12/a_40_152# _128_ 0
C20886 net21 _665_/a_1785_429# 0.00112f
C20887 _159_ _158_ 1.61082f
C20888 baud_inst.counter\[23\] clknet_0_clk 0.00132f
C20889 hold101/a_326_118# baud_inst.counter\[17\] 0.01928f
C20890 _225_ _167_ 0
C20891 _660_/a_2250_412# _074_ 0
C20892 _486_/a_358_436# VPWR 0.02791f
C20893 net37 _404_/a_46_156# 0.00478f
C20894 _692_/a_612_127# _105_ 0.00146f
C20895 rx_inst.bit_index\[2\] net49 1.09913f
C20896 baud_inst.counter\[22\] hold114/a_438_182# 0
C20897 _349_/a_350_122# _037_ 0
C20898 _182_ _503_/a_165_412# 0
C20899 _688_/a_132_114# net157 0
C20900 clknet_0_clk _100_ 0
C20901 _129_ net43 0
C20902 _658_/a_550_127# net41 0
C20903 hold154/a_56_118# baud_inst.counter\[4\] 0.00184f
C20904 hold137/a_438_182# clknet_0_clk 0.00222f
C20905 _685_/a_843_236# net29 0.00131f
C20906 hold74/a_438_182# VPWR 0.00278f
C20907 _645_/a_612_127# net48 0.00129f
C20908 clknet_4_11_0_clk net49 0.04201f
C20909 _096_ _682_/a_2002_114# 0
C20910 _125_ _636_/a_550_127# 0
C20911 _284_ _036_ 0
C20912 _114_ FILLER_25_25/a_40_246# 0.00418f
C20913 FILLER_15_173/a_40_246# net26 0.00372f
C20914 _240_ _635_/a_298_337# 0
C20915 _343_/a_257_140# _196_ 0
C20916 clknet_4_5_0_clk _665_/a_741_93# 0.03641f
C20917 clknet_4_3_0_clk clknet_4_1_0_clk 0.07058f
C20918 net42 _666_/a_681_505# 0
C20919 hold116/a_326_118# baud_inst.counter\[9\] 0
C20920 _069_ _657_/a_1785_429# 0
C20921 _155_ clknet_4_15_0_clk 0.00575f
C20922 net50 _705_/a_843_236# 0
C20923 FILLER_15_173/a_40_246# net32 0.01893f
C20924 hold119/a_438_182# _223_ 0
C20925 _202_ net43 0
C20926 net56 _651_/a_298_337# 0.00134f
C20927 hold128/a_438_182# _280_ 0.00143f
C20928 _684_/a_741_93# _520_/a_155_412# 0
C20929 baud_inst.counter\[18\] _103_ 0
C20930 _478_/a_27_156# _665_/a_1840_334# 0
C20931 clknet_0_clk _668_/a_741_93# 0
C20932 _133_ net24 0.01008f
C20933 _174_ _175_ 0.11427f
C20934 hold110/a_56_118# _683_/a_298_337# 0
C20935 _282_ FILLER_9_70/a_40_246# 0
C20936 hold124/a_56_118# _048_ 0.00156f
C20937 hold111/a_326_118# _635_/a_324_432# 0
C20938 hold111/a_438_182# _635_/a_38_114# 0
C20939 net178 _684_/a_741_93# 0.00374f
C20940 hold133/a_438_182# net133 0.00247f
C20941 net182 _685_/a_843_236# 0
C20942 baud_inst.counter\[21\] _692_/a_324_432# 0
C20943 _155_ _158_ 0.001f
C20944 net49 _243_ 0.0986f
C20945 _638_/a_132_114# VPWR 0
C20946 _191_ FILLER_12_82/a_32_246# 0.01209f
C20947 _639_/a_132_114# net81 0
C20948 _059_ _633_/a_1489_191# 0
C20949 net184 hold165/a_56_118# 0
C20950 _691_/a_550_127# VPWR 0
C20951 hold66/a_326_118# clknet_0_clk 0
C20952 net56 _166_ 0.00157f
C20953 _206_ input5/a_40_152# 0.00732f
C20954 _696_/a_324_432# baud_inst.counter\[25\] 0
C20955 _159_ _633_/a_1489_191# 0
C20956 clknet_0_clk _648_/a_324_432# 0
C20957 _287_ _086_ 0
C20958 hold89/a_56_118# _687_/a_741_93# 0
C20959 hold138/a_56_118# _264_ 0.06624f
C20960 hold119/a_438_182# _240_ 0.01118f
C20961 _643_/a_1583_191# net24 0
C20962 _230_ _642_/a_2002_114# 0
C20963 _224_ _161_ 0.03263f
C20964 _639_/a_2250_412# net118 0
C20965 _658_/a_843_236# _388_/a_59_156# 0
C20966 _658_/a_741_93# _388_/a_382_118# 0
C20967 hold109/a_326_118# net97 0.02603f
C20968 net73 _269_ 0.07491f
C20969 _428_/a_252_412# VPWR 0
C20970 _189_ _296_ 0.18987f
C20971 _643_/a_2250_412# _273_ 0
C20972 hold86/a_56_118# _019_ 0
C20973 net10 tx_data[7] 0.03255f
C20974 _639_/a_38_114# hold80/a_56_118# 0
C20975 _303_ _693_/a_843_236# 0
C20976 hold56/a_326_118# net168 0
C20977 net49 _703_/a_1840_334# 0.01225f
C20978 _701_/a_741_93# _701_/a_1583_191# -0
C20979 _705_/a_38_114# net172 0
C20980 _675_/a_741_93# _674_/a_324_432# 0
C20981 hold57/a_326_118# net183 0.00136f
C20982 net152 hold92/a_56_118# 0.00458f
C20983 rx_data[4] output19/a_40_152# 0.09956f
C20984 _022_ hold147/a_326_118# 0.01455f
C20985 net61 net38 0.16656f
C20986 _033_ _085_ 0.26578f
C20987 _675_/a_1785_429# _279_ 0
C20988 _652_/a_741_93# VPWR 0.02831f
C20989 net49 _355_/a_252_412# 0
C20990 _163_ VPWR 0.19292f
C20991 net37 FILLER_14_202/a_40_246# 0
C20992 FILLER_19_139/a_40_246# _450_/a_127_436# 0
C20993 _644_/a_324_432# rx_inst.bit_index\[2\] 0
C20994 net123 hold128/a_326_118# 0
C20995 hold112/a_438_182# hold127/a_326_118# 0
C20996 _442_/a_350_122# net24 0
C20997 hold112/a_326_118# hold127/a_438_182# 0
C20998 _078_ net169 0.158f
C20999 tx_inst.bit_index\[1\] tx_inst.data_reg\[5\] 0.09425f
C21000 hold167/a_56_118# _002_ 0.01578f
C21001 _232_ _438_/a_248_122# 0
C21002 _657_/a_1785_429# clknet_4_4_0_clk 0
C21003 hold128/a_438_182# _191_ 0
C21004 net2 hold118/a_438_182# 0
C21005 baud_inst.counter\[22\] _302_ 0.88971f
C21006 clkbuf_4_0_0_clk/a_27_118# hold95/a_326_118# 0
C21007 _678_/a_612_127# clknet_0_clk 0.00124f
C21008 hold126/a_56_118# _273_ 0
C21009 net55 _070_ 0.00755f
C21010 _164_ _100_ 0.00103f
C21011 net122 _168_ 0
C21012 net37 net62 0.03856f
C21013 _462_/a_120_432# rx_inst.data_reg\[6\] 0.0027f
C21014 net28 clkbuf_4_6_0_clk/a_27_118# 0
C21015 hold59/a_438_182# _703_/a_38_114# 0
C21016 hold59/a_56_118# _703_/a_741_93# 0
C21017 _488_/a_209_168# VPWR 0.00581f
C21018 _679_/a_1583_191# baud_inst.counter\[6\] 0
C21019 _025_ clknet_4_9_0_clk 0.00614f
C21020 _696_/a_741_93# _180_ 0.00264f
C21021 _127_ _461_/a_22_110# 0.0012f
C21022 _339_/a_500_118# _172_ 0
C21023 _360_/a_308_118# tx_inst.data_reg\[0\] 0.0015f
C21024 net79 baud_inst.counter\[8\] 0.01394f
C21025 _661_/a_1840_334# _069_ 0.00515f
C21026 tx_inst.data_reg\[7\] _658_/a_681_505# 0
C21027 _206_ _659_/a_612_127# 0.01878f
C21028 _121_ _668_/a_1785_429# 0
C21029 VPWR FILLER_22_43/a_40_246# 0.13678f
C21030 _674_/a_1583_191# net86 0
C21031 _674_/a_1840_334# net181 0
C21032 net39 baud_inst.counter\[10\] 0
C21033 _049_ net30 0.0344f
C21034 hold53/a_56_118# _051_ 0
C21035 tx_inst.data_reg\[6\] _360_/a_1453_124# 0.00154f
C21036 net161 baud_inst.counter\[16\] 0.00478f
C21037 hold76/a_56_118# _695_/a_324_432# 0.00352f
C21038 FILLER_12_171/a_40_246# clknet_4_6_0_clk 0
C21039 _433_/a_142_412# _137_ -0
C21040 _433_/a_244_412# _247_ 0.00102f
C21041 hold183/a_326_118# net34 0.00107f
C21042 net45 _550_/a_474_130# 0.00329f
C21043 _673_/a_298_337# net86 0.00235f
C21044 _673_/a_38_114# net181 0.05638f
C21045 _309_ _296_ 0
C21046 _288_ net135 0
C21047 _638_/a_1583_191# net30 0.00233f
C21048 _638_/a_132_114# _266_ 0
C21049 _295_ _292_ 0.19579f
C21050 _535_/a_248_122# net107 0
C21051 net81 rx_inst.data_reg\[7\] 0
C21052 _640_/a_1840_334# _130_ 0.00283f
C21053 net38 _681_/a_550_127# 0
C21054 baud_inst.counter\[12\] hold129/a_326_118# 0.00874f
C21055 net128 hold129/a_56_118# 0
C21056 rx_data[4] _636_/a_843_236# 0.00137f
C21057 net16 _636_/a_681_505# 0
C21058 _245_ net24 0.04322f
C21059 _675_/a_550_127# net61 0
C21060 _675_/a_1489_191# _033_ 0
C21061 tx_inst.data_reg\[4\] tx_inst.bit_index\[2\] 0
C21062 _706_/a_1583_191# _042_ 0.01636f
C21063 FILLER_26_227/a_40_246# _637_/a_741_93# 0.00249f
C21064 VPWR FILLER_0_56/a_32_246# 0.06761f
C21065 _277_ net26 0
C21066 _661_/a_1785_429# net55 0
C21067 net10 clknet_4_1_0_clk 0.0013f
C21068 clknet_0_clk _037_ 0
C21069 hold90/a_56_118# _685_/a_324_432# 0
C21070 net176 net24 0
C21071 clknet_4_12_0_clk _649_/a_324_432# 0
C21072 net120 _693_/a_38_114# 0.00856f
C21073 hold102/a_438_182# _015_ 0.00101f
C21074 _662_/a_298_337# net43 0.0012f
C21075 net33 _706_/a_324_432# 0
C21076 _353_/a_248_122# _186_ -0
C21077 _009_ net109 0
C21078 _227_ net28 0.49981f
C21079 _138_ VPWR 0.11115f
C21080 _107_ FILLER_25_25/a_40_246# 0.00415f
C21081 FILLER_15_89/a_32_246# _013_ 0
C21082 _277_ net32 0
C21083 _637_/a_843_236# hold70/a_438_182# 0
C21084 clkbuf_4_10_0_clk/a_27_118# FILLER_22_54/a_40_246# 0.01205f
C21085 _220_ clknet_0_clk 0
C21086 output17/a_40_152# net17 0.03857f
C21087 hold117/a_56_118# net117 0.00243f
C21088 _079_ _667_/a_741_93# 0.00238f
C21089 _410_/a_155_412# _229_ 0
C21090 hold144/a_56_118# _448_/a_142_412# 0
C21091 _232_ VPWR 1.08672f
C21092 _677_/a_1583_191# _676_/a_1583_191# 0
C21093 baud_inst.counter\[8\] net116 0.38918f
C21094 FILLER_15_89/a_32_246# baud_inst.counter\[14\] 0
C21095 _026_ _025_ 0.00377f
C21096 _360_/a_589_385# VPWR 0
C21097 _398_/a_115_308# tx_inst.data_reg\[3\] 0
C21098 _292_ clknet_4_2_0_clk 0.8037f
C21099 baud_inst.counter\[26\] FILLER_21_96/a_40_246# 0.00697f
C21100 _650_/a_843_236# FILLER_17_199/a_40_246# 0
C21101 _635_/a_38_114# clknet_0_clk 0.00137f
C21102 clkbuf_4_0_0_clk/a_27_118# _086_ 0
C21103 net145 _659_/a_843_236# 0
C21104 hold116/a_56_118# net29 0
C21105 _269_ net118 0
C21106 hold56/a_438_182# tx_inst.bit_index\[0\] 0
C21107 _696_/a_741_93# net140 0
C21108 _696_/a_298_337# _309_ 0
C21109 _696_/a_324_432# baud_inst.counter\[24\] 0.00332f
C21110 _068_ _209_ 0
C21111 net145 net43 0
C21112 _118_ net2 0
C21113 net28 hold62/a_438_182# 0.0044f
C21114 _555_/a_474_130# _313_ 0
C21115 hold105/a_438_182# _701_/a_1583_191# 0.00197f
C21116 _663_/a_681_505# VPWR 0
C21117 _643_/a_132_114# VPWR 0
C21118 _118_ tx 0.00307f
C21119 net14 output18/a_40_152# 0.10529f
C21120 _266_ _647_/a_1785_429# 0
C21121 _232_ _239_ 0.00184f
C21122 _135_ _256_ 0
C21123 _672_/a_324_432# FILLER_0_54/a_40_246# 0
C21124 net46 net90 0.00131f
C21125 FILLER_25_177/a_40_246# _138_ 0
C21126 _641_/a_38_114# _111_ 0
C21127 _641_/a_324_432# net45 0
C21128 _046_ hold74/a_56_118# 0
C21129 net39 hold129/a_326_118# 0
C21130 clknet_4_6_0_clk hold51/a_438_182# 0
C21131 net44 _670_/a_298_337# 0
C21132 net13 _634_/a_298_337# 0
C21133 FILLER_25_177/a_40_246# _232_ 0
C21134 _203_ FILLER_7_210/a_40_246# 0
C21135 FILLER_12_171/a_40_246# net29 0.00871f
C21136 rx_data[4] hold81/a_438_182# 0
C21137 net164 _105_ 0.07946f
C21138 net48 _446_/a_146_122# 0
C21139 _073_ _198_ 0.02189f
C21140 _182_ _037_ 0.11312f
C21141 net126 _154_ 0.41286f
C21142 clknet_4_1_0_clk _149_ 0.00912f
C21143 _671_/a_38_114# clknet_4_6_0_clk 0.001f
C21144 baud_inst.counter\[18\] _688_/a_324_432# 0
C21145 net31 clkbuf_4_12_0_clk/a_27_118# 0.00249f
C21146 _292_ _683_/a_298_337# 0.00676f
C21147 _685_/a_612_127# net29 0.00157f
C21148 net49 _429_/a_244_412# 0
C21149 _654_/a_1583_191# FILLER_1_212/a_32_246# 0
C21150 net54 _665_/a_1583_191# 0.03014f
C21151 net35 clknet_4_12_0_clk 0.17717f
C21152 net75 _695_/a_132_114# 0
C21153 _442_/a_248_122# VPWR 0
C21154 _674_/a_298_337# net38 0.00438f
C21155 _012_ _357_/a_150_412# 0
C21156 _411_/a_358_436# _161_ 0
C21157 _230_ _450_/a_127_436# 0.00781f
C21158 hold120/a_438_182# baud_inst.counter\[21\] 0.00739f
C21159 hold120/a_56_118# baud_inst.counter\[23\] 0.00177f
C21160 FILLER_19_139/a_40_246# net175 0.01934f
C21161 _069_ _068_ 0
C21162 tx_inst.bit_index\[1\] _339_/a_805_385# 0.00278f
C21163 net50 _705_/a_612_127# 0.00119f
C21164 hold154/a_326_118# _035_ 0.01427f
C21165 FILLER_6_151/a_40_246# clknet_0_clk 0.02108f
C21166 hold75/a_438_182# hold76/a_56_118# 0
C21167 _141_ _651_/a_843_236# 0
C21168 _223_ _650_/a_38_114# 0
C21169 fanout28/a_40_152# clknet_0_clk 0
C21170 tx_data[7] input8/a_40_152# 0.04419f
C21171 _684_/a_741_93# _297_ 0
C21172 net13 net47 0.10065f
C21173 _151_ _383_/a_46_156# 0.00105f
C21174 _676_/a_38_114# _034_ 0.00645f
C21175 _257_ fanout35/a_40_152# 0.00268f
C21176 net110 _683_/a_38_114# 0.01618f
C21177 hold63/a_438_182# net37 0.01163f
C21178 _679_/a_1583_191# FILLER_5_74/a_32_246# 0
C21179 _698_/a_2250_412# _026_ 0.00188f
C21180 FILLER_2_81/a_32_246# net6 0
C21181 clknet_4_11_0_clk hold59/a_438_182# 0.00143f
C21182 _138_ _266_ 0
C21183 _638_/a_1489_191# VPWR 0.00234f
C21184 baud_inst.counter\[21\] _692_/a_2250_412# 0.00109f
C21185 _550_/a_209_168# net49 0
C21186 net71 _649_/a_1583_191# 0
C21187 _201_ _664_/a_1840_334# 0
C21188 _203_ _664_/a_1583_191# 0.00104f
C21189 _202_ _664_/a_2250_412# 0
C21190 rx_inst.state\[3\] _667_/a_132_114# 0
C21191 hold160/a_438_182# clknet_4_2_0_clk 0
C21192 net89 _687_/a_843_236# 0
C21193 _683_/a_324_432# _096_ 0.0141f
C21194 _119_ net168 0
C21195 _045_ _044_ 0.00258f
C21196 net48 net127 0.03601f
C21197 baud_inst.counter\[15\] net103 0
C21198 _232_ _167_ 0.00164f
C21199 _694_/a_324_432# FILLER_22_32/a_40_246# 0
C21200 clknet_4_5_0_clk FILLER_1_212/a_32_246# 0
C21201 hold168/a_438_182# VPWR 0.0041f
C21202 hold77/a_438_182# clknet_4_14_0_clk 0
C21203 hold125/a_326_118# _154_ 0
C21204 _093_ net136 0.10626f
C21205 _658_/a_324_432# net165 0.0036f
C21206 _513_/a_155_160# _186_ 0
C21207 _539_/a_139_160# _296_ 0
C21208 _547_/a_379_118# baud_inst.counter\[25\] 0
C21209 _057_ _264_ 0
C21210 _659_/a_38_114# _657_/a_298_337# 0
C21211 _392_/a_59_156# clknet_4_4_0_clk 0
C21212 _659_/a_298_337# _657_/a_38_114# 0
C21213 rx_inst.state\[2\] hold180/a_438_182# 0.01806f
C21214 _229_ hold180/a_56_118# 0.06191f
C21215 hold100/a_438_182# _697_/a_298_337# 0
C21216 hold100/a_326_118# _697_/a_38_114# 0
C21217 hold165/a_326_118# _206_ 0
C21218 _639_/a_324_432# net80 0.04776f
C21219 hold96/a_438_182# _679_/a_298_337# 0
C21220 hold96/a_326_118# _679_/a_38_114# 0
C21221 _690_/a_1583_191# net40 0
C21222 VPWR hold73/a_326_118# 0.00107f
C21223 _052_ VPWR 0.23387f
C21224 _643_/a_1583_191# net30 0
C21225 _675_/a_1840_334# _674_/a_843_236# 0
C21226 tx_inst.data_reg\[2\] _071_ 0
C21227 _675_/a_2250_412# _674_/a_741_93# 0
C21228 net57 _221_ 0.00227f
C21229 _081_ _668_/a_298_337# 0.03867f
C21230 net31 net26 0.03285f
C21231 _660_/a_324_432# net3 0
C21232 _278_ fanout42/a_40_152# 0
C21233 net118 _153_ 0.74314f
C21234 _678_/a_324_432# _282_ 0.0038f
C21235 _678_/a_843_236# net152 0
C21236 hold137/a_438_182# net43 0.02279f
C21237 _671_/a_38_114# net29 0.04716f
C21238 FILLER_19_139/a_40_246# _161_ 0.02649f
C21239 _023_ _536_/a_192_429# 0
C21240 _537_/a_192_429# _022_ 0
C21241 hold120/a_56_118# _694_/a_1840_334# 0.00193f
C21242 hold120/a_326_118# _694_/a_1583_191# 0
C21243 _677_/a_1583_191# _677_/a_2250_412# 0
C21244 clknet_0_clk hold90/a_326_118# 0.00557f
C21245 net31 net32 1.35881f
C21246 VPWR clkbuf_4_1_0_clk/a_27_118# 0.06273f
C21247 _255_ net24 0.07401f
C21248 _458_/a_165_412# _140_ 0
C21249 _465_/a_22_110# _047_ 0.00139f
C21250 net124 clknet_0_clk 0.01107f
C21251 _176_ clknet_4_4_0_clk 0.01681f
C21252 output22/a_40_152# FILLER_10_222/a_32_246# 0.00624f
C21253 _686_/a_38_114# net29 0
C21254 _643_/a_324_432# _154_ 0.00179f
C21255 _068_ clknet_4_4_0_clk 0.00413f
C21256 _479_/a_22_110# clknet_0_clk 0
C21257 clknet_0_clk _667_/a_1840_334# 0.00125f
C21258 _050_ FILLER_16_221/a_32_246# 0
C21259 _392_/a_285_412# _076_ 0
C21260 net93 clknet_0_clk 0
C21261 hold154/a_438_182# _280_ 0.05377f
C21262 net84 _636_/a_741_93# 0
C21263 _128_ rx_inst.data_reg\[6\] 0.16659f
C21264 _267_ _632_/a_741_93# 0
C21265 _043_ _638_/a_843_236# 0
C21266 _680_/a_612_127# FILLER_5_32/a_40_246# 0
C21267 _198_ net41 0
C21268 clk _400_/a_192_429# 0.00201f
C21269 hold178/a_438_182# baud_inst.counter\[13\] 0
C21270 net43 _668_/a_741_93# 0
C21271 FILLER_16_70/a_40_246# _515_/a_76_160# 0.00216f
C21272 _313_ _702_/a_324_432# 0.00262f
C21273 _248_ net30 0.00409f
C21274 tx_inst.data_reg\[7\] _658_/a_550_127# 0
C21275 fanout38/a_40_152# _039_ 0.00481f
C21276 hold55/a_438_182# _705_/a_1583_191# 0
C21277 hold55/a_326_118# _705_/a_1840_334# 0
C21278 _081_ clknet_4_6_0_clk 0.03191f
C21279 FILLER_14_202/a_40_246# _650_/a_1583_191# 0
C21280 VPWR FILLER_20_95/a_40_246# 0.13765f
C21281 _555_/a_209_168# _700_/a_324_432# 0
C21282 _147_ _149_ 0.20426f
C21283 _126_ _647_/a_1583_191# 0.00121f
C21284 hold76/a_438_182# _303_ 0
C21285 net44 hold100/a_56_118# 0
C21286 baud_inst.counter\[7\] hold94/a_326_118# 0.01976f
C21287 clknet_4_3_0_clk hold94/a_438_182# 0.00284f
C21288 tx_inst.data_reg\[6\] _360_/a_1377_160# 0.00207f
C21289 net55 _706_/a_38_114# 0.02954f
C21290 _643_/a_324_432# FILLER_20_198/a_40_246# 0
C21291 _112_ net46 0.02584f
C21292 VPWR _523_/a_155_412# 0.01992f
C21293 _156_ _137_ 0.0168f
C21294 hold54/a_56_118# VPWR 0.00573f
C21295 net2 _000_ 0.02608f
C21296 hold105/a_56_118# baud_inst.counter\[29\] 0.03581f
C21297 _707_/a_298_337# _668_/a_1583_191# 0.00143f
C21298 fanout30/a_40_152# _235_ 0
C21299 _673_/a_1840_334# net181 0
C21300 _673_/a_1583_191# net86 0.00172f
C21301 _449_/a_229_118# net49 0
C21302 hold150/a_56_118# net47 0.01662f
C21303 _455_/a_257_140# _263_ 0.00354f
C21304 _448_/a_550_140# _232_ 0
C21305 _656_/a_324_432# _146_ 0.00605f
C21306 _656_/a_843_236# net165 0
C21307 net122 _278_ 0.14366f
C21308 net37 rx_inst.state\[3\] 0.47816f
C21309 _668_/a_1840_334# net19 0.00336f
C21310 _642_/a_1583_191# net180 0
C21311 _638_/a_2002_114# net30 0
C21312 net32 _440_/a_550_140# 0
C21313 _183_ _683_/a_741_93# 0
C21314 _018_ _301_ 0
C21315 _690_/a_1489_191# net103 0
C21316 _690_/a_132_114# net101 0
C21317 _690_/a_741_93# _300_ 0
C21318 _224_ _418_/a_268_412# 0
C21319 net114 _314_ 0
C21320 net177 VPWR 0.0732f
C21321 rx_inst.state\[2\] _137_ 0
C21322 hold65/a_438_182# rx_inst.data_reg\[6\] 0.00192f
C21323 hold65/a_56_118# _632_/a_843_236# 0
C21324 _255_ _438_/a_146_122# 0.00369f
C21325 baud_inst.counter\[3\] _033_ 0.01631f
C21326 _706_/a_2002_114# _042_ 0
C21327 _432_/a_146_122# clknet_0_clk 0
C21328 net132 _135_ 0.21387f
C21329 _055_ net151 0
C21330 _072_ net55 0.01132f
C21331 _103_ _527_/a_192_429# 0.00119f
C21332 net120 _693_/a_1840_334# 0
C21333 fanout33/a_40_152# _706_/a_1489_191# 0
C21334 net93 _182_ 0
C21335 _230_ net175 0.0696f
C21336 _643_/a_324_432# _160_ 0.00611f
C21337 _107_ net1 0
C21338 _425_/a_46_156# net52 0.00185f
C21339 hold144/a_56_118# _160_ 0
C21340 FILLER_16_154/a_32_246# fanout28/a_40_152# 0.00624f
C21341 hold52/a_56_118# net24 0.00749f
C21342 _641_/a_741_93# _052_ 0.00246f
C21343 _641_/a_324_432# net176 0.01107f
C21344 hold154/a_438_182# _191_ 0
C21345 _677_/a_741_93# _034_ 0
C21346 net154 _676_/a_741_93# 0
C21347 _117_ _704_/a_38_114# 0.01733f
C21348 net30 hold73/a_438_182# 0.00321f
C21349 baud_inst.counter\[28\] _699_/a_1583_191# 0.00197f
C21350 _179_ _699_/a_843_236# 0
C21351 FILLER_13_68/a_40_246# _190_ 0
C21352 _360_/a_1023_118# VPWR 0
C21353 hold112/a_56_118# _139_ 0
C21354 _656_/a_298_337# _656_/a_324_432# -0
C21355 net43 _667_/a_38_114# 0
C21356 hold131/a_438_182# VPWR 0.00873f
C21357 _515_/a_76_160# baud_inst.counter\[13\] 0
C21358 _514_/a_257_140# net29 0
C21359 _696_/a_2250_412# baud_inst.counter\[24\] 0.00411f
C21360 _206_ _214_ 0.12298f
C21361 _003_ clknet_0_clk 0
C21362 _226_ hold180/a_438_182# 0.00406f
C21363 _136_ net25 0.00253f
C21364 _513_/a_192_429# _684_/a_843_236# 0
C21365 _663_/a_550_127# VPWR 0
C21366 baud_inst.counter\[26\] _051_ 0.00133f
C21367 net94 _678_/a_324_432# 0
C21368 net92 _678_/a_38_114# 0
C21369 _283_ _678_/a_298_337# 0
C21370 _246_ net48 0
C21371 _643_/a_1489_191# VPWR 0
C21372 FILLER_15_17/a_40_246# baud_inst.counter\[16\] 0
C21373 _547_/a_379_118# baud_inst.counter\[24\] 0
C21374 _264_ net80 0.07775f
C21375 _660_/a_843_236# net170 0
C21376 _185_ _183_ 0.19192f
C21377 _058_ hold119/a_326_118# 0
C21378 _545_/a_248_122# net99 0
C21379 _653_/a_324_432# net183 0
C21380 net115 _683_/a_741_93# 0
C21381 _095_ _096_ 0.00373f
C21382 rx_done _639_/a_298_337# 0
C21383 net26 _404_/a_46_156# 0
C21384 net120 FILLER_24_19/a_40_246# 0
C21385 baud_inst.counter\[22\] FILLER_22_32/a_40_246# 0
C21386 clknet_4_0_0_clk _183_ 0.00117f
C21387 net57 _652_/a_2250_412# 0
C21388 clknet_4_11_0_clk _699_/a_741_93# 0
C21389 hold161/a_438_182# _015_ 0
C21390 _647_/a_324_432# net139 0
C21391 net48 _258_ 0.22831f
C21392 _218_ _396_/a_257_140# 0
C21393 net161 _016_ 0
C21394 rx_data[7] _668_/a_1583_191# 0
C21395 _127_ _634_/a_324_432# 0
C21396 _051_ net24 0
C21397 net97 net40 0.00157f
C21398 _671_/a_1840_334# clknet_4_6_0_clk 0.0116f
C21399 _234_ rx_inst.state\[4\] 0.03478f
C21400 hold146/a_56_118# _479_/a_22_110# 0
C21401 _292_ _683_/a_1583_191# 0
C21402 net130 net29 0.00181f
C21403 net54 _665_/a_2002_114# 0.00168f
C21404 _305_ _695_/a_550_127# 0
C21405 _023_ _695_/a_612_127# 0
C21406 net40 net86 0
C21407 _674_/a_1583_191# net38 0
C21408 _086_ net181 0.07266f
C21409 net129 _190_ 0.1352f
C21410 _294_ _189_ 0.00397f
C21411 _270_ net64 0.02047f
C21412 _090_ net137 0.00229f
C21413 FILLER_25_198/a_32_246# clkbuf_4_15_0_clk/a_27_118# 0
C21414 _230_ _161_ 0.1261f
C21415 _117_ hold146/a_326_118# 0
C21416 _680_/a_1840_334# _489_/a_115_308# 0
C21417 _680_/a_1583_191# _489_/a_358_436# 0
C21418 hold52/a_438_182# _161_ 0.00199f
C21419 _180_ FILLER_22_86/a_32_246# 0
C21420 FILLER_10_78/a_32_246# _185_ 0
C21421 _292_ FILLER_14_70/a_40_246# 0.00446f
C21422 _170_ fanout31/a_40_152# 0
C21423 _653_/a_1489_191# VPWR 0.00104f
C21424 _486_/a_115_308# _409_/a_73_118# 0.00164f
C21425 _701_/a_1840_334# baud_inst.counter\[29\] 0
C21426 _203_ FILLER_5_207/a_32_246# 0.00288f
C21427 VPWR _665_/a_298_337# 0.00266f
C21428 _117_ hold51/a_56_118# 0
C21429 _670_/a_132_114# clknet_0_clk 0
C21430 _673_/a_298_337# net38 0.01774f
C21431 hold173/a_56_118# _142_ 0
C21432 hold173/a_326_118# _220_ 0
C21433 _220_ net43 0
C21434 _129_ net51 0
C21435 clkbuf_0_clk/a_116_82# FILLER_15_127/a_32_246# 0.00119f
C21436 _141_ _651_/a_612_127# 0.00127f
C21437 rx_inst.bit_index\[1\] _249_ 0.00508f
C21438 net32 _422_/a_248_122# 0.0019f
C21439 _126_ net74 0.05456f
C21440 VPWR _477_/a_120_432# 0.00152f
C21441 _173_ _196_ 0.06371f
C21442 net26 _666_/a_38_114# 0.0733f
C21443 _689_/a_1489_191# net40 0.00115f
C21444 net49 _418_/a_46_156# 0.00178f
C21445 hold182/a_438_182# baud_inst.counter\[4\] 0.00238f
C21446 _555_/a_177_436# net105 0
C21447 _112_ _313_ 0.00545f
C21448 _225_ _406_/a_154_118# 0
C21449 clknet_4_3_0_clk _676_/a_741_93# 0.03585f
C21450 _048_ _648_/a_2250_412# 0
C21451 input9/a_40_152# tx_data[6] 0.0322f
C21452 _666_/a_741_93# FILLER_8_191/a_32_246# 0
C21453 net18 VPWR 0.30188f
C21454 _679_/a_298_337# net96 0.00572f
C21455 hold167/a_56_118# _669_/a_1583_191# 0
C21456 _002_ _669_/a_324_432# 0
C21457 net167 _669_/a_38_114# 0.02125f
C21458 _246_ _250_ 0
C21459 _633_/a_1583_191# _264_ 0
C21460 _643_/a_843_236# _043_ 0
C21461 _195_ _403_/a_22_110# 0
C21462 _217_ _403_/a_120_432# 0.00127f
C21463 _294_ hold129/a_438_182# 0.01218f
C21464 net37 _447_/a_175_118# 0.00249f
C21465 _185_ net115 0
C21466 FILLER_14_164/a_32_246# clknet_0_clk 0
C21467 _273_ _649_/a_1583_191# 0.00122f
C21468 net147 _693_/a_741_93# 0
C21469 _304_ _693_/a_324_432# 0
C21470 clknet_4_0_0_clk net115 0.0062f
C21471 _693_/a_741_93# net46 0.0113f
C21472 hold74/a_56_118# net2 0
C21473 net53 _698_/a_741_93# 0.00168f
C21474 clknet_4_11_0_clk _698_/a_681_505# 0
C21475 FILLER_7_7/a_40_246# _094_ 0.01214f
C21476 _405_/a_27_156# _224_ 0.01259f
C21477 _069_ _388_/a_382_118# 0
C21478 _658_/a_1583_191# _146_ 0
C21479 _658_/a_2250_412# net165 0.00491f
C21480 _143_ net39 0
C21481 tx_inst.data_reg\[4\] _661_/a_1583_191# 0
C21482 _276_ clknet_4_4_0_clk 0
C21483 hold126/a_56_118# _638_/a_741_93# 0
C21484 _659_/a_843_236# _657_/a_843_236# 0.00216f
C21485 _374_/a_244_412# clknet_4_6_0_clk 0
C21486 baud_inst.counter\[13\] net91 0
C21487 net100 _697_/a_741_93# 0
C21488 hold116/a_56_118# _288_ 0.07887f
C21489 _689_/a_298_337# _015_ 0
C21490 _690_/a_2002_114# net40 0
C21491 _701_/a_132_114# net107 0
C21492 _303_ net149 0
C21493 _657_/a_843_236# net43 0
C21494 _094_ _681_/a_741_93# 0.00149f
C21495 VPWR net157 0.13037f
C21496 _098_ _292_ 0.01496f
C21497 net37 net19 0.00101f
C21498 net138 _156_ 0.0441f
C21499 net124 _048_ 0
C21500 _643_/a_1489_191# _266_ 0
C21501 clknet_4_13_0_clk net65 0
C21502 net4 net38 0.02465f
C21503 _678_/a_2250_412# _211_ 0
C21504 rx_inst.state\[2\] _669_/a_741_93# 0
C21505 _202_ FILLER_5_213/a_32_246# 0.00522f
C21506 _691_/a_1840_334# net49 0.02892f
C21507 fanout36/a_40_152# _224_ 0.0015f
C21508 tx_inst.bit_index\[2\] _396_/a_155_412# 0
C21509 tx_inst.bit_index\[1\] hold57/a_438_182# 0
C21510 _063_ VPWR 0.07172f
C21511 _671_/a_1840_334# net29 0
C21512 FILLER_22_86/a_32_246# net140 0
C21513 _305_ _022_ 0.14428f
C21514 _358_/a_72_436# net29 0.02254f
C21515 net54 _203_ 0
C21516 hold157/a_438_182# baud_inst.counter\[17\] 0
C21517 clknet_4_1_0_clk clknet_0_clk 0.7734f
C21518 _686_/a_1840_334# net29 0
C21519 _643_/a_2250_412# _154_ 0
C21520 _341_/a_1377_160# net54 0
C21521 hold157/a_326_118# _688_/a_298_337# 0
C21522 hold159/a_326_118# tx_inst.data_reg\[1\] 0.02366f
C21523 _171_ _198_ 0.20309f
C21524 net55 _388_/a_559_412# 0.00308f
C21525 _661_/a_741_93# hold155/a_326_118# 0.00638f
C21526 _661_/a_843_236# hold155/a_56_118# 0
C21527 _661_/a_324_432# hold155/a_438_182# 0
C21528 _638_/a_38_114# net70 0.01618f
C21529 net26 net62 0.21697f
C21530 _680_/a_741_93# _279_ 0
C21531 hold55/a_438_182# net33 0.00238f
C21532 baud_inst.counter\[12\] _685_/a_298_337# 0
C21533 net28 net118 0
C21534 _127_ net18 0.01316f
C21535 hold134/a_326_118# VPWR 0.004f
C21536 baud_inst.counter\[28\] hold107/a_438_182# 0.00182f
C21537 _690_/a_38_114# _015_ 0
C21538 _690_/a_324_432# _296_ 0
C21539 _690_/a_741_93# net160 0
C21540 _170_ _168_ 0
C21541 clknet_4_3_0_clk _185_ 0.00758f
C21542 net37 _671_/a_298_337# 0
C21543 _233_ rx_inst.state\[4\] 0
C21544 net141 hold91/a_438_182# 0
C21545 net32 net62 0.00242f
C21546 net108 _682_/a_843_236# 0
C21547 _694_/a_741_93# clknet_4_10_0_clk 0.02378f
C21548 _360_/a_295_385# clk 0.00147f
C21549 _527_/a_341_118# baud_inst.counter\[17\] 0
C21550 hold184/a_56_118# _216_ 0
C21551 _653_/a_324_432# _652_/a_1583_191# 0
C21552 net182 _358_/a_72_436# 0.00336f
C21553 _047_ _156_ 0.00928f
C21554 _645_/a_843_236# VPWR 0.00438f
C21555 baud_inst.counter\[27\] _698_/a_741_93# 0
C21556 baud_inst.counter\[26\] _698_/a_324_432# 0.00133f
C21557 _372_/a_22_110# _224_ 0
C21558 hold126/a_326_118# net126 0
C21559 tx_inst.data_reg\[6\] tx_inst.bit_index\[1\] 0.02669f
C21560 hold150/a_326_118# net131 0.00125f
C21561 net176 FILLER_20_106/a_32_246# 0.02795f
C21562 _691_/a_843_236# FILLER_17_22/a_40_246# 0
C21563 _138_ _232_ 0.09741f
C21564 VPWR _298_ 0.0974f
C21565 hold122/a_56_118# net183 0.00357f
C21566 _282_ net95 0
C21567 net62 hold62/a_326_118# 0.00729f
C21568 _168_ hold62/a_56_118# 0.00124f
C21569 hold57/a_56_118# _651_/a_38_114# 0
C21570 clkbuf_4_2_0_clk/a_27_118# net40 0
C21571 _230_ clkbuf_4_14_0_clk/a_27_118# 0.00219f
C21572 clknet_4_4_0_clk _388_/a_382_118# 0
C21573 _000_ _084_ 0
C21574 hold118/a_56_118# _265_ 0
C21575 clknet_4_1_0_clk _386_/a_59_156# 0.00112f
C21576 _168_ _650_/a_1489_191# 0
C21577 hold136/a_438_182# _038_ 0.00376f
C21578 baud_inst.counter\[18\] _355_/a_252_412# 0
C21579 FILLER_16_56/a_32_246# clkbuf_4_8_0_clk/a_27_118# 0.00571f
C21580 hold75/a_438_182# _695_/a_843_236# 0
C21581 _201_ _368_/a_257_140# 0.00145f
C21582 _445_/a_279_412# VPWR 0
C21583 hold142/a_438_182# VPWR 0.00259f
C21584 _661_/a_843_236# FILLER_0_128/a_40_246# 0
C21585 _690_/a_1489_191# net101 0.00222f
C21586 net35 _449_/a_27_156# 0
C21587 baud_inst.counter\[20\] net147 0.17478f
C21588 VPWR _634_/a_2250_412# 0.00198f
C21589 baud_inst.counter\[20\] net46 0.52467f
C21590 VPWR _681_/a_681_505# 0
C21591 clknet_4_1_0_clk _182_ 0.00218f
C21592 _635_/a_38_114# clkbuf_4_13_0_clk/a_27_118# 0
C21593 FILLER_26_227/a_40_246# _048_ 0
C21594 net67 hold106/a_56_118# 0
C21595 net100 clknet_0_clk 0.07169f
C21596 FILLER_1_173/a_32_246# net41 0
C21597 hold127/a_56_118# net24 0
C21598 fanout45/a_40_152# _106_ 0
C21599 FILLER_23_204/a_40_246# net47 0.01791f
C21600 _536_/a_341_118# net149 0
C21601 fanout33/a_40_152# _042_ 0.00117f
C21602 _188_ VPWR 0.24806f
C21603 _696_/a_843_236# _099_ 0
C21604 _696_/a_681_505# net46 0
C21605 _651_/a_1840_334# _274_ 0
C21606 _644_/a_1840_334# clkbuf_4_14_0_clk/a_27_118# 0
C21607 _543_/a_146_122# _308_ 0.00268f
C21608 _305_ _108_ 0
C21609 _643_/a_2250_412# _160_ 0.00508f
C21610 clkbuf_0_clk/a_116_82# _409_/a_73_118# 0
C21611 _310_ _308_ 0.03896f
C21612 _641_/a_1785_429# _052_ 0
C21613 _058_ net37 0
C21614 clk tx_data[6] 0
C21615 _511_/a_150_412# _186_ 0
C21616 _117_ _704_/a_1840_334# 0
C21617 baud_inst.counter\[31\] _699_/a_1489_191# 0
C21618 _512_/a_165_412# _010_ 0.00224f
C21619 net39 _689_/a_298_337# 0.0055f
C21620 VPWR _649_/a_843_236# 0.00489f
C21621 _194_ _274_ 0.00544f
C21622 net43 _667_/a_1840_334# 0.00472f
C21623 net36 fanout35/a_40_152# 0.01361f
C21624 _285_ _673_/a_298_337# 0
C21625 _283_ _673_/a_38_114# 0
C21626 _643_/a_38_114# net47 0.00298f
C21627 _643_/a_298_337# _054_ 0.00516f
C21628 _173_ tx_inst.data_reg\[0\] 0
C21629 _163_ _684_/a_681_505# 0
C21630 _513_/a_341_118# _684_/a_1840_334# 0
C21631 _011_ _684_/a_741_93# 0.00215f
C21632 _050_ _047_ 0
C21633 _657_/a_324_432# _211_ 0
C21634 _189_ _683_/a_1785_429# 0
C21635 clknet_4_7_0_clk VPWR 0.42274f
C21636 _251_ FILLER_25_141/a_32_246# 0
C21637 hold147/a_326_118# _302_ 0.0168f
C21638 FILLER_13_228/a_40_246# _121_ 0
C21639 hold182/a_56_118# hold123/a_438_182# 0
C21640 hold125/a_326_118# net49 0
C21641 _236_ FILLER_25_163/a_32_246# 0
C21642 net113 _309_ 0.00131f
C21643 _378_/a_559_412# VPWR 0
C21644 _064_ FILLER_8_118/a_32_246# 0.01183f
C21645 _639_/a_324_432# _121_ 0
C21646 net99 baud_inst.counter\[25\] 0.18053f
C21647 _660_/a_612_127# net170 0
C21648 hold110/a_438_182# _292_ 0.01157f
C21649 hold110/a_326_118# _010_ 0.0113f
C21650 _360_/a_886_118# net9 0.00176f
C21651 _653_/a_1583_191# _221_ 0
C21652 _653_/a_2250_412# net183 0.0082f
C21653 _278_ FILLER_11_123/a_40_246# 0.00118f
C21654 net27 clknet_0_clk 0.07024f
C21655 _524_/a_248_122# baud_inst.counter\[16\] 0.0012f
C21656 _089_ VPWR 0.11774f
C21657 _248_ _423_/a_279_412# -0
C21658 hold79/a_326_118# _085_ 0.00226f
C21659 _147_ clknet_0_clk 0.03921f
C21660 _083_ _685_/a_2250_412# 0
C21661 hold85/a_326_118# _636_/a_1840_334# 0.00108f
C21662 hold85/a_438_182# _636_/a_1583_191# 0.00198f
C21663 rx_inst.bit_index\[2\] net25 0.25046f
C21664 net135 _683_/a_298_337# 0
C21665 clknet_0_clk _296_ 0.04224f
C21666 _662_/a_324_432# net54 0.02422f
C21667 hold146/a_326_118# _006_ 0
C21668 hold146/a_438_182# _275_ 0
C21669 net44 hold163/a_326_118# 0.00368f
C21670 _023_ net76 0.03262f
C21671 _674_/a_1489_191# _085_ 0
C21672 VPWR _651_/a_741_93# 0.02164f
C21673 net44 baud_inst.counter\[12\] 0
C21674 _454_/a_257_140# _262_ 0
C21675 _662_/a_681_505# clknet_4_5_0_clk 0
C21676 _350_/a_279_412# _183_ 0.00174f
C21677 net44 _696_/a_38_114# 0.00344f
C21678 _637_/a_741_93# _264_ 0
C21679 net27 _077_ 0
C21680 FILLER_24_229/a_32_246# clknet_4_15_0_clk 0.00116f
C21681 net173 _171_ 0
C21682 hold138/a_438_182# net138 0.03f
C21683 VPWR _665_/a_1583_191# 0.00685f
C21684 _670_/a_1489_191# clknet_0_clk 0.00127f
C21685 _223_ hold62/a_438_182# 0.00335f
C21686 _673_/a_1583_191# net38 0.02656f
C21687 _686_/a_843_236# hold90/a_438_182# 0
C21688 _424_/a_244_412# net24 0
C21689 net94 net95 0.02834f
C21690 hold117/a_56_118# _682_/a_324_432# 0
C21691 net92 net29 0.06469f
C21692 _222_ clknet_4_6_0_clk 0.00147f
C21693 _701_/a_298_337# net46 0
C21694 _363_/a_22_110# VPWR 0
C21695 hold96/a_326_118# _292_ 0
C21696 VPWR _007_ 0.16836f
C21697 _080_ clkbuf_0_clk/a_116_82# 0.00109f
C21698 hold63/a_438_182# net26 0.00506f
C21699 baud_inst.counter\[26\] _543_/a_248_122# 0
C21700 net58 hold59/a_326_118# 0.01332f
C21701 net55 net172 0.23567f
C21702 net26 _666_/a_1840_334# 0
C21703 baud_inst.counter\[17\] net40 0.83435f
C21704 net177 _163_ 0.6685f
C21705 net44 net88 0
C21706 clknet_4_3_0_clk _676_/a_1785_429# 0
C21707 net37 _205_ 1.88476f
C21708 _043_ net47 0.70872f
C21709 hold63/a_56_118# _231_ 0
C21710 _702_/a_298_337# _700_/a_1840_334# 0
C21711 baud_inst.counter\[26\] _025_ 0
C21712 FILLER_8_171/a_32_246# _222_ 0
C21713 _147_ _386_/a_59_156# 0.01679f
C21714 _068_ _386_/a_382_118# 0.02214f
C21715 _002_ _669_/a_2250_412# 0.00448f
C21716 _268_ rx_inst.data_reg\[6\] 0
C21717 _218_ _222_ 0
C21718 _217_ _141_ 0.01884f
C21719 _659_/a_298_337# net41 0.00603f
C21720 _128_ hold70/a_56_118# 0.02355f
C21721 _267_ hold70/a_326_118# 0.00492f
C21722 _500_/a_155_412# net40 0.00144f
C21723 hold55/a_326_118# tx_done 0
C21724 _273_ _649_/a_2002_114# 0
C21725 _240_ hold62/a_438_182# 0
C21726 hold150/a_326_118# _644_/a_2250_412# 0
C21727 baud_inst.counter\[12\] _517_/a_380_412# 0
C21728 _100_ _687_/a_132_114# 0
C21729 net36 _132_ 0.00217f
C21730 _693_/a_1785_429# net46 0
C21731 rx_inst.bit_index\[1\] clknet_4_12_0_clk 0.01505f
C21732 hold152/a_326_118# _142_ 0.00185f
C21733 _517_/a_209_168# _696_/a_741_93# 0
C21734 hold103/a_326_118# hold103/a_438_182# -0
C21735 _266_ _649_/a_843_236# 0
C21736 net27 _666_/a_1489_191# 0
C21737 net53 _698_/a_1785_429# 0
C21738 baud_inst.counter\[26\] _699_/a_1583_191# 0
C21739 baud_inst.counter\[27\] _699_/a_1840_334# 0
C21740 _064_ hold152/a_56_118# 0
C21741 net42 hold152/a_326_118# 0.00311f
C21742 _152_ _375_/a_170_412# 0
C21743 _230_ FILLER_18_148/a_40_246# 0
C21744 _658_/a_2002_114# _146_ 0
C21745 clknet_4_0_0_clk _504_/a_474_130# 0
C21746 hold169/a_326_118# net183 0
C21747 _676_/a_741_93# baud_inst.counter\[5\] 0
C21748 _519_/a_81_118# baud_inst.counter\[14\] 0
C21749 hold53/a_438_182# net36 0
C21750 _643_/a_298_337# _060_ 0.00128f
C21751 _659_/a_1840_334# _657_/a_1583_191# 0
C21752 _659_/a_1583_191# _657_/a_1840_334# 0
C21753 hold138/a_438_182# _047_ 0.00213f
C21754 _698_/a_38_114# VPWR 0.01004f
C21755 _689_/a_2250_412# net160 0
C21756 net155 _390_/a_496_118# 0
C21757 hold162/a_438_182# _109_ 0.00357f
C21758 _178_ _699_/a_843_236# 0.00919f
C21759 hold55/a_326_118# net55 0
C21760 hold101/a_326_118# VPWR 0.01137f
C21761 _154_ _649_/a_298_337# 0.01146f
C21762 _312_ _547_/a_81_118# 0.00113f
C21763 hold137/a_56_118# tx_inst.data_reg\[5\] 0.01543f
C21764 FILLER_16_70/a_40_246# clkbuf_4_8_0_clk/a_27_118# 0.01205f
C21765 rx_inst.state\[2\] _669_/a_1785_429# 0
C21766 net93 net152 0.00391f
C21767 _145_ net7 0.00161f
C21768 VPWR net61 0.22849f
C21769 _677_/a_550_127# net154 0
C21770 input2/a_40_152# net2 0
C21771 _077_ _706_/a_298_337# 0
C21772 _670_/a_324_432# clknet_4_9_0_clk 0.03977f
C21773 _205_ _670_/a_843_236# 0
C21774 hold65/a_326_118# hold70/a_326_118# 0.00159f
C21775 net109 baud_inst.counter\[10\] 0.39152f
C21776 net44 _529_/a_45_160# 0.02709f
C21777 net103 _687_/a_741_93# 0
C21778 _301_ _687_/a_38_114# 0
C21779 tx input2/a_40_152# 0
C21780 _230_ _418_/a_268_412# 0
C21781 _536_/a_155_160# _303_ 0
C21782 _704_/a_843_236# rx_inst.state\[1\] 0
C21783 hold155/a_438_182# clknet_4_1_0_clk 0.0026f
C21784 _076_ net172 0.01041f
C21785 _461_/a_22_110# net18 0.01757f
C21786 output21/a_40_152# tx 0.00256f
C21787 _022_ _695_/a_38_114# 0.00243f
C21788 net155 _145_ 0
C21789 net34 tx_inst.data_reg\[2\] 0
C21790 _174_ clknet_4_4_0_clk 0.01496f
C21791 hold122/a_438_182# clk 0
C21792 _164_ _296_ 0
C21793 _650_/a_1583_191# net19 0.01927f
C21794 _043_ net70 0
C21795 _357_/a_354_412# _189_ 0.00372f
C21796 _358_/a_268_436# net40 0.00344f
C21797 _690_/a_2250_412# _296_ 0
C21798 _227_ _261_ 0.00132f
C21799 net145 _339_/a_71_118# 0.01923f
C21800 net37 _671_/a_1583_191# 0
C21801 hold162/a_326_118# VPWR 0.00726f
C21802 _341_/a_1453_124# VPWR 0.00717f
C21803 net40 net38 0.14534f
C21804 net182 hold123/a_438_182# 0
C21805 _405_/a_229_118# _169_ 0
C21806 baud_inst.counter\[23\] _540_/a_139_160# 0
C21807 _694_/a_1785_429# clknet_4_10_0_clk 0.00129f
C21808 hold146/a_56_118# net27 0
C21809 _665_/a_1583_191# FILLER_7_234/a_32_246# 0
C21810 _695_/a_2250_412# baud_inst.counter\[25\] 0
C21811 _031_ _701_/a_1583_191# 0
C21812 net99 baud_inst.counter\[24\] 0.21204f
C21813 _660_/a_843_236# _392_/a_59_156# 0.00122f
C21814 _660_/a_741_93# _392_/a_382_118# 0
C21815 tx_done _705_/a_843_236# 0
C21816 net44 hold104/a_56_118# 0.0098f
C21817 VPWR hold71/a_326_118# 0.00357f
C21818 _699_/a_2250_412# hold113/a_438_182# 0
C21819 _653_/a_741_93# _652_/a_1489_191# 0
C21820 _653_/a_1583_191# _652_/a_2250_412# 0
C21821 _532_/a_155_412# FILLER_20_0/a_40_246# 0
C21822 net110 baud_inst.counter\[10\] 0
C21823 baud_inst.counter\[26\] _698_/a_2250_412# 0.0107f
C21824 _660_/a_132_114# net41 0
C21825 net98 _689_/a_324_432# 0
C21826 _224_ _140_ 0
C21827 rx_inst.state\[1\] hold81/a_56_118# 0
C21828 FILLER_19_132/a_40_246# _132_ 0
C21829 hold147/a_56_118# _692_/a_1583_191# 0
C21830 net51 _668_/a_741_93# 0.02703f
C21831 _707_/a_38_114# rx_inst.state\[1\] 0.00223f
C21832 rx_inst.state\[3\] net26 0.34139f
C21833 net44 _531_/a_177_436# 0.00241f
C21834 hold125/a_56_118# _649_/a_324_432# 0
C21835 net57 _651_/a_324_432# 0.00371f
C21836 hold131/a_438_182# _138_ 0
C21837 rx_inst.bit_index\[2\] _139_ 0
C21838 _183_ _096_ 0
C21839 _168_ rx_inst.data_reg\[7\] 0
C21840 FILLER_28_176/a_32_246# net47 0
C21841 net55 _705_/a_843_236# 0.00195f
C21842 hold177/a_326_118# baud_inst.counter\[14\] 0
C21843 hold163/a_326_118# _302_ 0
C21844 hold75/a_56_118# _695_/a_1489_191# 0
C21845 hold64/a_438_182# net64 0
C21846 tx_inst.bit_index\[1\] net183 0
C21847 _671_/a_1583_191# _650_/a_298_337# 0
C21848 _466_/a_22_110# _647_/a_1840_334# 0
C21849 _216_ net168 1.8132f
C21850 baud_inst.counter\[17\] _682_/a_741_93# 0
C21851 _689_/a_843_236# clknet_4_2_0_clk 0.03088f
C21852 _103_ _300_ 0.11548f
C21853 _029_ net105 0.00424f
C21854 VPWR _681_/a_550_127# 0
C21855 net89 VPWR 0.18856f
C21856 hold147/a_438_182# hold148/a_56_118# 0
C21857 _677_/a_1583_191# net137 0
C21858 _439_/a_252_412# net24 0
C21859 _040_ _120_ 0.00286f
C21860 net156 hold102/a_56_118# 0
C21861 _696_/a_550_127# net46 0
C21862 net36 _451_/a_257_140# 0.00161f
C21863 _424_/a_142_412# VPWR 0.00264f
C21864 _109_ _025_ 0.01788f
C21865 net74 rx_data[3] 0.00529f
C21866 _659_/a_843_236# clknet_4_1_0_clk 0.02183f
C21867 _219_ tx_inst.data_reg\[5\] 0.0013f
C21868 net42 _078_ 0.08931f
C21869 net49 _224_ 0.07037f
C21870 net39 _685_/a_1583_191# 0.00295f
C21871 _373_/a_170_412# net63 0
C21872 _205_ _667_/a_1489_191# 0
C21873 _691_/a_843_236# _105_ 0
C21874 hold165/a_56_118# net3 0
C21875 clknet_4_1_0_clk net43 0
C21876 _179_ net114 0
C21877 net39 _689_/a_1583_191# 0.00957f
C21878 VPWR _649_/a_612_127# 0.002f
C21879 _662_/a_324_432# _065_ 0
C21880 _690_/a_1583_191# _014_ 0
C21881 _656_/a_741_93# _656_/a_1489_191# -0
C21882 _656_/a_1583_191# _656_/a_2250_412# 0
C21883 net27 FILLER_6_189/a_40_246# 0.02016f
C21884 _697_/a_324_432# _696_/a_1840_334# 0
C21885 rx_inst.data_reg\[3\] _125_ 0.00124f
C21886 _180_ net140 0.01614f
C21887 baud_inst.counter\[12\] hold108/a_438_182# 0
C21888 net122 _374_/a_244_412# 0.00716f
C21889 net37 _374_/a_142_412# 0.00515f
C21890 hold129/a_56_118# _292_ 0.0117f
C21891 _663_/a_298_337# _075_ 0.02092f
C21892 _044_ _429_/a_244_412# 0
C21893 _643_/a_1840_334# net47 0.042f
C21894 _695_/a_38_114# _108_ 0.04132f
C21895 _114_ clknet_4_10_0_clk 0.02634f
C21896 _243_ _139_ 0.00116f
C21897 _652_/a_741_93# _063_ 0
C21898 _705_/a_132_114# net22 0
C21899 _127_ hold71/a_326_118# 0
C21900 _163_ _684_/a_550_127# 0
C21901 _231_ clknet_0_clk 0
C21902 _643_/a_38_114# net112 0.03722f
C21903 FILLER_21_175/a_32_246# _223_ 0.00134f
C21904 net92 hold95/a_438_182# 0.01009f
C21905 _285_ hold95/a_56_118# 0.03208f
C21906 _189_ _096_ 0
C21907 _180_ baud_inst.counter\[11\] 0
C21908 hold158/a_438_182# _015_ 0
C21909 _293_ _493_/a_139_160# 0
C21910 _391_/a_46_156# net170 0.00897f
C21911 FILLER_2_81/a_32_246# net181 0
C21912 net54 _380_/a_496_118# 0
C21913 _537_/a_192_429# _302_ 0
C21914 clknet_0_clk hold94/a_438_182# 0.00172f
C21915 _446_/a_248_122# net24 0.00272f
C21916 _230_ _154_ 0
C21917 _284_ hold154/a_326_118# 0
C21918 _556_/a_192_429# _699_/a_1840_334# 0
C21919 net58 _699_/a_324_432# 0
C21920 VPWR _310_ 0.24587f
C21921 net51 _667_/a_38_114# 0
C21922 _235_ _140_ 0.18475f
C21923 net146 _666_/a_2250_412# 0.01277f
C21924 hold151/a_326_118# _056_ 0.00555f
C21925 net115 _096_ 0.001f
C21926 _679_/a_324_432# _287_ 0.01059f
C21927 _008_ _675_/a_1840_334# 0
C21928 tx_inst.bit_index\[1\] _653_/a_741_93# 0.00278f
C21929 net173 hold184/a_438_182# 0.01421f
C21930 _287_ _683_/a_132_114# 0
C21931 hold117/a_438_182# _039_ 0.01469f
C21932 _195_ clkbuf_4_4_0_clk/a_27_118# 0.00311f
C21933 net85 net48 0.00608f
C21934 _345_/a_252_412# baud_inst.counter\[22\] 0.00297f
C21935 _345_/a_354_412# baud_inst.counter\[23\] 0.00128f
C21936 net30 hold71/a_438_182# 0.0013f
C21937 _662_/a_2250_412# net54 0.00435f
C21938 _699_/a_132_114# VPWR 0
C21939 hold141/a_326_118# _696_/a_324_432# 0
C21940 _093_ _183_ 0
C21941 net21 _275_ 0.06763f
C21942 _639_/a_298_337# net19 0.00191f
C21943 _680_/a_612_127# baud_inst.counter\[9\] 0
C21944 VPWR _651_/a_1785_429# 0
C21945 rx_data[6] net17 0.35438f
C21946 _674_/a_298_337# VPWR 0.01394f
C21947 _302_ _529_/a_45_160# 0.00603f
C21948 net44 _696_/a_1840_334# 0.00206f
C21949 _637_/a_1785_429# _264_ 0
C21950 tx_inst.data_reg\[4\] _388_/a_59_156# 0
C21951 VPWR _416_/a_350_122# 0
C21952 net2 _241_ 0
C21953 _672_/a_1583_191# net86 0
C21954 tx_inst.data_reg\[6\] FILLER_1_212/a_32_246# 0
C21955 _163_ _298_ 0
C21956 hold72/a_56_118# rx_inst.data_reg\[5\] 0.00117f
C21957 net45 hold134/a_56_118# 0.01335f
C21958 _680_/a_843_236# baud_inst.counter\[9\] 0.00204f
C21959 _663_/a_38_114# _166_ 0.00425f
C21960 _694_/a_843_236# FILLER_25_36/a_32_246# 0
C21961 hold175/a_438_182# _262_ 0.00324f
C21962 _673_/a_1489_191# _085_ 0
C21963 _673_/a_2002_114# net38 0
C21964 _655_/a_741_93# net40 0.00819f
C21965 net39 hold108/a_438_182# 0.00345f
C21966 _686_/a_1583_191# net90 0
C21967 _240_ FILLER_16_203/a_32_246# 0
C21968 _658_/a_324_432# _069_ 0.01597f
C21969 _191_ _667_/a_324_432# 0
C21970 _695_/a_324_432# net76 0.00331f
C21971 _701_/a_1583_191# net46 0.00119f
C21972 net42 _280_ 0
C21973 _542_/a_257_140# _309_ 0.00307f
C21974 clknet_0_clk _264_ 0.60744f
C21975 tx_inst.bit_index\[2\] tx_inst.data_reg\[5\] 0
C21976 _286_ _037_ 0.00544f
C21977 _442_/a_146_122# _255_ 0
C21978 _230_ fanout36/a_40_152# 0.0061f
C21979 _091_ _655_/a_324_432# 0
C21980 VPWR hold92/a_438_182# 0.0012f
C21981 _044_ rx_data[1] 0
C21982 net168 _666_/a_843_236# 0.00177f
C21983 hold104/a_56_118# _302_ 0.01246f
C21984 hold52/a_438_182# fanout36/a_40_152# 0
C21985 net49 _409_/a_269_412# 0
C21986 _702_/a_324_432# _700_/a_1489_191# 0
C21987 _702_/a_612_127# _700_/a_843_236# 0
C21988 net104 _690_/a_324_432# 0
C21989 hold145/a_326_118# VPWR 0.00813f
C21990 _696_/a_1583_191# clknet_0_clk 0.00387f
C21991 net35 _236_ 0.72984f
C21992 _181_ _490_/a_139_160# 0.00186f
C21993 _163_ _188_ 0.0419f
C21994 hold130/a_56_118# hold177/a_56_118# 0.0197f
C21995 _659_/a_1583_191# net41 0
C21996 net174 FILLER_4_183/a_40_246# 0
C21997 _412_/a_120_432# net43 0
C21998 _285_ net40 0
C21999 _632_/a_741_93# _273_ 0
C22000 _632_/a_843_236# net64 0
C22001 net128 _013_ 0.09309f
C22002 hold157/a_326_118# _101_ 0
C22003 hold176/a_56_118# _453_/a_170_412# 0
C22004 net44 _305_ 0
C22005 baud_inst.counter\[28\] _555_/a_177_436# 0
C22006 _346_/a_252_412# net67 0
C22007 _411_/a_115_308# _241_ 0
C22008 _431_/a_81_118# _248_ 0
C22009 net163 _690_/a_741_93# 0
C22010 _177_ _699_/a_1489_191# 0.00104f
C22011 _699_/a_1583_191# net59 0
C22012 _547_/a_175_118# clknet_0_clk 0
C22013 _283_ _091_ 0
C22014 tx_inst.bit_index\[1\] _652_/a_1583_191# 0.00107f
C22015 net55 _658_/a_843_236# 0
C22016 tx_inst.data_reg\[6\] _341_/a_382_118# 0.03513f
C22017 _678_/a_298_337# hold93/a_56_118# 0
C22018 _676_/a_1785_429# baud_inst.counter\[5\] 0
C22019 net128 baud_inst.counter\[14\] 0.00214f
C22020 hold183/a_438_182# _216_ 0.03776f
C22021 _696_/a_324_432# baud_inst.counter\[14\] 0
C22022 _696_/a_741_93# baud_inst.counter\[15\] 0.00137f
C22023 _643_/a_1583_191# _060_ 0
C22024 _659_/a_681_505# _068_ 0
C22025 _659_/a_324_432# tx_inst.data_reg\[3\] 0
C22026 hold173/a_326_118# net27 0
C22027 net27 net43 0.01011f
C22028 net100 _110_ 0
C22029 _698_/a_1840_334# VPWR 0.00254f
C22030 _654_/a_298_337# _071_ 0
C22031 _392_/a_382_118# _664_/a_324_432# 0
C22032 clknet_4_1_0_clk net152 0
C22033 baud_inst.counter\[17\] _522_/a_380_412# 0.00117f
C22034 _634_/a_298_337# hold83/a_326_118# 0.00282f
C22035 _147_ net43 0.00607f
C22036 VPWR _439_/a_150_412# 0
C22037 _178_ _699_/a_612_127# 0.00977f
C22038 hold158/a_438_182# net39 0
C22039 net71 _648_/a_1583_191# 0.00245f
C22040 _256_ _252_ 0.01308f
C22041 net126 _649_/a_1840_334# 0.00152f
C22042 _154_ _649_/a_1583_191# 0.01751f
C22043 hold66/a_56_118# net64 0.04358f
C22044 baud_inst.counter\[3\] _674_/a_1489_191# 0
C22045 net179 _074_ 0.01254f
C22046 net94 net79 0.00253f
C22047 _443_/a_150_412# _224_ 0.00212f
C22048 hold75/a_326_118# _108_ 0
C22049 output21/a_40_152# _665_/a_324_432# 0
C22050 _098_ _099_ 0
C22051 hold163/a_56_118# _692_/a_1583_191# 0.00364f
C22052 baud_inst.counter\[20\] _692_/a_324_432# 0.00557f
C22053 baud_inst.counter\[14\] _014_ 0.00186f
C22054 net180 _161_ 0
C22055 _376_/a_76_160# _275_ 0
C22056 clkbuf_4_12_0_clk/a_27_118# _058_ 0.0016f
C22057 _644_/a_298_337# net47 0
C22058 _192_ _664_/a_298_337# 0.00214f
C22059 net27 _664_/a_324_432# 0
C22060 _530_/a_257_140# _104_ 0
C22061 _661_/a_2250_412# input5/a_40_152# 0
C22062 hold151/a_438_182# fanout47/a_40_152# 0.00238f
C22063 clknet_4_12_0_clk _635_/a_38_114# 0
C22064 hold136/a_438_182# net86 0
C22065 net42 _191_ 0.03828f
C22066 _656_/a_843_236# FILLER_0_161/a_40_246# 0
C22067 _378_/a_59_156# _066_ 0
C22068 FILLER_12_166/a_40_246# hold62/a_438_182# 0
C22069 _704_/a_612_127# rx_inst.state\[1\] 0
C22070 hold80/a_56_118# net80 0.00635f
C22071 _699_/a_324_432# _027_ 0.04477f
C22072 _534_/a_46_156# _693_/a_38_114# 0
C22073 _658_/a_843_236# _067_ 0
C22074 _658_/a_324_432# clknet_4_4_0_clk 0.01695f
C22075 FILLER_8_19/a_40_246# _681_/a_612_127# 0
C22076 FILLER_7_82/a_32_246# _352_/a_46_156# 0.0073f
C22077 net30 _470_/a_120_432# 0.00205f
C22078 _203_ VPWR 0.1095f
C22079 _384_/a_285_118# net171 0
C22080 _384_/a_285_412# _148_ 0
C22081 _650_/a_2002_114# net19 0
C22082 _704_/a_298_337# hold50/a_326_118# 0
C22083 _189_ _190_ 0.52124f
C22084 _103_ net160 0
C22085 net47 hold83/a_326_118# 0.00493f
C22086 _676_/a_741_93# clknet_0_clk 0.00338f
C22087 _341_/a_1377_160# VPWR 0.00766f
C22088 _485_/a_22_110# _191_ 0
C22089 _046_ _125_ 0.001f
C22090 _107_ clknet_4_10_0_clk 0.04655f
C22091 _446_/a_146_122# VPWR 0.00249f
C22092 rx_data[6] _128_ 0
C22093 net60 _033_ 0.15031f
C22094 _679_/a_324_432# clkbuf_4_0_0_clk/a_27_118# 0.00345f
C22095 FILLER_12_117/a_40_246# _670_/a_843_236# 0
C22096 _515_/a_76_160# net29 0
C22097 net32 _671_/a_298_337# 0
C22098 _411_/a_358_436# net49 0
C22099 net111 clkbuf_4_15_0_clk/a_27_118# 0
C22100 _672_/a_298_337# net38 0
C22101 clknet_0_clk _683_/a_741_93# 0.0039f
C22102 _698_/a_324_432# FILLER_20_106/a_32_246# 0
C22103 _167_ _416_/a_350_122# 0
C22104 _095_ fanout38/a_40_152# 0
C22105 _083_ baud_inst.counter\[4\] 0.00274f
C22106 _095_ _689_/a_324_432# 0
C22107 _548_/a_76_160# _542_/a_155_412# 0
C22108 fanout28/a_40_152# net51 0
C22109 net51 _668_/a_1785_429# 0.00149f
C22110 net44 _020_ 0.00824f
C22111 _449_/a_229_118# net25 0
C22112 net47 _634_/a_843_236# 0.00128f
C22113 _644_/a_38_114# net49 0.03486f
C22114 net55 _656_/a_132_114# 0
C22115 _537_/a_341_118# _692_/a_741_93# 0
C22116 _706_/a_298_337# net43 0.02967f
C22117 _671_/a_38_114# hold62/a_56_118# 0
C22118 _128_ rx_inst.data_reg\[5\] 0.00299f
C22119 _643_/a_298_337# _257_ 0
C22120 net55 _705_/a_612_127# 0
C22121 hold150/a_326_118# _044_ 0.00101f
C22122 hold122/a_438_182# _169_ 0.00137f
C22123 _538_/a_379_118# VPWR 0
C22124 _232_ _649_/a_843_236# 0
C22125 _160_ _649_/a_1583_191# 0
C22126 output22/a_40_152# _705_/a_843_236# 0
C22127 _689_/a_612_127# clknet_4_2_0_clk 0
C22128 hold129/a_438_182# _190_ 0.04262f
C22129 net49 FILLER_23_158/a_40_246# 0.00107f
C22130 _360_/a_308_118# tx_inst.bit_index\[1\] 0
C22131 _360_/a_886_118# net184 0.01112f
C22132 _313_ _701_/a_1583_191# 0.00145f
C22133 hold88/a_326_118# clknet_4_8_0_clk 0
C22134 hold107/a_326_118# VPWR 0.00234f
C22135 _126_ _270_ 0.01767f
C22136 _251_ net24 0.01175f
C22137 _294_ clknet_0_clk 0.06399f
C22138 FILLER_17_131/a_32_246# _669_/a_2250_412# 0
C22139 _645_/a_298_337# net49 0.0384f
C22140 hold65/a_438_182# rx_data[6] 0
C22141 _241_ _169_ 0
C22142 hold123/a_438_182# _670_/a_741_93# 0
C22143 hold123/a_326_118# _670_/a_843_236# 0
C22144 FILLER_24_218/a_40_246# VPWR 0.13989f
C22145 _659_/a_612_127# clknet_4_1_0_clk 0.00508f
C22146 net156 _518_/a_45_160# 0
C22147 _469_/a_22_110# FILLER_28_204/a_32_246# 0
C22148 net49 FILLER_29_165/a_40_246# 0
C22149 _254_ _236_ 0.05362f
C22150 net20 _705_/a_2250_412# 0
C22151 FILLER_0_115/a_40_246# _210_ 0.02336f
C22152 _191_ _670_/a_298_337# 0
C22153 _643_/a_1583_191# _649_/a_741_93# 0
C22154 _643_/a_1840_334# _649_/a_324_432# 0
C22155 _517_/a_380_412# _012_ 0
C22156 _704_/a_1583_191# FILLER_13_228/a_40_246# 0
C22157 _517_/a_474_130# _294_ 0.00315f
C22158 _124_ FILLER_27_210/a_40_246# 0.01861f
C22159 net39 _689_/a_2002_114# 0
C22160 _307_ _695_/a_324_432# 0
C22161 output13/a_40_152# net82 0
C22162 VPWR net127 0.13725f
C22163 VPWR _632_/a_298_337# 0.00297f
C22164 clknet_4_10_0_clk _165_ 0
C22165 _073_ _654_/a_1840_334# 0
C22166 _656_/a_741_93# tx_inst.data_reg\[2\] 0
C22167 _656_/a_843_236# clknet_4_4_0_clk 0.00656f
C22168 _461_/a_22_110# hold71/a_326_118# 0
C22169 rx_inst.state\[2\] _407_/a_248_122# 0
C22170 _182_ _683_/a_741_93# 0
C22171 _663_/a_681_505# clknet_4_7_0_clk 0
C22172 _663_/a_843_236# tx_inst.state\[1\] 0
C22173 hold109/a_326_118# VPWR 0.00652f
C22174 _185_ clknet_0_clk 0
C22175 hold130/a_56_118# baud_inst.counter\[12\] 0.0021f
C22176 output19/a_40_152# _061_ 0
C22177 _116_ _551_/a_76_160# 0
C22178 net179 _201_ 0.03487f
C22179 _705_/a_1489_191# net22 0.01099f
C22180 hold58/a_438_182# _702_/a_1583_191# 0.00138f
C22181 clknet_4_0_0_clk clknet_0_clk 0
C22182 hold127/a_438_182# _154_ 0.0125f
C22183 _214_ _208_ 0
C22184 _186_ FILLER_9_70/a_40_246# 0.0146f
C22185 VPWR _528_/a_81_118# 0.0209f
C22186 _305_ _302_ 0.08446f
C22187 FILLER_5_59/a_40_246# net86 0.00337f
C22188 hold110/a_326_118# _287_ 0
C22189 rx_inst.bit_index\[1\] _449_/a_27_156# 0
C22190 net45 _698_/a_298_337# 0.02534f
C22191 tx_inst.data_reg\[4\] net34 0
C22192 _198_ _119_ 0.04422f
C22193 _651_/a_843_236# _221_ 0
C22194 baud_inst.counter\[28\] _702_/a_298_337# 0.01265f
C22195 _414_/a_279_412# net31 0
C22196 _032_ _699_/a_1583_191# 0
C22197 _316_ _699_/a_1840_334# 0.001f
C22198 _672_/a_612_127# FILLER_2_46/a_40_246# 0
C22199 net50 _704_/a_324_432# 0.00749f
C22200 net51 _667_/a_1840_334# 0
C22201 net71 hold70/a_326_118# 0.00123f
C22202 rx_inst.data_reg\[1\] net30 0
C22203 _268_ hold70/a_56_118# 0
C22204 rx_inst.state\[3\] hold167/a_326_118# 0
C22205 hold86/a_56_118# _673_/a_1840_334# 0
C22206 baud_inst.counter\[1\] _673_/a_741_93# 0
C22207 hold86/a_326_118# _673_/a_1583_191# 0
C22208 hold124/a_438_182# VPWR 0.00508f
C22209 _707_/a_843_236# FILLER_13_228/a_40_246# 0
C22210 net18 _634_/a_324_432# 0
C22211 _635_/a_298_337# net64 0.00926f
C22212 hold169/a_326_118# hold169/a_438_182# -0
C22213 _669_/a_1583_191# _669_/a_2250_412# 0
C22214 tx_inst.bit_index\[1\] _653_/a_1785_429# 0.00187f
C22215 hold161/a_56_118# net156 0.00121f
C22216 _639_/a_741_93# hold81/a_438_182# 0
C22217 _639_/a_843_236# hold81/a_326_118# 0
C22218 _178_ baud_inst.counter\[23\] 0.01515f
C22219 _290_ _683_/a_132_114# 0
C22220 _294_ _182_ 0
C22221 net163 _692_/a_38_114# 0
C22222 _694_/a_741_93# VPWR 0.02381f
C22223 _639_/a_324_432# _707_/a_843_236# 0
C22224 _639_/a_741_93# _707_/a_741_93# 0.00133f
C22225 VPWR _271_ 0.1072f
C22226 _699_/a_1489_191# VPWR 0.00125f
C22227 net91 net29 0.15727f
C22228 _639_/a_1583_191# net19 0.0075f
C22229 baud_inst.counter\[19\] _100_ 0
C22230 _382_/a_59_156# net137 0.00193f
C22231 rx_inst.data_reg\[0\] _474_/a_120_432# 0
C22232 net55 _381_/a_46_156# 0.01668f
C22233 hold98/a_326_118# hold117/a_56_118# 0.00191f
C22234 _102_ _689_/a_324_432# 0.03627f
C22235 _206_ input9/a_40_152# 0.00987f
C22236 _674_/a_1583_191# VPWR 0.01837f
C22237 _048_ _264_ 0.00796f
C22238 FILLER_24_218/a_40_246# _127_ 0
C22239 baud_inst.counter\[31\] _165_ 0.00182f
C22240 _662_/a_324_432# VPWR 0.00888f
C22241 _269_ clknet_0_clk 0
C22242 hold96/a_326_118# net135 0.01002f
C22243 hold96/a_56_118# _287_ 0.03587f
C22244 net3 _144_ 0
C22245 _663_/a_1840_334# _166_ 0.00151f
C22246 _636_/a_741_93# FILLER_19_228/a_40_246# 0
C22247 FILLER_21_175/a_32_246# _447_/a_81_118# 0.0099f
C22248 _655_/a_1785_429# net40 0
C22249 _686_/a_2002_114# net90 0
C22250 _246_ FILLER_18_169/a_40_246# 0
C22251 hold53/a_438_182# _640_/a_843_236# 0
C22252 net53 _640_/a_298_337# 0.00757f
C22253 _185_ _182_ 0.04784f
C22254 _281_ _162_ 0.00287f
C22255 hold130/a_56_118# net39 0
C22256 net132 _252_ 0
C22257 _673_/a_298_337# VPWR 0.00652f
C22258 _195_ VPWR 0.07313f
C22259 _677_/a_681_505# clknet_0_clk 0
C22260 _087_ hold61/a_438_182# 0
C22261 clknet_4_5_0_clk _275_ 0.11132f
C22262 _270_ _647_/a_1489_191# 0
C22263 clknet_4_0_0_clk _182_ 0.04779f
C22264 _220_ _274_ 0
C22265 _097_ hold178/a_326_118# 0.00802f
C22266 net26 _205_ 0.17222f
C22267 hold118/a_438_182# _668_/a_1583_191# 0
C22268 hold125/a_438_182# hold127/a_438_182# 0.00124f
C22269 _639_/a_1583_191# hold51/a_326_118# 0
C22270 _283_ _281_ 0
C22271 net104 _164_ 0.01519f
C22272 _692_/a_741_93# _104_ 0.00332f
C22273 FILLER_1_90/a_32_246# net10 0
C22274 hold55/a_56_118# _077_ 0
C22275 _098_ _685_/a_843_236# 0.00355f
C22276 _115_ _700_/a_681_505# 0
C22277 net68 _700_/a_843_236# 0.00275f
C22278 _152_ tx_inst.state\[4\] 0.00205f
C22279 _688_/a_1489_191# net40 0.01563f
C22280 clknet_4_3_0_clk baud_inst.counter\[7\] 0.07381f
C22281 clkbuf_4_5_0_clk/a_27_118# _200_ 0
C22282 hold146/a_438_182# net50 0.05425f
C22283 _355_/a_354_412# _301_ 0
C22284 _696_/a_2002_114# clknet_0_clk 0
C22285 hold108/a_438_182# _683_/a_843_236# 0
C22286 baud_inst.counter\[13\] _684_/a_741_93# 0.01416f
C22287 FILLER_24_218/a_40_246# _266_ 0.00167f
C22288 net48 _244_ 0.00104f
C22289 output23/a_40_152# tx_done 0.00161f
C22290 _231_ net43 0
C22291 net12 VPWR 0.29387f
C22292 hold171/a_56_118# _656_/a_38_114# 0.02058f
C22293 hold96/a_438_182# baud_inst.counter\[8\] 0
C22294 _678_/a_38_114# _036_ 0.00328f
C22295 FILLER_13_100/a_40_246# _685_/a_1583_191# 0
C22296 hold87/a_438_182# _180_ 0.00126f
C22297 _020_ _302_ 0.84237f
C22298 hold124/a_438_182# _127_ 0
C22299 hold176/a_438_182# _131_ 0.00132f
C22300 baud_inst.counter\[30\] net67 0.18338f
C22301 _632_/a_38_114# net30 0.01663f
C22302 _632_/a_298_337# _266_ 0.00231f
C22303 net113 clknet_0_clk 0.0396f
C22304 _233_ _004_ 0
C22305 baud_inst.counter\[20\] hold120/a_438_182# 0.01054f
C22306 _424_/a_550_140# _154_ 0
C22307 tx_inst.data_reg\[6\] _341_/a_810_118# 0.00176f
C22308 rx_inst.state\[3\] _676_/a_1840_334# 0
C22309 _523_/a_155_412# _298_ 0.00178f
C22310 _229_ fanout25/a_40_152# 0.01131f
C22311 hold142/a_438_182# FILLER_20_95/a_40_246# 0.00941f
C22312 _659_/a_550_127# _068_ 0
C22313 _659_/a_2250_412# tx_inst.data_reg\[3\] 0.06898f
C22314 tx_inst.data_reg\[5\] _657_/a_2250_412# 0
C22315 _083_ hold123/a_56_118# 0
C22316 hold102/a_326_118# net102 0
C22317 hold102/a_438_182# _017_ 0.04431f
C22318 _228_ clknet_0_clk 0.00393f
C22319 _654_/a_1840_334# net41 0
C22320 _000_ _668_/a_298_337# 0
C22321 _178_ net114 0.0214f
C22322 hold86/a_56_118# _086_ 0
C22323 output23/a_40_152# net55 0
C22324 hold166/a_56_118# _002_ 0.00524f
C22325 _154_ _649_/a_2002_114# 0
C22326 net66 _273_ 0
C22327 baud_inst.counter\[5\] _096_ 0
C22328 rx_inst.state\[2\] FILLER_18_158/a_40_246# 0
C22329 _395_/a_146_122# _200_ 0
C22330 _395_/a_248_122# net168 0.00387f
C22331 _688_/a_324_432# net160 0.00558f
C22332 _536_/a_192_429# _304_ 0.02344f
C22333 net35 net2 0.18352f
C22334 _315_ hold105/a_56_118# 0.00131f
C22335 _536_/a_435_412# net46 0
C22336 net4 VPWR 0.08051f
C22337 _703_/a_38_114# _702_/a_741_93# 0
C22338 FILLER_15_89/a_32_246# VPWR 0.07894f
C22339 baud_inst.counter\[20\] _692_/a_2250_412# 0.02706f
C22340 hold124/a_438_182# _266_ 0.00374f
C22341 _360_/a_886_118# _341_/a_71_118# 0
C22342 _360_/a_71_118# _341_/a_886_118# 0
C22343 _644_/a_1583_191# net47 0
C22344 _246_ VPWR 0.05462f
C22345 net27 _664_/a_2250_412# 0.00105f
C22346 _204_ _667_/a_1785_429# 0
C22347 _645_/a_612_127# _232_ 0
C22348 _311_ net46 0
C22349 _194_ _172_ 0
C22350 _099_ _669_/a_324_432# 0.00217f
C22351 net35 clkload3/Y 0
C22352 rx_data[0] _049_ 0
C22353 _662_/a_38_114# net179 0.01306f
C22354 _508_/a_209_168# net40 0
C22355 _699_/a_2250_412# _027_ 0
C22356 _021_ _693_/a_324_432# 0.08018f
C22357 _377_/a_46_156# net55 0.00974f
C22358 _680_/a_38_114# _030_ 0
C22359 _062_ _141_ 0.00649f
C22360 _126_ _265_ 0
C22361 net48 hold139/a_56_118# 0.00887f
C22362 _658_/a_2250_412# clknet_4_4_0_clk 0.00724f
C22363 FILLER_8_19/a_40_246# net117 0.0049f
C22364 net30 _124_ 0.00171f
C22365 _266_ _271_ 0.06016f
C22366 net51 _650_/a_324_432# 0
C22367 net171 _148_ 0.02476f
C22368 net26 _671_/a_1583_191# 0.04926f
C22369 _656_/a_1583_191# FILLER_0_163/a_32_246# 0
C22370 net177 _188_ 0.35653f
C22371 _676_/a_1785_429# clknet_0_clk 0
C22372 clknet_4_6_0_clk _000_ 0.03736f
C22373 rx_inst.state\[2\] hold166/a_326_118# 0
C22374 _467_/a_120_432# net30 0.00194f
C22375 _258_ VPWR 0.06712f
C22376 net106 clknet_4_10_0_clk 0
C22377 hold153/a_326_118# net29 0.00167f
C22378 hold106/a_326_118# _701_/a_324_432# 0.00102f
C22379 _230_ net49 0.0823f
C22380 rx_data[0] _638_/a_1583_191# 0.00202f
C22381 _133_ _257_ 0.00981f
C22382 baud_inst.counter\[8\] baud_inst.counter\[10\] 0.08362f
C22383 net101 _688_/a_550_127# 0
C22384 net12 _127_ 0
C22385 _055_ _236_ 0
C22386 hold52/a_438_182# net49 0.0011f
C22387 _672_/a_1583_191# net38 0
C22388 net43 hold50/a_326_118# 0.00338f
C22389 clknet_0_clk _683_/a_1785_429# 0
C22390 clknet_4_5_0_clk _071_ 0.00445f
C22391 _095_ FILLER_11_32/a_32_246# 0
C22392 FILLER_26_88/a_40_246# _703_/a_741_93# 0.00392f
C22393 _095_ _689_/a_2250_412# 0
C22394 net2 _460_/a_120_432# 0.00177f
C22395 _312_ _542_/a_155_412# 0
C22396 _232_ _424_/a_142_412# 0.00111f
C22397 _548_/a_272_160# baud_inst.counter\[24\] 0
C22398 _699_/a_681_505# net45 0
C22399 _002_ fanout26/a_40_152# 0.02295f
C22400 net48 clknet_4_14_0_clk 0.08401f
C22401 _153_ clknet_0_clk 0
C22402 _676_/a_741_93# FILLER_10_110/a_40_246# 0.00125f
C22403 rx_inst.data_reg\[7\] hold51/a_438_182# 0
C22404 net75 _692_/a_1583_191# 0
C22405 net47 _634_/a_612_127# 0.00157f
C22406 _644_/a_1840_334# net49 0
C22407 _706_/a_132_114# _120_ 0
C22408 _706_/a_1583_191# net43 0
C22409 _671_/a_741_93# rx_inst.state\[4\] 0.02054f
C22410 _170_ hold112/a_438_182# 0.01151f
C22411 clk _206_ 0.58361f
C22412 hold169/a_326_118# _166_ 0.05509f
C22413 _306_ VPWR 0.1385f
C22414 _506_/a_257_140# _287_ 0.00509f
C22415 net158 clknet_4_2_0_clk 0.00398f
C22416 tx_inst.data_reg\[0\] net170 0
C22417 _313_ _701_/a_2002_114# 0
C22418 net182 hold153/a_326_118# 0
C22419 clknet_4_1_0_clk _655_/a_681_505# 0
C22420 _679_/a_38_114# net97 0
C22421 _081_ FILLER_12_208/a_32_246# 0
C22422 hold90/a_438_182# hold91/a_438_182# 0.00216f
C22423 net51 FILLER_14_164/a_32_246# 0.01803f
C22424 net48 _639_/a_843_236# 0
C22425 _696_/a_843_236# clknet_4_8_0_clk 0.00986f
C22426 _158_ _633_/a_324_432# 0.02491f
C22427 hold120/a_56_118# _701_/a_324_432# 0
C22428 _305_ hold148/a_326_118# 0
C22429 net75 hold148/a_438_182# 0
C22430 hold68/a_438_182# _031_ 0.00395f
C22431 _023_ hold148/a_56_118# 0.00579f
C22432 tx_inst.data_reg\[6\] _380_/a_382_118# 0
C22433 net108 _683_/a_132_114# 0
C22434 _291_ _683_/a_324_432# 0
C22435 FILLER_15_116/a_40_246# VPWR 0.16177f
C22436 _679_/a_324_432# net181 0
C22437 _679_/a_38_114# net86 0.00252f
C22438 hold174/a_326_118# hold169/a_326_118# 0
C22439 hold174/a_438_182# hold169/a_56_118# 0
C22440 _052_ _698_/a_38_114# 0
C22441 _010_ _287_ 0
C22442 _661_/a_298_337# net155 0.00541f
C22443 _191_ _670_/a_1583_191# 0.02647f
C22444 hold139/a_56_118# _250_ 0.0146f
C22445 hold139/a_326_118# _157_ 0
C22446 _643_/a_1489_191# _649_/a_843_236# 0
C22447 _643_/a_843_236# _649_/a_1489_191# 0
C22448 baud_inst.counter\[28\] _029_ 0.25717f
C22449 net26 _376_/a_76_160# 0
C22450 hold157/a_438_182# VPWR 0.00715f
C22451 _307_ _695_/a_2250_412# 0
C22452 VPWR _632_/a_1583_191# 0.00846f
C22453 _679_/a_132_114# _182_ 0
C22454 hold54/a_56_118# _665_/a_1583_191# 0.00364f
C22455 _314_ net68 0.00411f
C22456 _656_/a_612_127# clknet_4_4_0_clk 0.00178f
C22457 _110_ _696_/a_1583_191# 0.00698f
C22458 net39 _688_/a_298_337# 0
C22459 _315_ _701_/a_1840_334# 0.00241f
C22460 rx_data[7] rx_inst.data_reg\[7\] 0.00208f
C22461 hold168/a_56_118# _370_/a_154_118# 0
C22462 baud_inst.counter\[12\] _358_/a_411_436# 0
C22463 _675_/a_298_337# clknet_4_0_0_clk 0.0016f
C22464 _041_ _651_/a_324_432# 0.00221f
C22465 net36 _260_ 0
C22466 FILLER_6_191/a_32_246# VPWR 0.06863f
C22467 _444_/a_244_412# VPWR 0.00127f
C22468 _554_/a_248_122# _180_ 0.00145f
C22469 net45 _698_/a_1583_191# 0.00275f
C22470 _111_ _698_/a_132_114# 0
C22471 _651_/a_612_127# _221_ 0
C22472 _696_/a_741_93# _686_/a_2250_412# 0
C22473 _696_/a_843_236# _686_/a_1840_334# 0
C22474 _246_ _167_ 0.00523f
C22475 hold140/a_56_118# _697_/a_1489_191# 0
C22476 hold136/a_438_182# net38 0.00632f
C22477 net2 _254_ 0.02074f
C22478 hold146/a_438_182# _705_/a_38_114# 0
C22479 net87 _189_ 0.00128f
C22480 VPWR _380_/a_496_118# 0
C22481 FILLER_16_154/a_32_246# _228_ 0.00402f
C22482 VPWR _648_/a_843_236# 0.00787f
C22483 net18 _634_/a_2250_412# 0.01997f
C22484 _532_/a_257_140# _302_ 0
C22485 _635_/a_1583_191# net64 0.00472f
C22486 _273_ hold70/a_326_118# 0
C22487 _693_/a_298_337# clknet_4_10_0_clk 0.00387f
C22488 hold152/a_326_118# net39 0
C22489 _691_/a_2250_412# baud_inst.counter\[21\] 0
C22490 _246_ _225_ 0.00126f
C22491 net82 net30 0.00103f
C22492 FILLER_1_90/a_32_246# input8/a_40_152# 0
C22493 _218_ _400_/a_192_429# 0
C22494 _314_ _701_/a_324_432# 0.00741f
C22495 _313_ _311_ 0.0314f
C22496 hold79/a_438_182# VPWR 0.00374f
C22497 net163 _692_/a_1840_334# 0
C22498 net136 hold117/a_438_182# 0
C22499 _639_/a_2002_114# net19 0.0012f
C22500 net13 _123_ 0.06952f
C22501 _173_ _360_/a_1377_160# 0
C22502 net157 _298_ 0.00129f
C22503 baud_inst.counter\[24\] _099_ 0
C22504 rx_inst.data_reg\[0\] _122_ 1.02295f
C22505 _158_ FILLER_26_151/a_32_246# 0
C22506 tx_inst.data_reg\[7\] net5 0.00527f
C22507 net98 hold117/a_438_182# 0
C22508 hold57/a_56_118# _220_ 0.00181f
C22509 net84 VPWR 0.07458f
C22510 _379_/a_46_156# net54 0.00734f
C22511 _674_/a_2002_114# VPWR 0
C22512 net33 tx_start 0.10524f
C22513 _121_ hold80/a_56_118# 0.00345f
C22514 hold105/a_438_182# hold106/a_56_118# 0.00113f
C22515 hold144/a_56_118# net25 0
C22516 hold76/a_438_182# hold120/a_326_118# 0
C22517 hold76/a_326_118# hold120/a_438_182# 0
C22518 _662_/a_2250_412# VPWR 0.00834f
C22519 net20 net80 0.00882f
C22520 output19/a_40_152# _156_ 0
C22521 _245_ _256_ 0
C22522 _638_/a_741_93# _632_/a_741_93# 0.00803f
C22523 FILLER_20_177/a_32_246# clknet_0_clk 0
C22524 clknet_4_11_0_clk _702_/a_741_93# 0.03934f
C22525 tx_inst.bit_index\[2\] hold57/a_438_182# 0
C22526 net50 _707_/a_132_114# 0
C22527 _642_/a_2250_412# hold175/a_56_118# 0
C22528 baud_inst.counter\[8\] net96 0
C22529 _234_ fanout31/a_40_152# 0
C22530 hold53/a_56_118# _640_/a_1489_191# 0
C22531 baud_inst.counter\[20\] hold164/a_438_182# 0
C22532 _645_/a_1583_191# _644_/a_324_432# 0
C22533 _673_/a_1583_191# VPWR 0.01398f
C22534 _677_/a_550_127# clknet_0_clk 0
C22535 _537_/a_341_118# _021_ 0
C22536 net121 net49 0.4791f
C22537 _165_ _308_ 0
C22538 _230_ _443_/a_150_412# 0
C22539 _046_ net16 0.00356f
C22540 _057_ _223_ 0.00173f
C22541 hold170/a_438_182# net3 0
C22542 VPWR _667_/a_741_93# 0.01324f
C22543 _639_/a_1489_191# hold51/a_438_182# 0
C22544 _636_/a_1840_334# rx_inst.data_reg\[7\] 0
C22545 net31 _158_ 0
C22546 FILLER_7_82/a_32_246# _679_/a_1583_191# 0
C22547 _678_/a_1489_191# VPWR 0
C22548 VPWR hold95/a_56_118# 0.00228f
C22549 _098_ _685_/a_612_127# 0.01838f
C22550 hold119/a_56_118# _000_ 0.00353f
C22551 net48 net119 0
C22552 _691_/a_843_236# net103 0
C22553 _115_ _700_/a_550_127# 0
C22554 _699_/a_324_432# net49 0
C22555 net50 net21 0
C22556 _357_/a_354_412# clknet_0_clk 0
C22557 FILLER_28_204/a_32_246# _648_/a_1583_191# 0
C22558 hold66/a_56_118# _638_/a_324_432# 0
C22559 _187_ _684_/a_612_127# 0
C22560 _081_ rx_inst.data_reg\[7\] 0
C22561 _206_ _384_/a_496_118# 0.00227f
C22562 _675_/a_1583_191# FILLER_0_40/a_40_246# 0
C22563 clknet_0_clk _434_/a_150_412# 0
C22564 clkbuf_4_15_0_clk/a_27_118# clknet_4_15_0_clk 0.03079f
C22565 tx_inst.data_reg\[4\] _656_/a_741_93# 0.00293f
C22566 _642_/a_324_432# hold176/a_326_118# 0
C22567 _642_/a_741_93# hold176/a_56_118# 0.00212f
C22568 _517_/a_209_168# _180_ 0.00675f
C22569 hold119/a_56_118# _647_/a_38_114# 0
C22570 _645_/a_1840_334# FILLER_29_165/a_40_246# 0
C22571 _657_/a_741_93# tx_inst.data_reg\[1\] 0.01002f
C22572 _687_/a_132_114# _296_ 0
C22573 _632_/a_1840_334# net30 0
C22574 FILLER_7_40/a_32_246# net109 0
C22575 net163 _103_ 0.00798f
C22576 _173_ _343_/a_155_412# 0.00446f
C22577 _671_/a_1489_191# clkbuf_4_6_0_clk/a_27_118# 0
C22578 _636_/a_550_127# _264_ 0
C22579 tx_inst.data_reg\[6\] tx_inst.bit_index\[2\] 0.00408f
C22580 _057_ _240_ 0.00661f
C22581 net94 hold94/a_56_118# 0
C22582 hold128/a_326_118# baud_inst.counter\[13\] 0.02094f
C22583 net172 _664_/a_38_114# 0
C22584 net168 _664_/a_298_337# 0.01687f
C22585 _431_/a_379_118# net35 0
C22586 _114_ VPWR 0.13237f
C22587 _680_/a_741_93# _288_ 0
C22588 _149_ _209_ 0.02987f
C22589 _680_/a_38_114# _039_ 0
C22590 rx_data[3] _270_ 0
C22591 _275_ _199_ 0.69202f
C22592 _538_/a_81_118# hold103/a_326_118# 0
C22593 _268_ rx_inst.data_reg\[5\] 0
C22594 clknet_0_clk baud_inst.counter\[29\] 0
C22595 net27 _476_/a_146_122# 0.00494f
C22596 hold149/a_326_118# _693_/a_38_114# 0
C22597 hold149/a_56_118# _693_/a_324_432# 0
C22598 _477_/a_22_110# net169 0.00633f
C22599 _688_/a_1840_334# _296_ 0
C22600 _022_ net147 0.13433f
C22601 output22/a_40_152# output23/a_40_152# 0.0015f
C22602 _022_ net46 0.004f
C22603 FILLER_5_59/a_40_246# net38 0
C22604 hold130/a_56_118# _012_ 0.01045f
C22605 hold130/a_326_118# _294_ 0.00847f
C22606 _448_/a_550_140# _258_ 0
C22607 _636_/a_843_236# _156_ 0.0028f
C22608 _703_/a_324_432# _702_/a_2250_412# 0
C22609 _703_/a_741_93# _702_/a_1840_334# 0
C22610 _305_ FILLER_22_32/a_40_246# 0.00435f
C22611 hold143/a_326_118# _264_ 0
C22612 hold55/a_56_118# net43 0
C22613 _677_/a_550_127# _182_ 0
C22614 net48 _433_/a_244_412# 0
C22615 net13 net124 0
C22616 _266_ _648_/a_843_236# 0.00585f
C22617 _676_/a_324_432# baud_inst.counter\[4\] 0.01731f
C22618 _676_/a_741_93# net152 0.00469f
C22619 _440_/a_550_140# _158_ 0
C22620 rx_inst.bit_index\[1\] _236_ 0
C22621 _658_/a_324_432# FILLER_3_141/a_40_246# 0
C22622 hold181/a_326_118# hold135/a_438_182# 0.00196f
C22623 tx_inst.state\[4\] net168 0
C22624 tx_inst.data_reg\[7\] tx_data[2] 0
C22625 clknet_4_8_0_clk _104_ 0.00506f
C22626 fanout33/a_40_152# _077_ 0
C22627 _079_ FILLER_14_148/a_40_246# 0
C22628 _155_ _464_/a_22_110# 0.011f
C22629 _634_/a_298_337# net83 0
C22630 net148 _693_/a_612_127# 0
C22631 _643_/a_324_432# FILLER_21_194/a_32_246# 0
C22632 net10 _207_ 0.02001f
C22633 _357_/a_354_412# _182_ 0
C22634 rx_done tx_done 0.03011f
C22635 FILLER_15_162/a_40_246# VPWR 0.13971f
C22636 net39 net153 0
C22637 baud_inst.counter\[1\] net79 0.00226f
C22638 _392_/a_559_412# net54 0.00277f
C22639 _392_/a_382_118# _214_ 0.02269f
C22640 _064_ VPWR 0.11649f
C22641 _555_/a_209_168# VPWR 0.01293f
C22642 FILLER_0_35/a_40_246# _675_/a_741_93# 0
C22643 _175_ _664_/a_324_432# 0
C22644 VPWR _366_/a_170_412# 0
C22645 _036_ net29 0
C22646 net26 _671_/a_2002_114# 0
C22647 net145 _172_ 0
C22648 _696_/a_1785_429# clknet_4_9_0_clk 0
C22649 net84 _266_ 0
C22650 hold150/a_56_118# _123_ 0
C22651 clknet_4_5_0_clk net26 0
C22652 net12 _461_/a_22_110# 0.00158f
C22653 _314_ hold105/a_326_118# 0.0121f
C22654 hold75/a_326_118# _302_ 0
C22655 _679_/a_1489_191# clknet_0_clk 0.00207f
C22656 _635_/a_741_93# VPWR 0.01358f
C22657 _234_ _168_ 0.01413f
C22658 VPWR net40 2.76945f
C22659 _177_ _165_ 0
C22660 clknet_0_clk _096_ 0.00376f
C22661 _687_/a_843_236# _014_ 0.00163f
C22662 _540_/a_139_160# _296_ 0.00278f
C22663 hold59/a_326_118# hold59/a_438_182# 0
C22664 _310_ FILLER_20_95/a_40_246# 0
C22665 hold161/a_438_182# _017_ 0.00376f
C22666 _134_ _161_ 0
C22667 net50 _376_/a_76_160# 0.01015f
C22668 _192_ net54 0
C22669 net34 _396_/a_155_412# 0.02785f
C22670 net2 _129_ 0.00877f
C22671 _312_ _309_ 0.00357f
C22672 net45 _694_/a_324_432# 0.00278f
C22673 _499_/a_474_130# net40 0
C22674 _233_ fanout31/a_40_152# 0.01537f
C22675 _697_/a_1840_334# clkbuf_4_9_0_clk/a_27_118# 0
C22676 _092_ FILLER_6_54/a_32_246# 0.00153f
C22677 _537_/a_435_412# clknet_4_10_0_clk 0.0041f
C22678 net47 net83 0.03215f
C22679 net55 tx_inst.data_reg\[2\] 0.00126f
C22680 _671_/a_1785_429# rx_inst.state\[4\] 0.00181f
C22681 _292_ _685_/a_132_114# 0
C22682 hold164/a_56_118# net104 0
C22683 hold117/a_326_118# clknet_4_0_0_clk 0.00147f
C22684 hold110/a_56_118# net97 0.00747f
C22685 hold110/a_326_118# net108 0.02468f
C22686 net40 hold93/a_326_118# 0.05821f
C22687 _515_/a_76_160# FILLER_14_72/a_32_246# 0
C22688 _232_ net127 0.0018f
C22689 _160_ _632_/a_741_93# 0
C22690 _705_/a_1583_191# _704_/a_741_93# 0
C22691 baud_inst.counter\[26\] hold100/a_438_182# 0.01757f
C22692 _657_/a_132_114# VPWR 0
C22693 _359_/a_22_110# _197_ 0.00891f
C22694 _176_ _196_ 0.04345f
C22695 clknet_4_13_0_clk _636_/a_324_432# 0.05604f
C22696 _170_ _426_/a_154_118# 0.00121f
C22697 clknet_4_1_0_clk _655_/a_550_127# 0
C22698 _661_/a_38_114# tx_inst.data_reg\[1\] 0
C22699 _091_ hold93/a_56_118# 0.00161f
C22700 rx_inst.state\[3\] _669_/a_741_93# 0
C22701 _696_/a_612_127# clknet_4_8_0_clk 0
C22702 _158_ _633_/a_2250_412# 0.00839f
C22703 FILLER_22_133/a_40_246# rx_inst.bit_index\[1\] 0
C22704 hold141/a_326_118# net99 0.00463f
C22705 _688_/a_843_236# clknet_4_2_0_clk 0.03684f
C22706 _504_/a_209_168# _287_ 0.0143f
C22707 _705_/a_741_93# net43 0.00636f
C22708 hold164/a_326_118# net163 0.00512f
C22709 FILLER_22_152/a_32_246# _236_ 0
C22710 net108 _683_/a_1489_191# 0.01878f
C22711 _108_ net46 0
C22712 rx_inst.data_reg\[3\] _635_/a_38_114# 0.0109f
C22713 baud_inst.counter\[6\] _211_ 0
C22714 net28 clknet_0_clk 0.03117f
C22715 baud_inst.counter\[6\] _282_ 0.10117f
C22716 _185_ net152 0.03419f
C22717 _551_/a_170_160# baud_inst.counter\[29\] 0.00328f
C22718 net47 _649_/a_1489_191# 0.0034f
C22719 net135 hold60/a_326_118# 0
C22720 _224_ net25 0.35038f
C22721 _118_ _073_ 0
C22722 _010_ _290_ 0
C22723 _191_ _670_/a_2002_114# 0.00109f
C22724 net44 _669_/a_132_114# 0
C22725 hold125/a_56_118# _648_/a_324_432# 0.00352f
C22726 _257_ _255_ 0
C22727 _388_/a_496_118# _212_ 0.00397f
C22728 _256_ _255_ 0.03384f
C22729 VPWR _632_/a_2002_114# 0
C22730 FILLER_6_205/a_40_246# _198_ 0
C22731 rx_inst.state\[2\] _436_/a_244_140# 0
C22732 net142 _696_/a_1489_191# 0
C22733 _662_/a_298_337# clk 0.00157f
C22734 _067_ tx_inst.data_reg\[2\] 0.0021f
C22735 _670_/a_38_114# VPWR 0
C22736 net18 hold71/a_326_118# 0.0652f
C22737 _489_/a_358_436# _279_ 0
C22738 hold108/a_56_118# _180_ 0.00158f
C22739 net39 _280_ 0.15518f
C22740 _125_ _466_/a_22_110# 0
C22741 net37 clkbuf_4_14_0_clk/a_27_118# 0
C22742 _182_ _096_ 0
C22743 clknet_4_3_0_clk _685_/a_324_432# 0
C22744 net39 _688_/a_1583_191# 0
C22745 _046_ hold66/a_326_118# 0
C22746 hold168/a_438_182# _203_ 0
C22747 _207_ _389_/a_268_412# 0
C22748 _377_/a_268_412# _213_ 0
C22749 baud_inst.counter\[12\] _191_ 0
C22750 hold135/a_56_118# _287_ 0
C22751 hold135/a_326_118# net135 0.00116f
C22752 net156 hold158/a_56_118# 0.01765f
C22753 _675_/a_1583_191# clknet_4_0_0_clk 0.00755f
C22754 hold61/a_56_118# _033_ 0.01318f
C22755 hold171/a_56_118# _658_/a_1489_191# 0
C22756 tx_inst.data_reg\[4\] _658_/a_1840_334# 0.00112f
C22757 hold68/a_438_182# _313_ 0.04215f
C22758 _111_ _698_/a_1489_191# 0
C22759 hold137/a_56_118# _653_/a_741_93# 0
C22760 hold137/a_326_118# _653_/a_324_432# 0
C22761 baud_inst.counter\[30\] _702_/a_550_127# 0
C22762 FILLER_18_160/a_32_246# VPWR 0.06873f
C22763 clknet_0_clk _669_/a_681_505# 0
C22764 hold140/a_438_182# net142 0.00167f
C22765 net54 _706_/a_324_432# 0.01578f
C22766 clk net145 0
C22767 tx_inst.state\[4\] _705_/a_681_505# 0
C22768 FILLER_16_221/a_32_246# _636_/a_1583_191# 0
C22769 _642_/a_843_236# rx_inst.state\[2\] 0
C22770 net51 FILLER_13_228/a_40_246# 0
C22771 VPWR _648_/a_612_127# 0.00137f
C22772 _698_/a_1583_191# FILLER_21_96/a_40_246# 0
C22773 fanout39/a_40_152# net40 0.03156f
C22774 _269_ clkbuf_4_13_0_clk/a_27_118# 0
C22775 net47 _470_/a_22_110# 0
C22776 _116_ _347_/a_146_122# 0
C22777 _693_/a_1583_191# clknet_4_10_0_clk 0
C22778 clknet_4_5_0_clk _706_/a_681_505# 0
C22779 net173 _398_/a_115_308# 0.01296f
C22780 _508_/a_380_412# _682_/a_1840_334# 0
C22781 hold108/a_326_118# _292_ 0
C22782 _169_ _416_/a_146_122# 0
C22783 _635_/a_843_236# net30 0.01998f
C22784 _635_/a_741_93# _266_ 0
C22785 _147_ _339_/a_71_118# 0
C22786 _217_ _221_ 0.09044f
C22787 _219_ net183 0.00436f
C22788 net81 hold81/a_326_118# 0.00156f
C22789 _050_ hold81/a_438_182# 0.00357f
C22790 clknet_4_13_0_clk hold81/a_56_118# 0.0662f
C22791 hold85/a_56_118# net30 0.05858f
C22792 _314_ _701_/a_2250_412# 0.0016f
C22793 hold141/a_56_118# _180_ 0.00389f
C22794 FILLER_13_89/a_40_246# _685_/a_298_337# 0
C22795 _107_ VPWR 0.41937f
C22796 _663_/a_741_93# clknet_4_6_0_clk 0.00708f
C22797 net81 _707_/a_324_432# 0
C22798 _050_ _707_/a_741_93# 0
C22799 hold135/a_438_182# baud_inst.counter\[8\] 0.00122f
C22800 _216_ _666_/a_324_432# 0
C22801 _698_/a_298_337# _051_ 0
C22802 _173_ tx_inst.bit_index\[1\] 0.98417f
C22803 _355_/a_150_412# _296_ 0
C22804 _644_/a_298_337# _055_ 0.00435f
C22805 _677_/a_741_93# _282_ 0
C22806 net26 _001_ 0.18732f
C22807 hold101/a_326_118# _298_ 0
C22808 _233_ _168_ 0
C22809 hold115/a_438_182# clknet_4_0_0_clk 0.00657f
C22810 net57 _142_ 0.016f
C22811 net42 net57 0
C22812 VPWR _682_/a_741_93# 0.02835f
C22813 clknet_4_6_0_clk _417_/a_22_110# 0
C22814 _216_ FILLER_9_169/a_32_246# 0.00107f
C22815 _235_ net25 0.03238f
C22816 _638_/a_612_127# rx_inst.data_reg\[6\] 0
C22817 tx_data[3] _213_ 0
C22818 net79 _680_/a_2250_412# 0
C22819 hold102/a_438_182# _530_/a_155_412# 0
C22820 clknet_4_11_0_clk _702_/a_1785_429# 0
C22821 tx_data[6] _380_/a_59_156# 0
C22822 _462_/a_22_110# net65 0.00929f
C22823 net7 _148_ 0
C22824 _017_ _690_/a_38_114# 0.04147f
C22825 net102 _690_/a_298_337# 0
C22826 net156 baud_inst.counter\[15\] 0.47323f
C22827 rx_inst.bit_index\[2\] _419_/a_154_118# 0.00277f
C22828 hold53/a_326_118# clknet_4_14_0_clk 0.00557f
C22829 clkbuf_4_9_0_clk/a_27_118# baud_inst.counter\[14\] 0.00106f
C22830 _697_/a_132_114# baud_inst.counter\[24\] 0
C22831 _645_/a_1489_191# _644_/a_741_93# 0
C22832 _645_/a_2250_412# _644_/a_1583_191# 0
C22833 _700_/a_843_236# baud_inst.counter\[29\] 0
C22834 hold79/a_326_118# net60 0
C22835 hold79/a_56_118# _181_ 0
C22836 _661_/a_843_236# VPWR 0.00494f
C22837 _673_/a_2002_114# VPWR 0
C22838 net138 _636_/a_298_337# 0
C22839 _510_/a_350_122# _183_ 0
C22840 net39 _191_ 2.65699f
C22841 net156 FILLER_12_42/a_32_246# 0.01383f
C22842 FILLER_12_89/a_40_246# _191_ 0.00134f
C22843 _640_/a_681_505# VPWR 0
C22844 hold52/a_326_118# _254_ 0.00105f
C22845 hold52/a_56_118# _256_ 0
C22846 _058_ _137_ 0.04776f
C22847 FILLER_1_173/a_32_246# _656_/a_2250_412# 0.01061f
C22848 _101_ _015_ 0
C22849 _098_ net130 0
C22850 _691_/a_2250_412# _301_ 0.00112f
C22851 _699_/a_2250_412# net49 0
C22852 hold54/a_326_118# _201_ 0
C22853 _190_ clknet_0_clk 0.00232f
C22854 _205_ hold180/a_438_182# 0
C22855 _691_/a_38_114# _300_ 0
C22856 _691_/a_843_236# net101 0
C22857 _352_/a_46_156# _280_ 0
C22858 hold108/a_56_118# baud_inst.counter\[11\] 0.01477f
C22859 net155 _148_ 0
C22860 _650_/a_38_114# _458_/a_165_412# 0
C22861 net69 _128_ 0.01068f
C22862 net47 net77 0
C22863 _679_/a_38_114# net38 0.00102f
C22864 _398_/a_115_308# FILLER_7_146/a_32_246# 0.00917f
C22865 hold127/a_438_182# _649_/a_38_114# 0
C22866 _060_ _649_/a_550_127# 0
C22867 _490_/a_139_160# _279_ 0.00342f
C22868 net94 baud_inst.counter\[6\] 0
C22869 _285_ _352_/a_268_412# 0
C22870 _657_/a_1785_429# tx_inst.data_reg\[1\] 0.00234f
C22871 fanout34/a_40_152# net56 0.0804f
C22872 _687_/a_1489_191# _296_ 0.00868f
C22873 _307_ _548_/a_272_160# 0.0023f
C22874 _245_ _238_ 0
C22875 baud_inst.counter\[22\] net45 0.02852f
C22876 net37 fanout30/a_40_152# 0.00861f
C22877 hold106/a_326_118# baud_inst.counter\[29\] 0
C22878 VPWR _165_ 0.06098f
C22879 _392_/a_59_156# tx_inst.data_reg\[0\] 0.00279f
C22880 _392_/a_285_412# _144_ 0
C22881 _078_ FILLER_8_189/a_40_246# 0.00492f
C22882 _180_ baud_inst.counter\[15\] 0.18818f
C22883 net26 _005_ 0.00592f
C22884 clknet_4_5_0_clk net50 0
C22885 _306_ FILLER_22_43/a_40_246# 0
C22886 _108_ _313_ 0
C22887 hold141/a_56_118# net140 0.00888f
C22888 _634_/a_2250_412# hold71/a_326_118# 0
C22889 net168 _664_/a_1583_191# 0.03328f
C22890 net172 _664_/a_1840_334# 0.05025f
C22891 _142_ _400_/a_341_118# 0
C22892 FILLER_22_86/a_32_246# _026_ 0
C22893 net179 _150_ 0
C22894 _231_ net51 0
C22895 FILLER_20_57/a_32_246# net140 0
C22896 _198_ _369_/a_248_122# 0.00158f
C22897 net27 _274_ 0.07697f
C22898 _636_/a_298_337# _047_ 0.03996f
C22899 tx_busy net23 0.04343f
C22900 rx_inst.data_reg\[1\] hold131/a_326_118# 0.01988f
C22901 tx_inst.bit_index\[2\] net183 0.00673f
C22902 FILLER_16_154/a_32_246# net28 0
C22903 fanout26/a_40_152# _669_/a_1583_191# 0.0019f
C22904 _232_ _258_ 0
C22905 baud_inst.counter\[1\] _672_/a_741_93# 0
C22906 hold86/a_56_118# _672_/a_1840_334# 0.00251f
C22907 hold86/a_326_118# _672_/a_1583_191# 0.0037f
C22908 _636_/a_612_127# _156_ 0.00353f
C22909 _703_/a_38_114# _115_ 0
C22910 _556_/a_341_118# net67 0
C22911 _441_/a_154_118# VPWR 0
C22912 _013_ _292_ 0.00288f
C22913 tx_inst.bit_index\[1\] _341_/a_589_385# 0.00146f
C22914 clknet_4_8_0_clk _545_/a_248_122# 0
C22915 net30 _648_/a_550_127# 0
C22916 hold100/a_326_118# VPWR 0.00734f
C22917 _676_/a_2250_412# baud_inst.counter\[4\] 0.02034f
C22918 _510_/a_350_122# net115 0.00257f
C22919 net14 rx_data[2] 0.00541f
C22920 _679_/a_843_236# _282_ 0
C22921 hold116/a_326_118# _010_ 0
C22922 _292_ baud_inst.counter\[14\] 0.00189f
C22923 net31 FILLER_18_158/a_40_246# 0
C22924 FILLER_3_207/a_40_246# net172 0.02043f
C22925 clknet_0_clk _382_/a_496_118# 0
C22926 _173_ hold174/a_56_118# 0.00145f
C22927 _046_ _635_/a_38_114# 0.00404f
C22928 net44 _017_ 0.00153f
C22929 net167 clknet_4_9_0_clk 0.5069f
C22930 _282_ _683_/a_1840_334# 0
C22931 baud_inst.counter\[4\] _683_/a_2250_412# 0.00236f
C22932 _190_ _182_ 0.07135f
C22933 _446_/a_248_122# _054_ 0
C22934 _469_/a_120_432# net47 0.00221f
C22935 FILLER_12_173/a_32_246# clkbuf_4_6_0_clk/a_27_118# 0.00571f
C22936 _227_ rx_inst.bit_index\[2\] 0.06323f
C22937 _637_/a_681_505# clknet_4_15_0_clk 0
C22938 _546_/a_155_160# net99 0
C22939 _546_/a_192_429# baud_inst.counter\[25\] 0
C22940 net178 _296_ 0
C22941 net128 hold91/a_326_118# 0.00697f
C22942 _154_ _648_/a_1583_191# 0
C22943 net6 net8 0
C22944 net156 _690_/a_1489_191# 0
C22945 net12 _638_/a_1489_191# 0.00152f
C22946 net45 FILLER_22_54/a_40_246# 0.00114f
C22947 hold143/a_56_118# _156_ 0
C22948 _010_ net108 0.22589f
C22949 _292_ net97 0.01813f
C22950 rx_inst.data_reg\[2\] net47 0.05118f
C22951 _697_/a_1489_191# baud_inst.counter\[25\] 0.00247f
C22952 tx_data[0] input9/a_40_152# 0
C22953 input3/a_40_152# tx_data[6] 0.00193f
C22954 net89 _188_ 0
C22955 net65 hold72/a_326_118# 0
C22956 baud_inst.counter\[7\] clknet_0_clk 0.06222f
C22957 hold174/a_438_182# net174 0.02806f
C22958 _411_/a_358_436# net25 0
C22959 hold121/a_438_182# _105_ 0
C22960 net85 VPWR 0.10688f
C22961 _642_/a_38_114# baud_inst.counter\[25\] 0
C22962 _283_ _677_/a_38_114# 0.02395f
C22963 _098_ _358_/a_72_436# 0
C22964 baud_inst.counter\[0\] _085_ 0.00128f
C22965 _276_ _196_ 0
C22966 hold153/a_438_182# _281_ 0
C22967 hold68/a_56_118# _700_/a_38_114# 0
C22968 hold125/a_56_118# _123_ 0
C22969 _098_ _686_/a_1840_334# 0
C22970 _044_ FILLER_29_165/a_40_246# 0.00355f
C22971 net14 _637_/a_843_236# 0.00174f
C22972 _672_/a_298_337# VPWR 0.00375f
C22973 net132 _255_ 0
C22974 rx_inst.bit_index\[1\] net2 0.07069f
C22975 net45 _694_/a_2250_412# 0.00255f
C22976 clkbuf_4_7_0_clk/a_27_118# _666_/a_2250_412# 0
C22977 rx_done output22/a_40_152# 0
C22978 net42 fanout27/a_40_152# 0.00144f
C22979 tx_busy clkbuf_4_7_0_clk/a_27_118# 0
C22980 _478_/a_27_156# _200_ 0
C22981 _658_/a_298_337# net5 0
C22982 _023_ clknet_4_10_0_clk 0.11309f
C22983 _042_ _120_ 0.00382f
C22984 _653_/a_298_337# _142_ 0.0053f
C22985 hold154/a_326_118# baud_inst.counter\[13\] 0
C22986 net39 _101_ 0.30903f
C22987 FILLER_17_160/a_40_246# VPWR 0.12446f
C22988 _342_/a_170_412# net54 0
C22989 net42 _653_/a_298_337# 0.00411f
C22990 rx_data[4] hold73/a_438_182# 0.01028f
C22991 VPWR FILLER_8_35/a_32_246# 0.08044f
C22992 _359_/a_120_432# VPWR 0.00118f
C22993 _705_/a_1489_191# _704_/a_843_236# 0
C22994 _201_ _665_/a_38_114# 0
C22995 fanout33/a_40_152# net43 0
C22996 hold142/a_326_118# _025_ 0.00322f
C22997 hold142/a_438_182# _310_ 0
C22998 _657_/a_1489_191# VPWR 0.00233f
C22999 clk _380_/a_559_412# 0
C23000 clkbuf_4_11_0_clk/a_27_118# clknet_4_11_0_clk 0.0901f
C23001 clknet_4_5_0_clk net34 0.00379f
C23002 net48 net81 0.00141f
C23003 _024_ clknet_4_8_0_clk 0.28314f
C23004 input7/a_40_152# tx_data[4] 0.03105f
C23005 _688_/a_612_127# clknet_4_2_0_clk 0
C23006 VPWR _522_/a_380_412# 0
C23007 VPWR _650_/a_843_236# 0.00374f
C23008 net135 _038_ 0.00206f
C23009 _705_/a_1785_429# net43 0
C23010 _637_/a_38_114# _637_/a_132_114# -0
C23011 net108 baud_inst.counter\[11\] 0.00167f
C23012 _314_ baud_inst.counter\[29\] 0.03043f
C23013 _427_/a_350_122# VPWR 0
C23014 clknet_0_clk _209_ 0.00179f
C23015 net47 rx_inst.data_reg\[6\] 0
C23016 net47 _632_/a_324_432# 0
C23017 _696_/a_324_432# _308_ 0
C23018 _232_ _444_/a_244_412# 0.03157f
C23019 clknet_4_12_0_clk _264_ 0.00853f
C23020 net36 net176 0
C23021 _082_ _669_/a_550_127# 0
C23022 _138_ _648_/a_843_236# 0.00139f
C23023 net66 _160_ 0
C23024 hold79/a_438_182# FILLER_0_56/a_32_246# 0.00985f
C23025 _659_/a_38_114# _382_/a_382_118# 0
C23026 _634_/a_38_114# _124_ 0.05905f
C23027 hold148/a_438_182# _303_ 0.00814f
C23028 net79 _491_/a_155_160# 0
C23029 hold54/a_326_118# tx_inst.state\[3\] 0.00202f
C23030 baud_inst.counter\[7\] _182_ 0
C23031 _228_ _249_ 0.00166f
C23032 _638_/a_741_93# hold70/a_326_118# 0
C23033 _638_/a_324_432# hold70/a_438_182# 0
C23034 _638_/a_843_236# hold70/a_56_118# 0
C23035 _662_/a_1583_191# clk 0.00471f
C23036 _376_/a_272_160# _200_ 0.00195f
C23037 _670_/a_1840_334# VPWR 0
C23038 hold157/a_56_118# baud_inst.counter\[16\] 0.00657f
C23039 _206_ input7/a_40_152# 0
C23040 _031_ hold114/a_438_182# 0
C23041 hold178/a_438_182# clknet_4_2_0_clk 0.00923f
C23042 baud_inst.counter\[21\] net49 0.01593f
C23043 clknet_4_10_0_clk _701_/a_843_236# 0.02688f
C23044 _043_ _635_/a_38_114# 0
C23045 fanout29/a_40_152# net90 0.00475f
C23046 FILLER_19_139/a_40_246# net25 0.01634f
C23047 hold175/a_438_182# _450_/a_127_436# 0
C23048 _676_/a_843_236# _280_ 0
C23049 _675_/a_2002_114# clknet_4_0_0_clk 0
C23050 net35 _413_/a_170_412# 0.00372f
C23051 _394_/a_120_432# _166_ 0.00131f
C23052 hold122/a_438_182# clknet_4_6_0_clk 0.04731f
C23053 _180_ _686_/a_324_432# 0
C23054 net49 net180 0.00243f
C23055 clk _667_/a_38_114# 0.05335f
C23056 _519_/a_81_118# VPWR 0.00506f
C23057 _684_/a_741_93# net29 0
C23058 hold99/a_326_118# net100 0.01593f
C23059 net94 FILLER_5_74/a_32_246# 0.01772f
C23060 _280_ _683_/a_843_236# 0
C23061 clknet_0_clk _669_/a_550_127# 0
C23062 FILLER_18_65/a_40_246# net46 0.01925f
C23063 hold126/a_438_182# rx_inst.data_reg\[6\] 0
C23064 net54 _706_/a_2250_412# 0.0041f
C23065 _378_/a_285_118# net155 0.00147f
C23066 _652_/a_843_236# _142_ 0.02657f
C23067 _676_/a_1840_334# FILLER_12_117/a_40_246# 0
C23068 net35 _424_/a_244_140# 0
C23069 _285_ _679_/a_38_114# 0
C23070 net94 _679_/a_843_236# 0.04351f
C23071 _500_/a_155_412# _679_/a_1840_334# 0
C23072 net92 _679_/a_741_93# 0
C23073 _527_/a_435_412# baud_inst.counter\[16\] 0
C23074 baud_inst.counter\[30\] _116_ 0.05731f
C23075 _064_ _652_/a_741_93# 0.0095f
C23076 net42 _652_/a_843_236# 0.01366f
C23077 _204_ rx_inst.state\[4\] 0
C23078 net124 hold125/a_56_118# 0
C23079 net15 net16 0
C23080 hold172/a_56_118# _200_ 0
C23081 hold172/a_438_182# net172 0.00541f
C23082 _704_/a_1583_191# hold80/a_56_118# 0
C23083 net173 _216_ 1.74595f
C23084 _286_ _683_/a_741_93# 0.00175f
C23085 _635_/a_612_127# net30 0.02243f
C23086 _068_ _339_/a_1377_160# 0
C23087 tx_inst.data_reg\[3\] _339_/a_589_385# 0
C23088 baud_inst.counter\[30\] hold67/a_438_182# 0.00531f
C23089 net85 _266_ 0.00959f
C23090 net128 _515_/a_272_160# 0
C23091 clkbuf_4_11_0_clk/a_27_118# _703_/a_1840_334# 0
C23092 net159 net41 0
C23093 FILLER_5_84/a_40_246# _066_ 0
C23094 _163_ net40 0.03154f
C23095 _639_/a_2250_412# net51 0
C23096 net81 _707_/a_2250_412# 0
C23097 _047_ _457_/a_22_110# 0
C23098 _697_/a_324_432# net46 0.00178f
C23099 net106 VPWR 0.11213f
C23100 baud_inst.counter\[19\] _296_ 0.00187f
C23101 clknet_4_13_0_clk _157_ 0
C23102 _194_ _193_ 0.00237f
C23103 FILLER_13_137/a_32_246# VPWR 0.07883f
C23104 _644_/a_843_236# rx_inst.data_reg\[1\] 0
C23105 _644_/a_132_114# net132 0
C23106 net58 _702_/a_324_432# 0.00127f
C23107 _316_ _702_/a_38_114# 0
C23108 tx_inst.data_reg\[4\] net55 0.01504f
C23109 VPWR _682_/a_1785_429# 0
C23110 hold178/a_56_118# _683_/a_324_432# 0
C23111 net53 _263_ 0
C23112 net70 rx_inst.data_reg\[6\] 1.11224f
C23113 hold142/a_438_182# _698_/a_1840_334# 0
C23114 _102_ _688_/a_324_432# 0
C23115 _017_ _302_ 0.00294f
C23116 hold102/a_438_182# _018_ 0
C23117 clknet_4_11_0_clk _115_ 0.08895f
C23118 _022_ _692_/a_324_432# 0
C23119 _546_/a_435_412# net140 0
C23120 _546_/a_192_429# baud_inst.counter\[24\] 0
C23121 input9/a_40_152# _208_ 0
C23122 hold147/a_438_182# VPWR 0.02054f
C23123 net28 net43 0.08312f
C23124 net37 _154_ 0
C23125 clk tx_data[0] 0
C23126 net2 _668_/a_741_93# 0
C23127 _697_/a_612_127# _309_ 0
C23128 _043_ _632_/a_550_127# 0
C23129 _645_/a_681_505# net132 0
C23130 _700_/a_612_127# baud_inst.counter\[29\] 0
C23131 _379_/a_46_156# VPWR 0.00932f
C23132 _661_/a_612_127# VPWR 0.00101f
C23133 rx_inst.data_reg\[4\] _636_/a_1840_334# 0
C23134 _488_/a_209_168# net40 0
C23135 _172_ FILLER_6_151/a_40_246# 0.02789f
C23136 _291_ _183_ 0.06853f
C23137 _292_ clkbuf_4_2_0_clk/a_27_118# 0.0778f
C23138 net123 _676_/a_741_93# 0
C23139 rx_inst.bit_index\[2\] _242_ 0.13414f
C23140 _640_/a_550_127# VPWR 0
C23141 net49 _694_/a_132_114# 0
C23142 _375_/a_170_412# _198_ 0
C23143 hold67/a_56_118# clknet_4_11_0_clk 0.02245f
C23144 net131 _272_ 0
C23145 _650_/a_132_114# _000_ 0
C23146 _650_/a_681_505# net30 0.00102f
C23147 _650_/a_843_236# _266_ 0.02863f
C23148 baud_inst.counter\[2\] net60 0.00359f
C23149 _676_/a_843_236# _191_ 0.00508f
C23150 _411_/a_494_160# net180 0
C23151 _031_ _551_/a_76_160# 0.00129f
C23152 hold68/a_56_118# net105 0.0048f
C23153 fanout40/a_40_152# _296_ 0.00394f
C23154 hold106/a_326_118# FILLER_28_53/a_32_246# 0
C23155 clk _220_ 0
C23156 FILLER_17_94/a_40_246# net46 0.00872f
C23157 _674_/a_741_93# _490_/a_45_160# 0.00282f
C23158 _669_/a_38_114# clknet_4_9_0_clk 0.05021f
C23159 net26 _161_ 0
C23160 _645_/a_324_432# rx_inst.data_reg\[2\] 0
C23161 tx_inst.data_reg\[4\] _067_ 0.1325f
C23162 _053_ hold176/a_56_118# 0
C23163 net44 net147 0
C23164 hold57/a_56_118# net27 0.00107f
C23165 net122 _405_/a_229_118# 0.00125f
C23166 net37 _405_/a_27_156# 0.02691f
C23167 net44 net46 0.23856f
C23168 _673_/a_1489_191# net60 0.01333f
C23169 _068_ tx_inst.data_reg\[1\] 0.04166f
C23170 FILLER_5_181/a_32_246# _005_ 0
C23171 hold177/a_326_118# VPWR 0.0014f
C23172 net32 _161_ 1.0732f
C23173 _286_ _185_ 0
C23174 hold133/a_326_118# _702_/a_324_432# 0
C23175 hold165/a_326_118# net165 0
C23176 _651_/a_1489_191# _166_ 0
C23177 hold184/a_56_118# clkbuf_4_4_0_clk/a_27_118# 0.00154f
C23178 clknet_4_14_0_clk _421_/a_354_412# 0
C23179 _665_/a_38_114# tx_inst.state\[3\] 0
C23180 clkbuf_4_0_0_clk/a_27_118# _287_ 0.02554f
C23181 net82 _634_/a_38_114# 0.00108f
C23182 net30 rx_inst.state\[1\] 0
C23183 net168 _664_/a_2002_114# 0
C23184 fanout43/a_40_152# _667_/a_324_432# 0
C23185 _155_ _049_ 0.00156f
C23186 _241_ net29 0
C23187 net37 fanout36/a_40_152# 0
C23188 _421_/a_150_412# _237_ 0.00286f
C23189 clknet_4_4_0_clk clknet_0_clk 0.03736f
C23190 _078_ tx_inst.bit_index\[0\] 0.00421f
C23191 _680_/a_38_114# net136 0.0387f
C23192 net23 _704_/a_741_93# 0.00217f
C23193 tx_done _704_/a_324_432# 0
C23194 _243_ _242_ 0.13001f
C23195 FILLER_19_77/a_32_246# baud_inst.counter\[25\] 0
C23196 hold116/a_438_182# _289_ 0.00108f
C23197 _305_ fanout44/a_40_152# 0
C23198 tx_inst.data_reg\[6\] _071_ 0.02704f
C23199 FILLER_8_70/a_32_246# baud_inst.counter\[4\] 0.01804f
C23200 _511_/a_354_412# net29 0
C23201 baud_inst.counter\[4\] FILLER_11_125/a_32_246# 0.00217f
C23202 _361_/a_248_122# net173 0.00372f
C23203 _277_ _671_/a_843_236# 0.02901f
C23204 net2 _667_/a_38_114# 0
C23205 clknet_4_8_0_clk baud_inst.counter\[25\] 0.02358f
C23206 hold114/a_438_182# net46 0.0034f
C23207 net37 _160_ 0
C23208 net97 _289_ 0.0103f
C23209 _291_ net115 0.01795f
C23210 _194_ net174 0
C23211 _679_/a_1489_191# net152 0
C23212 _679_/a_612_127# _282_ 0
C23213 _644_/a_1840_334# _044_ 0
C23214 net42 _663_/a_132_114# 0
C23215 _693_/a_298_337# VPWR 0.00894f
C23216 net16 _466_/a_22_110# 0
C23217 net36 _255_ 0.0055f
C23218 _017_ hold158/a_438_182# 0
C23219 _296_ _297_ 0.00873f
C23220 _514_/a_257_140# hold129/a_56_118# 0
C23221 _457_/a_120_432# net80 0.0061f
C23222 _637_/a_550_127# clknet_4_15_0_clk 0
C23223 net54 net168 0.00253f
C23224 _206_ _370_/a_154_118# 0.00202f
C23225 _681_/a_132_114# net117 0
C23226 _681_/a_843_236# baud_inst.counter\[9\] 0
C23227 _677_/a_132_114# _280_ 0
C23228 _180_ clknet_4_9_0_clk 0.01991f
C23229 net12 net18 0.91412f
C23230 net50 _199_ 0.04888f
C23231 FILLER_16_56/a_32_246# _100_ 0
C23232 hold162/a_438_182# net141 0.00173f
C23233 hold162/a_56_118# _025_ 0.01949f
C23234 _230_ net25 0.0683f
C23235 hold162/a_326_118# _310_ 0.04735f
C23236 _170_ _429_/a_550_140# 0
C23237 rx_inst.bit_index\[0\] net24 0.00378f
C23238 hold118/a_56_118# _639_/a_1840_334# 0.00106f
C23239 hold118/a_326_118# _639_/a_1583_191# 0.00293f
C23240 _674_/a_298_337# net61 0
C23241 net35 _430_/a_170_412# 0
C23242 hold52/a_438_182# net25 0
C23243 _392_/a_559_412# VPWR 0.00114f
C23244 _276_ _365_/a_155_412# 0
C23245 net26 _365_/a_257_140# 0
C23246 clkbuf_0_clk/a_116_82# _670_/a_324_432# 0
C23247 FILLER_15_185/a_32_246# _140_ 0
C23248 _234_ _671_/a_38_114# 0
C23249 hold103/a_438_182# _301_ 0.01659f
C23250 hold111/a_56_118# rx_inst.data_reg\[0\] 0.02658f
C23251 hold175/a_438_182# net175 0.02152f
C23252 hold175/a_56_118# net24 0.00803f
C23253 net37 _417_/a_120_432# 0.00112f
C23254 _031_ _700_/a_741_93# 0
C23255 clk FILLER_6_151/a_40_246# 0
C23256 net14 _637_/a_612_127# 0
C23257 _536_/a_192_429# _021_ 0.00956f
C23258 net120 _534_/a_46_156# 0
C23259 _672_/a_1583_191# VPWR 0.00852f
C23260 net6 net181 0
C23261 FILLER_4_183/a_40_246# net41 0
C23262 hold98/a_56_118# _094_ 0
C23263 baud_inst.counter\[8\] _510_/a_146_122# 0.0013f
C23264 hold119/a_56_118# _241_ 0
C23265 _139_ _649_/a_298_337# 0
C23266 net87 clknet_0_clk 0.01008f
C23267 _653_/a_1840_334# _220_ 0
C23268 _653_/a_1583_191# _142_ 0.00271f
C23269 hold135/a_56_118# net181 0.00817f
C23270 _064_ _653_/a_132_114# 0
C23271 _080_ _667_/a_324_432# 0.04507f
C23272 _314_ FILLER_28_53/a_32_246# 0
C23273 _192_ VPWR 0.27907f
C23274 net22 _704_/a_843_236# 0.0016f
C23275 hold129/a_56_118# net130 0.00819f
C23276 _134_ fanout36/a_40_152# 0
C23277 _386_/a_382_118# _149_ 0
C23278 _386_/a_559_412# net137 0.00243f
C23279 _059_ net125 0.13443f
C23280 tx_inst.data_reg\[3\] VPWR 0.2488f
C23281 FILLER_10_147/a_32_246# _080_ 0
C23282 clk _208_ 0.02546f
C23283 net46 _685_/a_1583_191# 0.00207f
C23284 _188_ _528_/a_81_118# 0
C23285 _649_/a_324_432# rx_inst.data_reg\[6\] 0
C23286 _072_ _145_ 0
C23287 _093_ hold117/a_326_118# 0
C23288 VPWR _650_/a_612_127# 0
C23289 hold119/a_326_118# _140_ 0.00467f
C23290 _249_ _434_/a_150_412# 0
C23291 _031_ hold106/a_56_118# 0.00103f
C23292 _109_ _696_/a_741_93# 0
C23293 _695_/a_324_432# clknet_4_10_0_clk 0.03707f
C23294 hold121/a_56_118# baud_inst.counter\[21\] 0.00268f
C23295 _174_ _196_ 0.00427f
C23296 _175_ FILLER_3_177/a_32_246# 0.00623f
C23297 _173_ _341_/a_382_118# 0
C23298 hold117/a_438_182# _183_ 0
C23299 _518_/a_45_160# baud_inst.counter\[15\] 0
C23300 _244_ VPWR 0.2444f
C23301 _640_/a_843_236# net45 0.00264f
C23302 _509_/a_155_412# _290_ 0.00172f
C23303 _179_ net113 0
C23304 _180_ _026_ 0
C23305 _138_ _648_/a_612_127# 0.01846f
C23306 _691_/a_298_337# _531_/a_209_168# 0
C23307 _228_ net51 0.00438f
C23308 hold155/a_438_182# _209_ 0
C23309 _662_/a_2002_114# clk 0
C23310 _151_ net7 0.01163f
C23311 _644_/a_2250_412# _272_ 0
C23312 net36 hold52/a_56_118# 0
C23313 rx_inst.bit_index\[1\] hold52/a_326_118# 0.00402f
C23314 net48 hold80/a_438_182# 0
C23315 _097_ _684_/a_324_432# 0.00864f
C23316 hold130/a_326_118# _190_ 0.05988f
C23317 net32 clkbuf_4_14_0_clk/a_27_118# 0
C23318 _346_/a_354_412# baud_inst.counter\[29\] 0
C23319 _640_/a_324_432# _224_ 0
C23320 _224_ _667_/a_1583_191# 0
C23321 hold88/a_326_118# clkbuf_4_8_0_clk/a_27_118# 0.00449f
C23322 _048_ _633_/a_1840_334# 0
C23323 _660_/a_681_505# net55 0
C23324 hold132/a_326_118# net24 0
C23325 hold175/a_438_182# _161_ 0.03551f
C23326 _183_ baud_inst.counter\[4\] 0.07547f
C23327 net147 _302_ 2.03673f
C23328 hold163/a_438_182# VPWR 0.01748f
C23329 _302_ net46 0.39531f
C23330 _180_ _686_/a_2250_412# 0.01316f
C23331 _244_ _239_ 0.00178f
C23332 clk _667_/a_1840_334# 0
C23333 net128 VPWR 0.39535f
C23334 _310_ _543_/a_146_122# 0.00172f
C23335 _684_/a_1785_429# net29 0
C23336 _696_/a_324_432# VPWR 0
C23337 hold102/a_326_118# net158 0
C23338 net155 _151_ 0.00808f
C23339 net94 _679_/a_612_127# 0.00394f
C23340 _285_ _679_/a_1840_334# 0.00553f
C23341 _283_ _679_/a_2250_412# 0.02076f
C23342 net92 _679_/a_1785_429# 0.00271f
C23343 _652_/a_612_127# _142_ 0
C23344 _132_ rx_inst.state\[2\] 0.01442f
C23345 FILLER_25_177/a_40_246# _244_ 0.01825f
C23346 clkbuf_4_10_0_clk/a_27_118# net46 0
C23347 net141 _025_ 0.67452f
C23348 hold136/a_438_182# VPWR 0.00807f
C23349 _506_/a_155_412# net38 0.00198f
C23350 hold69/a_56_118# _273_ 0
C23351 _080_ _142_ 0
C23352 net42 _652_/a_612_127# 0.02207f
C23353 FILLER_19_77/a_32_246# baud_inst.counter\[24\] 0.00299f
C23354 _155_ net125 0.01468f
C23355 _312_ clknet_0_clk 0.0028f
C23356 net42 _080_ 0.01525f
C23357 hold140/a_438_182# clknet_4_11_0_clk 0
C23358 hold98/a_438_182# VPWR 0.02268f
C23359 hold114/a_438_182# _313_ 0.05407f
C23360 FILLER_3_150/a_40_246# net165 0
C23361 _706_/a_324_432# VPWR 0.01724f
C23362 _680_/a_298_337# clknet_4_0_0_clk 0.00654f
C23363 hold169/a_56_118# _220_ 0
C23364 _223_ clknet_0_clk 0.16803f
C23365 hold139/a_56_118# VPWR 0.01184f
C23366 FILLER_25_150/a_32_246# _161_ 0
C23367 hold100/a_56_118# net45 0
C23368 FILLER_10_78/a_32_246# baud_inst.counter\[4\] 0.01889f
C23369 hold122/a_56_118# _667_/a_1583_191# 0
C23370 _075_ clknet_4_6_0_clk 0.21419f
C23371 hold128/a_326_118# net29 0.0064f
C23372 hold118/a_438_182# rx_inst.data_reg\[7\] 0.01567f
C23373 VPWR _014_ 0.04483f
C23374 clknet_4_8_0_clk baud_inst.counter\[24\] 0.31627f
C23375 _444_/a_142_412# _255_ 0.02801f
C23376 net183 _667_/a_1489_191# 0
C23377 _684_/a_681_505# net40 0
C23378 net184 _217_ 0
C23379 _118_ net146 0
C23380 _045_ _633_/a_298_337# 0
C23381 _660_/a_324_432# tx_inst.data_reg\[2\] 0
C23382 net154 baud_inst.counter\[4\] 0.58348f
C23383 net26 _458_/a_279_412# 0.00203f
C23384 hold87/a_438_182# baud_inst.counter\[15\] 0.00932f
C23385 net162 _296_ 0
C23386 _032_ _702_/a_1583_191# 0
C23387 _113_ _700_/a_298_337# 0.01253f
C23388 hold181/a_438_182# net86 0
C23389 _370_/a_154_118# _202_ 0
C23390 _080_ _485_/a_22_110# 0
C23391 net67 net45 0
C23392 net92 hold96/a_326_118# 0.00655f
C23393 net94 hold96/a_438_182# 0.00214f
C23394 _169_ _667_/a_38_114# 0.00607f
C23395 net18 _632_/a_1583_191# 0
C23396 _026_ net140 0.00176f
C23397 _022_ _692_/a_2250_412# 0
C23398 _675_/a_324_432# FILLER_3_21/a_40_246# 0
C23399 hold160/a_438_182# baud_inst.counter\[17\] 0.04056f
C23400 net51 _153_ 0.05118f
C23401 net2 fanout28/a_40_152# 0
C23402 baud_inst.counter\[28\] _701_/a_550_127# 0
C23403 _093_ hold115/a_438_182# 0.00129f
C23404 net48 _633_/a_741_93# 0.00248f
C23405 net2 _668_/a_1785_429# 0
C23406 net142 _309_ 0
C23407 _534_/a_46_156# _533_/a_248_122# 0
C23408 _254_ _439_/a_354_412# 0.0013f
C23409 _256_ _439_/a_252_412# 0
C23410 _537_/a_435_412# VPWR 0
C23411 _645_/a_550_127# net132 0
C23412 _645_/a_1489_191# _055_ 0
C23413 VPWR _702_/a_1489_191# 0
C23414 hold123/a_56_118# FILLER_11_125/a_32_246# 0.00109f
C23415 net13 _264_ 0.11262f
C23416 _240_ clknet_0_clk 0.07298f
C23417 _707_/a_2250_412# hold80/a_438_182# 0.00199f
C23418 _453_/a_170_412# _131_ 0
C23419 clknet_4_14_0_clk VPWR 1.03087f
C23420 baud_inst.counter\[4\] net115 0
C23421 _090_ VPWR 0.20446f
C23422 net182 hold128/a_326_118# 0.00188f
C23423 clknet_0_clk _685_/a_324_432# 0.01171f
C23424 _061_ _459_/a_27_156# 0
C23425 _650_/a_612_127# _266_ 0
C23426 _691_/a_1583_191# hold163/a_56_118# 0.00119f
C23427 clknet_0_clk _666_/a_1583_191# 0.0211f
C23428 _294_ _520_/a_155_412# 0.03054f
C23429 _230_ _139_ 0.00298f
C23430 _651_/a_38_114# clknet_4_6_0_clk 0.01364f
C23431 net44 _530_/a_155_412# 0
C23432 hold157/a_438_182# net157 0.00145f
C23433 _669_/a_1840_334# clknet_4_9_0_clk 0.00117f
C23434 _645_/a_2250_412# rx_inst.data_reg\[2\] 0.00118f
C23435 _112_ _027_ 0.01827f
C23436 _523_/a_155_412# net40 0.0155f
C23437 net44 _690_/a_843_236# 0
C23438 _696_/a_298_337# net162 0.00261f
C23439 _639_/a_843_236# VPWR 0.00235f
C23440 _059_ _245_ 0.00299f
C23441 _062_ _221_ 0
C23442 fanout30/a_40_152# net26 0
C23443 clknet_4_1_0_clk _181_ 0
C23444 _705_/a_38_114# _199_ 0
C23445 clknet_4_8_0_clk FILLER_15_42/a_40_246# 0
C23446 hold75/a_438_182# clknet_4_10_0_clk 0.05391f
C23447 _139_ FILLER_22_175/a_32_246# 0
C23448 _217_ _651_/a_324_432# 0
C23449 VPWR _529_/a_139_160# 0
C23450 _446_/a_248_122# _257_ 0
C23451 fanout30/a_40_152# net32 0
C23452 _245_ _159_ 0
C23453 hold127/a_56_118# _238_ 0
C23454 clknet_4_14_0_clk _239_ 0.0836f
C23455 _665_/a_1840_334# tx_inst.state\[3\] 0.00793f
C23456 _041_ _142_ 0
C23457 net177 net40 0
C23458 hold120/a_438_182# _108_ 0
C23459 _640_/a_38_114# net49 0
C23460 _200_ tx_inst.state\[2\] 0.03921f
C23461 _152_ VPWR 0.15222f
C23462 net42 _041_ 0.08105f
C23463 _659_/a_843_236# _069_ 0
C23464 _693_/a_324_432# _106_ 0.01168f
C23465 _211_ _382_/a_559_412# 0.00189f
C23466 _652_/a_38_114# FILLER_11_123/a_40_246# 0
C23467 _527_/a_155_160# _299_ 0
C23468 FILLER_25_177/a_40_246# clknet_4_14_0_clk 0
C23469 _680_/a_1840_334# net136 0
C23470 output23/a_40_152# _704_/a_1489_191# 0
C23471 tx_done _704_/a_2250_412# 0.00532f
C23472 hold161/a_438_182# _690_/a_612_127# 0
C23473 FILLER_26_229/a_32_246# hold72/a_56_118# 0
C23474 _551_/a_76_160# _313_ 0.0431f
C23475 net155 FILLER_4_108/a_40_246# 0
C23476 _195_ _007_ 0.01363f
C23477 _217_ net169 0.0695f
C23478 net156 _688_/a_681_505# 0
C23479 hold156/a_438_182# _688_/a_2250_412# 0
C23480 net179 _706_/a_38_114# 0.00663f
C23481 baud_inst.counter\[12\] _513_/a_192_429# 0
C23482 _519_/a_81_118# _163_ 0.01175f
C23483 FILLER_15_67/a_40_246# hold177/a_56_118# 0.00102f
C23484 hold86/a_438_182# baud_inst.counter\[0\] 0
C23485 hold104/a_326_118# VPWR 0.00271f
C23486 VPWR FILLER_5_59/a_40_246# 0.14424f
C23487 net122 hold122/a_438_182# 0.00456f
C23488 net2 _667_/a_1840_334# 0
C23489 net37 hold122/a_326_118# 0
C23490 _277_ _671_/a_612_127# 0.01575f
C23491 rx_inst.state\[2\] _451_/a_257_140# 0
C23492 _515_/a_76_160# FILLER_14_70/a_40_246# 0.00231f
C23493 hold184/a_56_118# VPWR 0.04779f
C23494 baud_inst.counter\[7\] net152 0
C23495 clknet_4_3_0_clk baud_inst.counter\[4\] 0.16423f
C23496 _516_/a_279_412# VPWR 0
C23497 _170_ _448_/a_244_412# 0.02519f
C23498 _693_/a_1583_191# VPWR 0.02552f
C23499 hold165/a_438_182# _656_/a_843_236# 0
C23500 _174_ tx_inst.data_reg\[0\] 0
C23501 _073_ hold168/a_56_118# 0.00324f
C23502 _484_/a_154_118# _278_ 0.00337f
C23503 _024_ _687_/a_2250_412# 0
C23504 net97 net135 0.02705f
C23505 net108 _287_ 0
C23506 _293_ hold129/a_326_118# 0.00264f
C23507 _226_ _132_ 0.09972f
C23508 _081_ clkbuf_4_7_0_clk/a_27_118# 0
C23509 _531_/a_380_412# VPWR 0
C23510 _697_/a_843_236# clknet_0_clk 0.01662f
C23511 rx_data[2] hold82/a_438_182# 0
C23512 hold132/a_56_118# VPWR 0.04404f
C23513 _360_/a_295_385# net41 0.00227f
C23514 _681_/a_612_127# baud_inst.counter\[9\] 0
C23515 _677_/a_1489_191# _280_ 0.0018f
C23516 output22/a_40_152# _704_/a_324_432# 0
C23517 hold157/a_438_182# _298_ 0.0025f
C23518 hold89/a_326_118# _100_ 0.00957f
C23519 hold139/a_56_118# _167_ 0
C23520 _287_ net181 0.31629f
C23521 net135 net86 0.04286f
C23522 baud_inst.counter\[14\] _099_ 0.06563f
C23523 net32 FILLER_18_148/a_40_246# 0
C23524 clkbuf_4_10_0_clk/a_27_118# _313_ 0.07038f
C23525 clknet_0_clk _261_ 0.01637f
C23526 _057_ _136_ 0.02668f
C23527 _155_ _245_ 0.40357f
C23528 _642_/a_1840_334# _669_/a_2250_412# 0
C23529 _053_ _669_/a_298_337# 0
C23530 hold139/a_438_182# _647_/a_38_114# 0
C23531 _674_/a_1840_334# _033_ 0
C23532 _180_ _162_ 0.00386f
C23533 FILLER_4_183/a_40_246# _171_ 0
C23534 _352_/a_268_412# VPWR 0
C23535 clkbuf_0_clk/a_116_82# _670_/a_2250_412# 0.00222f
C23536 net37 _140_ 0.03676f
C23537 _704_/a_38_114# _121_ 0.0018f
C23538 _672_/a_2002_114# VPWR 0
C23539 net20 _704_/a_1583_191# 0.01167f
C23540 net55 _654_/a_298_337# 0.01811f
C23541 _651_/a_741_93# _401_/a_22_110# 0
C23542 net147 _692_/a_132_114# 0
C23543 clknet_4_14_0_clk _266_ 0.06521f
C23544 _658_/a_1489_191# _212_ 0
C23545 _499_/a_209_168# baud_inst.counter\[6\] 0
C23546 hold118/a_56_118# net118 0.00216f
C23547 _053_ clkbuf_4_9_0_clk/a_27_118# 0
C23548 _555_/a_474_130# net49 0
C23549 _178_ _701_/a_324_432# 0
C23550 hold126/a_56_118# hold70/a_438_182# 0.00113f
C23551 hold171/a_438_182# tx_inst.data_reg\[4\] 0.00193f
C23552 net39 _513_/a_192_429# 0.00982f
C23553 VPWR FILLER_19_228/a_40_246# 0.13781f
C23554 FILLER_12_46/a_32_246# _097_ 0.00781f
C23555 baud_inst.counter\[28\] _180_ 0.00537f
C23556 _659_/a_843_236# clknet_4_4_0_clk 0.01171f
C23557 _424_/a_244_412# _238_ 0.00127f
C23558 _099_ _685_/a_1489_191# 0
C23559 VPWR rx_inst.state\[4\] 0.27423f
C23560 _691_/a_298_337# net104 0.00609f
C23561 _649_/a_2250_412# rx_inst.data_reg\[6\] 0.00258f
C23562 clknet_4_12_0_clk FILLER_20_177/a_32_246# 0
C23563 clknet_4_4_0_clk net43 0.16365f
C23564 hold173/a_326_118# clknet_4_4_0_clk 0.00205f
C23565 _639_/a_843_236# _266_ 0
C23566 _639_/a_681_505# net30 0
C23567 hold148/a_326_118# net147 0.00946f
C23568 _672_/a_132_114# net60 0
C23569 VPWR net119 0.05527f
C23570 hold148/a_326_118# net46 0
C23571 _698_/a_1583_191# _698_/a_2250_412# -0
C23572 baud_inst.counter\[26\] FILLER_22_86/a_32_246# 0.01344f
C23573 _650_/a_298_337# _140_ 0
C23574 _313_ _700_/a_741_93# 0
C23575 _637_/a_843_236# _048_ 0.00161f
C23576 _637_/a_741_93# net72 0
C23577 net37 net49 0.22616f
C23578 _342_/a_170_412# VPWR 0
C23579 net55 net21 0.23301f
C23580 _695_/a_2250_412# clknet_4_10_0_clk 0
C23581 hold177/a_326_118# _163_ 0
C23582 baud_inst.counter\[16\] _522_/a_209_168# 0.03935f
C23583 _640_/a_612_127# net45 0
C23584 tx_inst.state\[4\] _666_/a_324_432# 0
C23585 _542_/a_155_412# _687_/a_1583_191# 0
C23586 _118_ _705_/a_298_337# 0.03653f
C23587 _691_/a_38_114# net163 0.02441f
C23588 baud_inst.counter\[23\] _699_/a_38_114# 0
C23589 clknet_4_4_0_clk _664_/a_324_432# 0.02495f
C23590 clknet_0_clk _452_/a_257_140# 0
C23591 _474_/a_22_110# _273_ 0.06117f
C23592 _126_ _650_/a_1840_334# 0
C23593 clknet_4_10_0_clk net107 0
C23594 _677_/a_298_337# VPWR 0.00205f
C23595 _530_/a_155_412# _302_ 0.00375f
C23596 _649_/a_843_236# _648_/a_843_236# 0
C23597 _640_/a_2250_412# _224_ 0
C23598 _179_ baud_inst.counter\[29\] 0.05636f
C23599 hold166/a_326_118# rx_inst.state\[3\] 0.01875f
C23600 clknet_4_12_0_clk _434_/a_150_412# 0.00109f
C23601 _661_/a_2250_412# clk 0
C23602 _377_/a_268_412# net38 0
C23603 _068_ _653_/a_324_432# 0
C23604 _302_ _690_/a_843_236# 0
C23605 _164_ _690_/a_741_93# 0.00312f
C23606 _018_ _690_/a_38_114# 0.00468f
C23607 net49 _056_ 0.03953f
C23608 _034_ _280_ 0.40947f
C23609 _344_/a_150_412# baud_inst.counter\[25\] 0.00143f
C23610 fanout38/a_40_152# FILLER_8_14/a_32_246# 0.01048f
C23611 _121_ hold51/a_56_118# 0
C23612 hold106/a_56_118# _313_ 0
C23613 clkbuf_0_clk/a_116_82# net63 0.00321f
C23614 _696_/a_2250_412# VPWR 0.00214f
C23615 _680_/a_2002_114# clknet_4_0_0_clk 0
C23616 net102 baud_inst.counter\[17\] 0.02205f
C23617 _128_ FILLER_26_229/a_32_246# 0
C23618 net47 FILLER_29_198/a_40_246# 0.02977f
C23619 FILLER_19_178/a_40_246# _257_ 0
C23620 _688_/a_1840_334# _096_ 0
C23621 net94 net96 0.02633f
C23622 _289_ net38 0.00184f
C23623 VPWR _433_/a_244_412# 0.00178f
C23624 _691_/a_741_93# _104_ 0.00119f
C23625 _501_/a_154_118# net96 0
C23626 _064_ _063_ 0.00935f
C23627 net74 hold84/a_326_118# 0
C23628 net175 hold180/a_438_182# 0
C23629 _646_/a_298_337# _057_ 0.00608f
C23630 _076_ _664_/a_843_236# 0
C23631 _283_ baud_inst.counter\[11\] 0
C23632 _677_/a_38_114# hold93/a_56_118# 0
C23633 _678_/a_324_432# FILLER_8_92/a_32_246# 0
C23634 net157 net40 0
C23635 net2 _650_/a_324_432# 0
C23636 _267_ clknet_4_15_0_clk 0.0921f
C23637 _206_ _380_/a_59_156# 0.04111f
C23638 _198_ _664_/a_298_337# 0.0011f
C23639 VPWR _547_/a_379_118# 0
C23640 net54 _656_/a_1583_191# 0
C23641 _286_ _096_ 0
C23642 _706_/a_2250_412# VPWR 0.00772f
C23643 _680_/a_1583_191# clknet_4_0_0_clk 0.03507f
C23644 net100 _111_ 0.05714f
C23645 hold122/a_326_118# _667_/a_1489_191# 0
C23646 _041_ _667_/a_2250_412# 0.03583f
C23647 _159_ _255_ 0.06182f
C23648 net111 _473_/a_120_432# 0.00236f
C23649 _069_ input5/a_40_152# 0
C23650 FILLER_15_67/a_40_246# baud_inst.counter\[12\] 0.00819f
C23651 _045_ _633_/a_1583_191# 0.00654f
C23652 _517_/a_209_168# baud_inst.counter\[15\] 0.02144f
C23653 net49 _134_ 0.07016f
C23654 net55 _211_ 0.02982f
C23655 tx_data[3] net38 0
C23656 hold136/a_56_118# _181_ 0
C23657 clkbuf_4_0_0_clk/a_27_118# net181 0.01709f
C23658 _169_ _667_/a_1840_334# 0.00431f
C23659 _662_/a_843_236# _206_ 0
C23660 clknet_0_clk _386_/a_382_118# 0.01727f
C23661 net39 _184_ 0
C23662 _099_ _686_/a_741_93# 0.00276f
C23663 net46 _686_/a_843_236# 0.04061f
C23664 hold165/a_438_182# _658_/a_2250_412# 0
C23665 _254_ _253_ 0.01221f
C23666 _256_ _251_ 0.00965f
C23667 _699_/a_38_114# net114 0.05096f
C23668 _023_ VPWR 0.06239f
C23669 _697_/a_2250_412# _262_ 0
C23670 rx_inst.data_reg\[2\] _055_ 0.00263f
C23671 net32 _154_ 0.05046f
C23672 _638_/a_38_114# _264_ 0.00735f
C23673 hold160/a_326_118# _688_/a_1583_191# 0
C23674 FILLER_15_67/a_40_246# net88 0
C23675 net51 hold80/a_56_118# 0
C23676 _428_/a_252_412# _244_ 0.00191f
C23677 _266_ rx_inst.state\[4\] 0.00224f
C23678 fanout47/a_40_152# net47 0.00265f
C23679 hold65/a_326_118# clknet_4_15_0_clk 0.06951f
C23680 hold127/a_438_182# _139_ 0
C23681 hold161/a_326_118# net158 0.00171f
C23682 _098_ net91 0.006f
C23683 baud_inst.counter\[27\] _024_ 0
C23684 rx_data[5] hold71/a_438_182# 0
C23685 _671_/a_843_236# net62 0.01229f
C23686 _671_/a_741_93# _168_ 0.01472f
C23687 _294_ _297_ 0.1222f
C23688 clknet_0_clk _685_/a_2250_412# 0.01602f
C23689 net119 _266_ 0
C23690 _691_/a_1489_191# hold163/a_326_118# 0
C23691 _691_/a_2250_412# baud_inst.counter\[20\] 0
C23692 clknet_0_clk _666_/a_2002_114# 0
C23693 _011_ _296_ 0
C23694 _034_ _191_ 0.01423f
C23695 net2 FILLER_14_164/a_32_246# 0.00157f
C23696 _651_/a_1840_334# clknet_4_6_0_clk 0.00418f
C23697 _167_ rx_inst.state\[4\] 0
C23698 _495_/a_154_118# _287_ 0
C23699 _094_ clknet_4_0_0_clk 0.01554f
C23700 net28 net51 0.15595f
C23701 net44 _018_ 0.0056f
C23702 net119 _167_ 0.0024f
C23703 _135_ FILLER_26_151/a_32_246# 0.00978f
C23704 FILLER_2_14/a_40_246# net38 0.0223f
C23705 baud_inst.counter\[8\] hold117/a_56_118# 0
C23706 _298_ net40 0.00431f
C23707 hold101/a_438_182# hold157/a_326_118# 0.00196f
C23708 net26 _405_/a_27_156# 0.04365f
C23709 _447_/a_81_118# clknet_0_clk 0
C23710 _679_/a_38_114# VPWR 0
C23711 _044_ _272_ 0
C23712 net133 net68 0.00264f
C23713 _644_/a_324_432# _056_ 0
C23714 net15 _635_/a_1840_334# 0
C23715 _217_ _651_/a_2250_412# 0
C23716 baud_inst.counter\[14\] _685_/a_843_236# 0
C23717 baud_inst.counter\[28\] hold68/a_56_118# 0
C23718 net49 _702_/a_324_432# 0
C23719 clk _392_/a_382_118# 0
C23720 _178_ net113 0
C23721 _284_ _676_/a_741_93# 0
C23722 hold101/a_56_118# net103 0
C23723 baud_inst.counter\[18\] _528_/a_379_118# 0.00368f
C23724 _640_/a_1840_334# net49 0
C23725 VPWR _701_/a_843_236# 0.00346f
C23726 _242_ _418_/a_46_156# 0.04913f
C23727 _510_/a_350_122# _182_ 0
C23728 hold176/a_56_118# VPWR 0.00703f
C23729 net55 FILLER_2_208/a_40_246# 0
C23730 FILLER_12_166/a_40_246# clknet_0_clk 0.0088f
C23731 net44 _697_/a_550_127# 0
C23732 _194_ _218_ 0.00157f
C23733 _188_ net40 0
C23734 net44 _642_/a_298_337# 0.00236f
C23735 _645_/a_38_114# _056_ 0.0137f
C23736 net156 _688_/a_550_127# 0
C23737 net32 fanout36/a_40_152# 0
C23738 net128 _163_ 0
C23739 _060_ _648_/a_550_127# 0
C23740 _215_ clknet_0_clk 0.06312f
C23741 FILLER_22_32/a_40_246# net46 0
C23742 _660_/a_38_114# FILLER_1_173/a_32_246# 0
C23743 _206_ input3/a_40_152# 0.0079f
C23744 hold103/a_56_118# _296_ 0
C23745 _661_/a_741_93# _148_ 0.00901f
C23746 net79 _489_/a_115_308# 0.00706f
C23747 clknet_4_1_0_clk _384_/a_496_118# 0
C23748 _109_ _545_/a_146_122# 0
C23749 net44 _686_/a_298_337# 0.00357f
C23750 _538_/a_81_118# baud_inst.counter\[21\] 0.03184f
C23751 _550_/a_209_168# _701_/a_1840_334# 0
C23752 hold146/a_326_118# clknet_0_clk 0.00257f
C23753 _167_ _433_/a_244_412# 0.02246f
C23754 _693_/a_2002_114# VPWR 0.00129f
C23755 _377_/a_46_156# _655_/a_843_236# 0
C23756 net55 _655_/a_298_337# 0
C23757 hold165/a_56_118# _656_/a_1489_191# 0
C23758 net99 _308_ 0.05558f
C23759 _644_/a_324_432# _134_ 0
C23760 hold140/a_56_118# _641_/a_38_114# 0.0122f
C23761 baud_inst.counter\[27\] _695_/a_843_236# 0
C23762 _344_/a_150_412# baud_inst.counter\[24\] 0.00771f
C23763 net117 baud_inst.counter\[9\] 0.00684f
C23764 hold172/a_56_118# net22 0
C23765 _170_ _423_/a_165_412# 0
C23766 _223_ _436_/a_550_140# 0
C23767 _697_/a_612_127# clknet_0_clk 0.00263f
C23768 net108 _290_ 0.02219f
C23769 _163_ _014_ 0
C23770 _180_ hold91/a_56_118# 0.03135f
C23771 tx_inst.data_reg\[6\] net34 0
C23772 _663_/a_324_432# net26 0.00205f
C23773 net182 hold154/a_326_118# 0
C23774 hold140/a_438_182# hold99/a_438_182# 0
C23775 tx_done _707_/a_1489_191# 0
C23776 net26 _372_/a_22_110# 0.02435f
C23777 hold181/a_438_182# net38 0.02221f
C23778 _053_ _669_/a_1583_191# 0
C23779 net43 _666_/a_1583_191# 0.00101f
C23780 hold63/a_326_118# net43 0
C23781 net26 _417_/a_120_432# 0.00406f
C23782 clknet_4_14_0_clk _428_/a_252_412# 0
C23783 _641_/a_1840_334# _263_ 0
C23784 _092_ hold95/a_326_118# 0
C23785 output16/a_40_152# net16 0.02839f
C23786 _424_/a_550_140# _139_ 0
C23787 VPWR net168 0.91807f
C23788 baud_inst.counter\[5\] baud_inst.counter\[4\] 0.21946f
C23789 _138_ _244_ 0.02879f
C23790 _170_ hold144/a_438_182# 0
C23791 _651_/a_1840_334# net29 0
C23792 _704_/a_1840_334# _121_ 0
C23793 tx_inst.bit_index\[1\] _657_/a_1785_429# 0
C23794 net31 fanout35/a_40_152# 0.04868f
C23795 _089_ net40 0.01896f
C23796 _228_ _449_/a_27_156# 0
C23797 _302_ _692_/a_324_432# 0.00584f
C23798 _653_/a_2250_412# FILLER_10_145/a_40_246# 0
C23799 net55 _654_/a_1583_191# 0.02253f
C23800 _533_/a_248_122# net164 0
C23801 _646_/a_2250_412# _122_ 0
C23802 _232_ _244_ 0.00667f
C23803 _230_ _640_/a_324_432# 0
C23804 FILLER_22_133/a_40_246# _425_/a_46_156# 0.01393f
C23805 net147 _692_/a_1489_191# 0
C23806 hold175/a_56_118# _641_/a_2250_412# 0.00115f
C23807 baud_inst.counter\[8\] hold115/a_326_118# 0.01017f
C23808 net42 _651_/a_843_236# 0
C23809 FILLER_25_198/a_32_246# _154_ 0
C23810 _637_/a_1489_191# hold82/a_56_118# 0
C23811 _292_ hold91/a_326_118# 0
C23812 _178_ _701_/a_2250_412# 0
C23813 _662_/a_324_432# _203_ 0
C23814 net6 _655_/a_324_432# 0
C23815 net153 _351_/a_46_156# 0.07429f
C23816 tx_busy _707_/a_324_432# 0.00775f
C23817 _307_ clknet_4_8_0_clk 0
C23818 hold125/a_56_118# _264_ 0
C23819 _098_ hold153/a_326_118# 0
C23820 hold178/a_56_118# _189_ 0
C23821 net177 _519_/a_81_118# 0.10275f
C23822 _659_/a_612_127# clknet_4_4_0_clk 0
C23823 net48 _168_ 0.02107f
C23824 _206_ _657_/a_38_114# 0.00142f
C23825 net11 _665_/a_741_93# 0
C23826 _215_ _666_/a_1489_191# 0
C23827 _198_ FILLER_7_210/a_40_246# 0
C23828 _691_/a_612_127# hold104/a_438_182# 0
C23829 FILLER_23_204/a_40_246# _264_ 0.01413f
C23830 _672_/a_1489_191# net60 0
C23831 _004_ _204_ 0.00765f
C23832 hold78/a_56_118# rx_data[1] 0.06697f
C23833 net116 _681_/a_324_432# 0.00413f
C23834 _288_ _681_/a_741_93# 0.00404f
C23835 _634_/a_298_337# rx_inst.data_reg\[5\] 0
C23836 _637_/a_612_127# _048_ 0.00483f
C23837 _248_ fanout32/a_40_152# 0
C23838 baud_inst.counter\[16\] _296_ 4.30842f
C23839 _173_ tx_inst.bit_index\[2\] 0.01719f
C23840 _412_/a_22_110# fanout43/a_40_152# 0
C23841 _045_ net14 0.01437f
C23842 hold55/a_438_182# VPWR 0.00474f
C23843 tx_inst.state\[4\] _666_/a_2250_412# 0.00583f
C23844 output22/a_40_152# net21 0
C23845 baud_inst.counter\[24\] _687_/a_2250_412# 0
C23846 _309_ _687_/a_1583_191# 0
C23847 _641_/a_324_432# hold176/a_326_118# 0.00102f
C23848 net41 _653_/a_612_127# 0
C23849 _118_ _705_/a_1583_191# 0.00132f
C23850 _046_ _264_ 0.01549f
C23851 _691_/a_132_114# _020_ 0
C23852 _691_/a_1840_334# net163 0.00378f
C23853 hold148/a_56_118# FILLER_22_22/a_32_246# 0.00404f
C23854 _430_/a_170_412# rx_inst.bit_index\[1\] 0.00176f
C23855 _656_/a_843_236# tx_inst.data_reg\[0\] 0
C23856 _216_ _402_/a_154_118# 0.00234f
C23857 _646_/a_1840_334# net111 0
C23858 net55 _391_/a_268_412# 0
C23859 clknet_4_4_0_clk _664_/a_2250_412# 0
C23860 FILLER_9_79/a_32_246# _185_ 0.01921f
C23861 _343_/a_155_412# _176_ 0.01281f
C23862 _412_/a_120_432# net2 0
C23863 _643_/a_38_114# _264_ 0.00168f
C23864 hold130/a_438_182# _685_/a_38_114# 0
C23865 hold74/a_56_118# rx_inst.data_reg\[7\] 0
C23866 hold124/a_56_118# rx_inst.data_reg\[6\] 0
C23867 net79 _490_/a_45_160# 0
C23868 _677_/a_1583_191# VPWR 0.00627f
C23869 _302_ _018_ 0.05345f
C23870 _649_/a_1840_334# _648_/a_1583_191# 0
C23871 net94 hold135/a_438_182# 0
C23872 _169_ FILLER_14_164/a_32_246# 0.00102f
C23873 clknet_4_5_0_clk net55 0.12024f
C23874 _002_ VPWR 0.05412f
C23875 _640_/a_843_236# _051_ 0.00175f
C23876 baud_inst.counter\[27\] baud_inst.counter\[25\] 0.01628f
C23877 _177_ net99 0
C23878 VPWR _146_ 0.15204f
C23879 _686_/a_843_236# _685_/a_741_93# 0
C23880 _686_/a_741_93# _685_/a_843_236# 0
C23881 _690_/a_324_432# _103_ 0.01448f
C23882 _690_/a_298_337# clknet_4_8_0_clk 0.00164f
C23883 net180 net25 0
C23884 _045_ _637_/a_741_93# 0
C23885 net47 rx_inst.data_reg\[5\] 0.05561f
C23886 net46 _347_/a_146_122# 0
C23887 _646_/a_2250_412# rx_inst.data_reg\[4\] 0
C23888 hold168/a_56_118# _171_ 0
C23889 net179 net172 0.10864f
C23890 baud_inst.counter\[13\] hold90/a_326_118# 0
C23891 hold160/a_326_118# _101_ 0.00156f
C23892 _112_ net49 0
C23893 _076_ _664_/a_612_127# 0.00349f
C23894 _286_ baud_inst.counter\[7\] 0
C23895 hold146/a_56_118# _215_ 0.00592f
C23896 net109 _508_/a_177_436# 0
C23897 _646_/a_1583_191# _057_ 0
C23898 _276_ _480_/a_120_432# 0
C23899 net26 _480_/a_22_110# 0.02373f
C23900 net2 _650_/a_2250_412# 0
C23901 net44 _692_/a_2250_412# 0.01047f
C23902 _198_ _664_/a_1583_191# 0
C23903 hold101/a_326_118# net40 0
C23904 clknet_4_14_0_clk _138_ 0.34311f
C23905 _661_/a_298_337# _072_ 0.00725f
C23906 net135 net38 0.43084f
C23907 clknet_4_14_0_clk _232_ 0.05028f
C23908 net111 _273_ 0.00713f
C23909 _351_/a_46_156# _280_ 0.00785f
C23910 net105 _700_/a_38_114# 0
C23911 hold168/a_438_182# _192_ 0.00172f
C23912 net177 hold177/a_326_118# 0.00238f
C23913 _315_ hold106/a_326_118# 0.02917f
C23914 net45 _693_/a_132_114# 0
C23915 _291_ clknet_0_clk 0
C23916 _656_/a_298_337# VPWR 0.00419f
C23917 _680_/a_298_337# _093_ 0.03231f
C23918 _178_ hold75/a_56_118# 0.00138f
C23919 hold126/a_438_182# rx_inst.data_reg\[5\] 0
C23920 FILLER_24_156/a_32_246# _254_ 0.00158f
C23921 _680_/a_324_432# baud_inst.counter\[10\] 0
C23922 net2 _456_/a_155_412# 0
C23923 _697_/a_741_93# net142 0
C23924 _697_/a_843_236# _110_ 0.04633f
C23925 fanout36/a_40_152# FILLER_25_150/a_32_246# 0
C23926 net46 _686_/a_612_127# 0.02259f
C23927 _699_/a_1840_334# net114 0
C23928 _638_/a_1840_334# _264_ 0
C23929 _446_/a_146_122# _258_ 0
C23930 hold160/a_438_182# _688_/a_1489_191# 0
C23931 _016_ _522_/a_209_168# 0.00138f
C23932 net157 _522_/a_380_412# 0
C23933 _525_/a_46_156# net160 0
C23934 _299_ _522_/a_177_436# 0
C23935 _642_/a_741_93# _131_ 0.00193f
C23936 rx_data[0] _632_/a_1840_334# 0
C23937 hold116/a_56_118# net97 0
C23938 _043_ _264_ 0.13067f
C23939 baud_inst.counter\[26\] _180_ 0.01612f
C23940 hold142/a_438_182# hold100/a_326_118# 0.00209f
C23941 hold142/a_326_118# hold100/a_438_182# 0
C23942 clknet_4_5_0_clk _076_ 0.06952f
C23943 hold110/a_56_118# VPWR 0.0541f
C23944 _078_ _666_/a_38_114# 0.01755f
C23945 _671_/a_612_127# net62 0
C23946 _057_ net64 0
C23947 _186_ _683_/a_38_114# 0
C23948 _184_ _683_/a_843_236# 0
C23949 hold183/a_438_182# VPWR 0.00396f
C23950 _508_/a_380_412# _096_ 0.00923f
C23951 hold169/a_56_118# net27 0.00729f
C23952 output19/a_40_152# net19 0.03104f
C23953 hold118/a_326_118# _047_ 0
C23954 _432_/a_350_122# _241_ 0
C23955 _695_/a_324_432# VPWR 0.00573f
C23956 _510_/a_248_122# _291_ -0
C23957 _270_ _635_/a_132_114# 0
C23958 net70 rx_inst.data_reg\[5\] 0
C23959 _024_ _541_/a_380_412# 0.02575f
C23960 hold85/a_326_118# _125_ 0
C23961 hold85/a_438_182# _270_ 0.00512f
C23962 _679_/a_1840_334# VPWR 0.00148f
C23963 net81 VPWR 0.17076f
C23964 _061_ _647_/a_612_127# 0
C23965 hold141/a_326_118# _546_/a_192_429# 0
C23966 _227_ _224_ 0
C23967 _073_ _665_/a_681_505# 0
C23968 _040_ _665_/a_741_93# 0.00149f
C23969 _658_/a_324_432# tx_inst.data_reg\[1\] 0
C23970 _293_ _685_/a_298_337# 0
C23971 net49 _702_/a_2250_412# 0
C23972 _663_/a_324_432# net50 0
C23973 _265_ _668_/a_1840_334# 0
C23974 _129_ _668_/a_1583_191# 0
C23975 net113 net162 0
C23976 rx_inst.data_reg\[1\] _472_/a_22_110# 0
C23977 _272_ _648_/a_38_114# 0
C23978 net77 _648_/a_324_432# 0
C23979 _231_ clk 0.00556f
C23980 baud_inst.counter\[18\] _301_ 0.22838f
C23981 _291_ _182_ 0.00626f
C23982 hold101/a_56_118# net101 0.00113f
C23983 FILLER_20_65/a_32_246# net140 0.00393f
C23984 _191_ _351_/a_46_156# 0
C23985 clknet_0_clk _664_/a_741_93# 0
C23986 hold132/a_56_118# _232_ 0.00166f
C23987 _006_ _665_/a_741_93# 0
C23988 _275_ _665_/a_843_236# 0.00661f
C23989 _397_/a_279_412# _219_ 0
C23990 net44 _642_/a_1583_191# 0
C23991 _082_ _642_/a_132_114# 0
C23992 _645_/a_1840_334# _056_ 0
C23993 clkbuf_4_12_0_clk/a_27_118# net49 0
C23994 hold166/a_326_118# _205_ 0
C23995 _295_ _684_/a_741_93# 0.00262f
C23996 _224_ hold62/a_438_182# 0
C23997 hold64/a_438_182# FILLER_21_229/a_32_246# 0.00985f
C23998 hold171/a_56_118# _212_ 0.00513f
C23999 _275_ _166_ 0.00136f
C24000 FILLER_24_229/a_32_246# _638_/a_1583_191# 0
C24001 _178_ baud_inst.counter\[29\] 0
C24002 hold143/a_326_118# _240_ 0.0032f
C24003 FILLER_1_30/a_32_246# _675_/a_741_93# 0.00112f
C24004 _346_/a_150_412# _316_ 0
C24005 _661_/a_1785_429# _148_ 0.00185f
C24006 tx_inst.data_reg\[7\] _384_/a_382_118# 0
C24007 _307_ _687_/a_324_432# 0.00121f
C24008 hold148/a_56_118# _692_/a_741_93# 0
C24009 _658_/a_2250_412# tx_inst.data_reg\[0\] 0
C24010 net44 _686_/a_1583_191# 0.00378f
C24011 _538_/a_379_118# _306_ 0
C24012 net2 FILLER_13_228/a_40_246# 0.00432f
C24013 net55 _655_/a_1583_191# 0.04409f
C24014 hold165/a_326_118# clknet_4_4_0_clk 0.04702f
C24015 hold165/a_56_118# tx_inst.data_reg\[2\] 0.03278f
C24016 net43 _386_/a_382_118# 0.00126f
C24017 _483_/a_120_432# VPWR 0
C24018 hold59/a_56_118# _702_/a_843_236# 0
C24019 _644_/a_1489_191# _159_ 0.00338f
C24020 hold59/a_326_118# _702_/a_741_93# 0
C24021 _346_/a_252_412# _313_ 0.003f
C24022 _177_ _695_/a_2250_412# 0
C24023 baud_inst.counter\[26\] _695_/a_1785_429# 0
C24024 hold120/a_438_182# _302_ 0.00827f
C24025 rx_inst.state\[2\] _641_/a_843_236# 0
C24026 baud_inst.counter\[26\] net140 0.15869f
C24027 baud_inst.counter\[27\] baud_inst.counter\[24\] 0.14483f
C24028 _685_/a_132_114# net130 0
C24029 _685_/a_681_505# clknet_4_9_0_clk 0
C24030 _636_/a_324_432# hold81/a_56_118# 0
C24031 _170_ _241_ 0.13729f
C24032 _223_ _249_ 0.03135f
C24033 _156_ _647_/a_843_236# 0.00119f
C24034 _170_ FILLER_25_163/a_32_246# 0
C24035 net142 clknet_0_clk 0.00696f
C24036 _216_ _222_ 0.16881f
C24037 net2 _639_/a_324_432# 0.02026f
C24038 _642_/a_132_114# clknet_0_clk 0
C24039 net2 _425_/a_46_156# 0
C24040 _315_ _314_ 0.68428f
C24041 _292_ FILLER_8_63/a_40_246# 0
C24042 FILLER_16_56/a_32_246# _296_ 0.00456f
C24043 _689_/a_132_114# net158 0
C24044 _356_/a_146_122# _296_ 0
C24045 _671_/a_132_114# clknet_0_clk 0
C24046 _170_ net47 0
C24047 _062_ _651_/a_324_432# 0.02982f
C24048 _704_/a_38_114# net43 0.00392f
C24049 _684_/a_741_93# clknet_4_2_0_clk 0.03175f
C24050 _132_ _669_/a_1489_191# 0
C24051 net26 _140_ 0.07789f
C24052 _645_/a_550_127# _159_ 0
C24053 _155_ hold127/a_56_118# 0
C24054 _206_ FILLER_0_115/a_40_246# 0.00496f
C24055 hold159/a_438_182# net41 0
C24056 _689_/a_741_93# _688_/a_298_337# 0.0011f
C24057 tx_inst.bit_index\[1\] _068_ 0.00279f
C24058 clknet_0_clk _686_/a_132_114# 0
C24059 rx_data[3] hold84/a_438_182# 0
C24060 net34 net183 0.36865f
C24061 net32 _140_ 0.00887f
C24062 rx_inst.state\[2\] _260_ 0.03214f
C24063 net55 _654_/a_2002_114# 0
C24064 _230_ _640_/a_2250_412# 0.00226f
C24065 net49 _693_/a_741_93# 0.00734f
C24066 VPWR net99 0.15485f
C24067 _304_ clknet_4_10_0_clk 0.00123f
C24068 _360_/a_1453_124# _174_ 0.00152f
C24069 output21/a_40_152# net146 0
C24070 _240_ _249_ 0
C24071 baud_inst.counter\[13\] _670_/a_132_114# 0
C24072 VPWR _669_/a_298_337# 0.00352f
C24073 net17 hold82/a_56_118# 0
C24074 input7/a_40_152# tx_data[7] 0.00576f
C24075 _538_/a_81_118# _301_ 0
C24076 _707_/a_324_432# _704_/a_741_93# 0
C24077 _707_/a_741_93# _704_/a_324_432# 0
C24078 hold131/a_438_182# _244_ 0
C24079 _551_/a_272_160# _314_ 0
C24080 hold159/a_56_118# _068_ 0
C24081 FILLER_7_121/a_40_246# net137 0.02755f
C24082 fanout30/a_40_152# _137_ 0
C24083 net71 clknet_4_15_0_clk 0.02525f
C24084 net6 _655_/a_2250_412# 0.05574f
C24085 tx_busy _707_/a_2250_412# 0.00658f
C24086 tx_data[5] net38 0
C24087 _090_ clkbuf_4_1_0_clk/a_27_118# 0
C24088 net177 net128 0.01069f
C24089 baud_inst.counter\[14\] _686_/a_38_114# 0.0061f
C24090 baud_inst.counter\[15\] _686_/a_324_432# 0
C24091 net44 hold164/a_438_182# 0
C24092 _676_/a_1583_191# _652_/a_38_114# 0
C24093 baud_inst.counter\[0\] net60 0
C24094 _658_/a_681_505# VPWR 0
C24095 clknet_4_0_0_clk _181_ 0.99845f
C24096 _283_ _287_ 0
C24097 FILLER_12_166/a_40_246# net43 0
C24098 net26 net49 0.06335f
C24099 _305_ net45 0.01669f
C24100 clknet_4_13_0_clk net30 2.81504f
C24101 _046_ _269_ 0
C24102 net116 _681_/a_2250_412# 0.00217f
C24103 _039_ _681_/a_1840_334# 0
C24104 _118_ net33 0
C24105 _519_/a_81_118# _188_ 0
C24106 clkbuf_4_9_0_clk/a_27_118# VPWR 0.07461f
C24107 _109_ _180_ 0.03991f
C24108 _048_ net72 0.03147f
C24109 rx_inst.bit_index\[2\] net52 0
C24110 clk _706_/a_1583_191# 0
C24111 tx_inst.bit_index\[2\] _397_/a_279_412# 0.00227f
C24112 net32 net49 0.04688f
C24113 hold75/a_438_182# VPWR 0.00608f
C24114 net71 _158_ 0
C24115 _678_/a_324_432# FILLER_5_84/a_40_246# 0
C24116 _023_ FILLER_22_43/a_40_246# 0.03082f
C24117 baud_inst.counter\[22\] _694_/a_843_236# 0.01984f
C24118 _116_ net45 0
C24119 baud_inst.counter\[21\] _694_/a_1583_191# 0.00225f
C24120 _017_ _101_ 0
C24121 net36 _251_ 0
C24122 hold53/a_438_182# _130_ 0.0025f
C24123 _360_/a_71_118# net165 0
C24124 _656_/a_612_127# tx_inst.data_reg\[0\] 0
C24125 tx_inst.state\[1\] FILLER_10_222/a_32_246# 0.02768f
C24126 baud_inst.counter\[4\] clknet_0_clk 0.16868f
C24127 _697_/a_1583_191# clknet_4_9_0_clk 0.00278f
C24128 hold92/a_438_182# net40 0.00133f
C24129 hold69/a_438_182# _638_/a_1840_334# 0.00197f
C24130 hold146/a_326_118# net43 0.00192f
C24131 hold130/a_438_182# _182_ 0
C24132 _535_/a_350_122# net49 0
C24133 hold66/a_56_118# _632_/a_741_93# 0
C24134 hold66/a_326_118# _632_/a_324_432# 0
C24135 _198_ FILLER_5_207/a_32_246# 0
C24136 _231_ net2 0.00143f
C24137 net148 _692_/a_298_337# 0.00115f
C24138 hold69/a_438_182# _043_ 0
C24139 _643_/a_1840_334# _264_ 0.01049f
C24140 tx_inst.data_reg\[6\] _656_/a_741_93# 0.00152f
C24141 _707_/a_741_93# net19 0.00216f
C24142 FILLER_19_75/a_40_246# _541_/a_209_168# 0.00303f
C24143 _091_ hold92/a_326_118# 0
C24144 VPWR FILLER_14_148/a_40_246# 0.1347f
C24145 _024_ clkbuf_4_8_0_clk/a_27_118# 0
C24146 net30 net65 0.07163f
C24147 _640_/a_612_127# _051_ 0
C24148 net27 _665_/a_324_432# 0
C24149 _164_ _103_ 0.04434f
C24150 rx_data[7] _636_/a_741_93# 0
C24151 _498_/a_279_412# clknet_0_clk 0
C24152 _690_/a_1583_191# clknet_4_8_0_clk 0.00315f
C24153 baud_inst.counter\[30\] net46 0
C24154 hold139/a_438_182# _241_ 0
C24155 hold121/a_56_118# FILLER_21_31/a_40_246# 0.00786f
C24156 net71 _637_/a_324_432# 0.0018f
C24157 net124 net83 0
C24158 net45 _701_/a_741_93# 0.02746f
C24159 _126_ net73 0
C24160 hold87/a_56_118# _696_/a_298_337# 0
C24161 net13 _633_/a_38_114# 0
C24162 output13/a_40_152# _633_/a_843_236# 0
C24163 net8 _383_/a_46_156# 0
C24164 _242_ _224_ 0.81038f
C24165 net27 _084_ 0
C24166 VPWR _434_/a_354_412# -0
C24167 _503_/a_165_412# net29 0.00596f
C24168 _076_ _005_ 0.09924f
C24169 _646_/a_2002_114# _057_ 0
C24170 _632_/a_843_236# FILLER_21_229/a_32_246# 0.00105f
C24171 VPWR _506_/a_155_412# 0.05803f
C24172 net145 _657_/a_38_114# 0
C24173 _707_/a_741_93# hold51/a_326_118# 0.00141f
C24174 _707_/a_843_236# hold51/a_56_118# 0
C24175 _214_ clknet_4_4_0_clk 0
C24176 net44 _687_/a_38_114# 0.01146f
C24177 clknet_4_6_0_clk _668_/a_741_93# 0.03366f
C24178 _411_/a_494_160# net26 0
C24179 input9/a_40_152# net165 0
C24180 clknet_4_0_0_clk _088_ 0.02627f
C24181 _132_ net46 0
C24182 net124 _649_/a_1489_191# 0
C24183 net184 _379_/a_268_412# 0
C24184 _143_ tx_inst.data_reg\[5\] 0.2349f
C24185 _227_ _411_/a_358_436# 0.00698f
C24186 _109_ net140 0
C24187 baud_inst.counter\[20\] net49 0.39088f
C24188 hold183/a_326_118# _400_/a_341_118# 0
C24189 _292_ VPWR 0.66753f
C24190 _641_/a_38_114# baud_inst.counter\[25\] 0.0234f
C24191 _656_/a_1583_191# VPWR 0.00885f
C24192 net55 _199_ 0.08697f
C24193 baud_inst.counter\[4\] _182_ 0.94292f
C24194 _470_/a_22_110# _648_/a_2250_412# 0
C24195 hold131/a_438_182# clknet_4_14_0_clk 0.00158f
C24196 _549_/a_155_412# _311_ 0.00196f
C24197 hold169/a_438_182# net26 0.00134f
C24198 hold164/a_326_118# _692_/a_298_337# 0
C24199 hold164/a_56_118# _692_/a_38_114# 0
C24200 hold66/a_56_118# FILLER_21_229/a_32_246# 0.00404f
C24201 _672_/a_298_337# net61 0
C24202 _672_/a_132_114# hold61/a_56_118# 0
C24203 _672_/a_38_114# _033_ 0.0517f
C24204 clknet_4_4_0_clk FILLER_3_177/a_32_246# 0
C24205 hold158/a_326_118# net158 0.02778f
C24206 baud_inst.counter\[28\] _554_/a_248_122# 0.00179f
C24207 baud_inst.counter\[31\] _554_/a_146_122# 0.00148f
C24208 _073_ _206_ 0.04169f
C24209 net2 _264_ 0
C24210 rx_inst.state\[2\] _486_/a_494_160# 0
C24211 _697_/a_612_127# _110_ 0.00985f
C24212 _248_ _433_/a_142_412# 0.00623f
C24213 _123_ net77 0.00132f
C24214 _237_ FILLER_25_163/a_32_246# 0
C24215 _226_ _260_ 0.332f
C24216 net12 _632_/a_1583_191# 0.01386f
C24217 net54 _198_ 0
C24218 _642_/a_1785_429# _131_ 0
C24219 _114_ hold107/a_326_118# 0
C24220 hold143/a_438_182# clknet_0_clk 0.06058f
C24221 _661_/a_741_93# _151_ 0
C24222 _661_/a_681_505# net155 0
C24223 _016_ _296_ 0
C24224 _299_ _015_ 0
C24225 _457_/a_22_110# hold81/a_438_182# 0
C24226 _644_/a_741_93# _170_ 0
C24227 _498_/a_279_412# _182_ 0
C24228 hold103/a_326_118# net163 0
C24229 net82 rx_data[5] 0
C24230 VPWR _382_/a_59_156# 0.06019f
C24231 _079_ _374_/a_244_412# 0
C24232 clknet_4_4_0_clk FILLER_3_150/a_40_246# 0
C24233 rx_data[7] hold81/a_326_118# 0
C24234 _078_ _666_/a_1840_334# -0
C24235 hold141/a_326_118# clknet_4_8_0_clk 0
C24236 _184_ _683_/a_612_127# 0
C24237 _186_ _683_/a_1840_334# 0.0375f
C24238 _191_ net62 0
C24239 _314_ hold106/a_438_182# 0.00912f
C24240 net48 _636_/a_38_114# 0
C24241 _674_/a_741_93# _030_ 0.00355f
C24242 _695_/a_2250_412# VPWR 0.0072f
C24243 FILLER_16_70/a_40_246# _296_ 0
C24244 _013_ net130 0.00409f
C24245 rx_inst.data_reg\[4\] _647_/a_38_114# 0
C24246 net124 _470_/a_22_110# 0
C24247 _645_/a_324_432# _170_ 0
C24248 hold64/a_438_182# net66 0
C24249 _160_ _474_/a_22_110# 0.02762f
C24250 _040_ _665_/a_1785_429# 0
C24251 _094_ _093_ 0.00613f
C24252 baud_inst.counter\[14\] net130 0
C24253 baud_inst.counter\[15\] clknet_4_9_0_clk 0
C24254 FILLER_7_176/a_32_246# net169 0.01265f
C24255 net55 _390_/a_382_118# 0.03649f
C24256 _663_/a_2250_412# net50 0.00447f
C24257 _165_ _310_ 0
C24258 VPWR net107 0.02117f
C24259 hold164/a_326_118# _164_ 0
C24260 hold164/a_438_182# _302_ 0.00209f
C24261 _677_/a_2250_412# _652_/a_38_114# 0
C24262 net31 _435_/a_411_436# 0
C24263 net147 fanout44/a_40_152# 0
C24264 hold175/a_438_182# net49 0
C24265 _275_ _665_/a_612_127# 0
C24266 fanout44/a_40_152# net46 0.02994f
C24267 _339_/a_71_118# clknet_4_4_0_clk 0.04157f
C24268 clknet_0_clk _136_ 0.02666f
C24269 _680_/a_1840_334# net115 0
C24270 VPWR hold80/a_438_182# 0.00212f
C24271 hold154/a_438_182# _281_ 0.00963f
C24272 baud_inst.counter\[12\] _684_/a_1489_191# 0
C24273 _198_ _368_/a_155_412# 0.0053f
C24274 VPWR FILLER_17_131/a_32_246# 0.08669f
C24275 baud_inst.counter\[28\] hold114/a_56_118# 0.00699f
C24276 _001_ _666_/a_681_505# 0
C24277 _700_/a_1583_191# _700_/a_2250_412# 0
C24278 FILLER_7_82/a_32_246# _282_ 0
C24279 rx_inst.data_reg\[1\] _059_ 0
C24280 _072_ _148_ 0.02416f
C24281 hold108/a_438_182# _282_ 0
C24282 _270_ _650_/a_1583_191# 0
C24283 _114_ _694_/a_741_93# 0
C24284 hold77/a_56_118# VPWR 0.05017f
C24285 net45 hold105/a_438_182# 0.00161f
C24286 hold100/a_56_118# _025_ 0
C24287 hold100/a_326_118# _310_ 0
C24288 _013_ clknet_4_8_0_clk 0.0186f
C24289 net44 _686_/a_2002_114# 0
C24290 _126_ net118 0.00379f
C24291 net10 _655_/a_1489_191# 0
C24292 _377_/a_46_156# _145_ 0
C24293 net55 _655_/a_2002_114# 0.001f
C24294 _678_/a_38_114# net93 0.01618f
C24295 _118_ net23 0
C24296 _004_ VPWR 0.17544f
C24297 rx_inst.data_reg\[1\] _159_ 0.07619f
C24298 baud_inst.counter\[30\] _313_ 0.90155f
C24299 _536_/a_192_429# _106_ 0.00252f
C24300 _175_ clk 0
C24301 VPWR _381_/a_268_412# -0
C24302 hold109/a_326_118# net40 0
C24303 net51 _223_ 0.03263f
C24304 hold160/a_438_182# VPWR 0.0079f
C24305 net49 FILLER_25_150/a_32_246# 0.0016f
C24306 net49 _701_/a_298_337# 0.00285f
C24307 _170_ _649_/a_324_432# 0
C24308 clknet_4_8_0_clk baud_inst.counter\[14\] 0.03511f
C24309 _156_ _647_/a_612_127# 0.00202f
C24310 _433_/a_142_412# net139 0
C24311 net2 _639_/a_2250_412# 0.00646f
C24312 _642_/a_1489_191# clknet_0_clk 0.00101f
C24313 hold89/a_326_118# _296_ 0.01681f
C24314 _225_ _434_/a_354_412# 0.00297f
C24315 _390_/a_559_412# net6 0.00519f
C24316 _492_/a_170_412# _182_ 0
C24317 hold123/a_56_118# clknet_0_clk 0
C24318 _636_/a_324_432# _157_ 0
C24319 net35 _432_/a_350_122# 0.00191f
C24320 _152_ _665_/a_298_337# 0
C24321 _548_/a_272_160# _308_ 0
C24322 _663_/a_681_505# net168 0
C24323 _671_/a_1489_191# clknet_0_clk 0
C24324 baud_inst.counter\[13\] _296_ 0.01611f
C24325 _280_ _685_/a_741_93# 0
C24326 _309_ _541_/a_209_168# 0.00612f
C24327 baud_inst.counter\[24\] _541_/a_380_412# 0.005f
C24328 _170_ net112 0
C24329 _689_/a_1583_191# _688_/a_741_93# 0.00257f
C24330 clknet_0_clk _686_/a_1489_191# 0
C24331 net15 _264_ 0.05007f
C24332 _353_/a_248_122# _183_ 0.00179f
C24333 net43 _120_ 0.84087f
C24334 net51 _240_ 0
C24335 _206_ net41 0.18478f
C24336 clknet_4_6_0_clk _220_ 0.00304f
C24337 net49 _693_/a_1785_429# 0.00164f
C24338 clknet_4_12_0_clk _223_ 0.03801f
C24339 clk net165 0.11054f
C24340 _360_/a_1377_160# _174_ 0.0196f
C24341 net74 FILLER_16_221/a_32_246# 0.007f
C24342 baud_inst.counter\[13\] _670_/a_1489_191# 0
C24343 VPWR _669_/a_1583_191# 0.00623f
C24344 VPWR _633_/a_741_93# 0.02446f
C24345 _680_/a_2250_412# net96 0
C24346 _073_ _202_ 0.03105f
C24347 _090_ _063_ 0
C24348 _190_ _297_ 0
C24349 FILLER_18_65/a_40_246# _687_/a_1840_334# 0
C24350 FILLER_12_106/a_40_246# VPWR 0.14739f
C24351 _230_ _419_/a_154_118# 0
C24352 hold147/a_326_118# _105_ 0
C24353 _641_/a_324_432# net140 0
C24354 _673_/a_843_236# net95 0
C24355 hold63/a_326_118# net51 0.00499f
C24356 _704_/a_1489_191# net19 0
C24357 hold150/a_438_182# net150 0.02981f
C24358 hold116/a_56_118# net38 0
C24359 FILLER_8_171/a_32_246# _220_ 0
C24360 hold142/a_56_118# _696_/a_843_236# 0
C24361 _638_/a_843_236# _122_ 0
C24362 _218_ _220_ 0
C24363 _217_ _142_ 0.01433f
C24364 baud_inst.counter\[14\] _686_/a_1840_334# 0.01266f
C24365 baud_inst.counter\[15\] _686_/a_2250_412# 0
C24366 rx_inst.data_reg\[1\] _155_ 0
C24367 _390_/a_382_118# _389_/a_46_156# 0
C24368 _099_ hold91/a_326_118# 0.00142f
C24369 _273_ clknet_4_15_0_clk 0.1516f
C24370 _658_/a_550_127# VPWR 0
C24371 hold54/a_56_118# _706_/a_2250_412# 0
C24372 net42 _217_ 0.00685f
C24373 _690_/a_550_127# baud_inst.counter\[17\] 0
C24374 fanout35/a_40_152# _262_ 0
C24375 _644_/a_681_505# clknet_4_14_0_clk 0
C24376 baud_inst.counter\[12\] _187_ 0
C24377 net128 _188_ 0
C24378 hold52/a_326_118# _425_/a_46_156# 0
C24379 net37 net25 0.0602f
C24380 tx_inst.data_reg\[1\] _382_/a_285_118# 0
C24381 FILLER_16_176/a_40_246# _277_ 0
C24382 clknet_4_12_0_clk _240_ 0.63885f
C24383 _052_ hold176/a_56_118# 0
C24384 baud_inst.counter\[22\] _694_/a_612_127# 0
C24385 FILLER_0_117/a_32_246# _384_/a_59_156# 0.01108f
C24386 hold98/a_56_118# _681_/a_1583_191# 0
C24387 net26 _166_ 0.24659f
C24388 _228_ clk 0
C24389 net31 _438_/a_350_122# 0
C24390 hold104/a_56_118# FILLER_17_22/a_40_246# 0.00786f
C24391 clknet_4_13_0_clk _647_/a_2250_412# 0
C24392 net35 _170_ 0.00422f
C24393 hold129/a_326_118# fanout29/a_40_152# 0
C24394 hold128/a_56_118# _676_/a_38_114# 0
C24395 _642_/a_324_432# clknet_4_9_0_clk 0
C24396 _646_/a_298_337# clknet_0_clk 0.0129f
C24397 _045_ hold82/a_438_182# 0
C24398 _032_ _180_ 0
C24399 _678_/a_132_114# net40 0
C24400 _357_/a_150_412# _186_ 0
C24401 hold89/a_56_118# net88 0.00181f
C24402 _645_/a_843_236# clknet_4_14_0_clk 0.02485f
C24403 VPWR _455_/a_257_140# 0
C24404 net66 _632_/a_843_236# 0
C24405 hold86/a_56_118# _287_ 0
C24406 net100 _698_/a_741_93# 0.00723f
C24407 hold100/a_438_182# _698_/a_1583_191# 0
C24408 hold100/a_56_118# _698_/a_2250_412# 0
C24409 hold100/a_326_118# _698_/a_1840_334# 0
C24410 _021_ _692_/a_681_505# 0
C24411 tx_inst.data_reg\[6\] _656_/a_1785_429# 0
C24412 _707_/a_1785_429# net19 0
C24413 _187_ net88 0.06551f
C24414 _649_/a_2250_412# rx_inst.data_reg\[5\] 0
C24415 hold64/a_326_118# _635_/a_1583_191# 0.00234f
C24416 input3/a_40_152# tx_data[0] 0.03103f
C24417 baud_inst.counter\[1\] hold60/a_438_182# 0.01495f
C24418 _655_/a_1840_334# _213_ 0
C24419 hold174/a_326_118# net26 0.00478f
C24420 hold174/a_438_182# _171_ 0
C24421 _682_/a_324_432# baud_inst.counter\[9\] 0
C24422 _091_ _678_/a_681_505# 0
C24423 _191_ _685_/a_741_93# 0
C24424 _436_/a_142_412# _157_ 0.02233f
C24425 _241_ _433_/a_550_140# 0
C24426 hold85/a_56_118# rx_data[4] 0
C24427 hold85/a_326_118# net16 0
C24428 _242_ FILLER_23_158/a_40_246# 0
C24429 _695_/a_324_432# FILLER_22_43/a_40_246# 0
C24430 tx_inst.data_reg\[4\] hold165/a_56_118# 0
C24431 _361_/a_146_122# _197_ 0
C24432 FILLER_8_116/a_40_246# _386_/a_382_118# 0
C24433 _644_/a_324_432# FILLER_25_150/a_32_246# 0
C24434 _377_/a_268_412# VPWR 0
C24435 _686_/a_324_432# clknet_4_9_0_clk 0.03052f
C24436 hold77/a_326_118# net30 0.03945f
C24437 hold77/a_56_118# _266_ 0.01157f
C24438 _343_/a_155_412# _174_ 0
C24439 _343_/a_257_140# net34 0.0049f
C24440 net48 rx_data[7] 0.27074f
C24441 _045_ _048_ 0.70505f
C24442 baud_inst.counter\[4\] FILLER_10_110/a_40_246# 0.00285f
C24443 net45 _701_/a_1785_429# 0.00177f
C24444 _206_ FILLER_0_109/a_32_246# 0
C24445 net55 FILLER_1_201/a_40_246# 0
C24446 net94 FILLER_7_82/a_32_246# 0
C24447 _294_ _684_/a_1583_191# 0
C24448 _248_ FILLER_16_166/a_32_246# 0
C24449 _646_/a_132_114# _223_ 0
C24450 net13 _633_/a_1840_334# 0.00975f
C24451 _021_ hold148/a_56_118# 0
C24452 net148 hold148/a_438_182# 0
C24453 hold66/a_56_118# net66 0
C24454 hold97/a_56_118# _096_ 0
C24455 hold183/a_56_118# clk 0.00428f
C24456 hold168/a_438_182# net168 0.01192f
C24457 _229_ _423_/a_279_412# 0
C24458 baud_inst.counter\[20\] hold121/a_56_118# 0.08338f
C24459 net128 _089_ 0
C24460 net29 _037_ 0.04327f
C24461 _291_ net152 0
C24462 _417_/a_22_110# _247_ 0
C24463 baud_inst.counter\[1\] hold135/a_438_182# 0
C24464 VPWR _289_ 0.0351f
C24465 net174 net27 0.05799f
C24466 net44 _687_/a_1840_334# 0.0065f
C24467 _660_/a_1840_334# _654_/a_38_114# 0
C24468 _660_/a_1583_191# _654_/a_324_432# 0
C24469 clknet_4_6_0_clk _668_/a_1785_429# 0
C24470 net4 net40 0.01369f
C24471 _380_/a_382_118# net170 0.0143f
C24472 _380_/a_59_156# _208_ 0.03118f
C24473 _227_ _230_ 0.82732f
C24474 _158_ _161_ 0
C24475 tx hold55/a_56_118# 0.01459f
C24476 clknet_4_14_0_clk _649_/a_843_236# 0
C24477 _641_/a_1840_334# baud_inst.counter\[25\] 0
C24478 _656_/a_2002_114# VPWR 0
C24479 _027_ _311_ 0.00557f
C24480 _234_ _000_ -0
C24481 _672_/a_1840_334# _033_ 0
C24482 tx_data[3] VPWR 0.01305f
C24483 _694_/a_741_93# _107_ 0.00106f
C24484 _533_/a_146_122# VPWR 0
C24485 _110_ net142 0.02941f
C24486 _659_/a_741_93# _211_ 0
C24487 _248_ _156_ 0.04675f
C24488 clknet_4_12_0_clk _697_/a_843_236# 0
C24489 _633_/a_741_93# _266_ 0.00352f
C24490 _633_/a_843_236# net30 0
C24491 hold136/a_56_118# _279_ 0.07219f
C24492 net12 _632_/a_2002_114# 0
C24493 _387_/a_46_156# net5 0.09777f
C24494 clknet_0_clk _687_/a_1583_191# 0
C24495 _132_ _262_ 0
C24496 _053_ _131_ 0.00131f
C24497 clknet_4_12_0_clk _261_ 0.10106f
C24498 baud_inst.counter\[28\] _700_/a_38_114# 0
C24499 _661_/a_550_127# net155 0
C24500 baud_inst.counter\[4\] net43 0
C24501 _228_ _409_/a_167_412# 0.00151f
C24502 rx_inst.state\[2\] _409_/a_73_118# 0.01954f
C24503 tx_data[2] FILLER_0_128/a_40_246# 0.00575f
C24504 _655_/a_132_114# clknet_0_clk 0
C24505 _265_ _650_/a_1583_191# 0.00286f
C24506 _248_ rx_inst.state\[2\] 0
C24507 _656_/a_324_432# tx_data[6] 0
C24508 _656_/a_38_114# net9 0.00258f
C24509 net48 _636_/a_1840_334# 0.00161f
C24510 _341_/a_886_118# net41 0
C24511 _076_ _365_/a_257_140# 0
C24512 FILLER_5_164/a_40_246# _197_ 0
C24513 hold161/a_326_118# net161 0
C24514 clknet_4_7_0_clk _639_/a_843_236# 0
C24515 _090_ _089_ 0
C24516 baud_inst.counter\[14\] _687_/a_324_432# 0
C24517 baud_inst.counter\[15\] _687_/a_741_93# 0.00102f
C24518 rx_inst.data_reg\[4\] _647_/a_1840_334# 0.00267f
C24519 _155_ _124_ 0
C24520 _645_/a_2250_412# _170_ 0
C24521 _294_ FILLER_16_56/a_32_246# 0
C24522 VPWR FILLER_2_14/a_40_246# 0.15755f
C24523 hold179/a_438_182# net55 0.00107f
C24524 _660_/a_324_432# clknet_4_5_0_clk 0.01138f
C24525 _662_/a_298_337# _073_ 0.0054f
C24526 _228_ net2 0.21323f
C24527 net111 FILLER_20_198/a_40_246# 0
C24528 clknet_4_7_0_clk _152_ 0
C24529 _075_ net146 0
C24530 clknet_4_6_0_clk _667_/a_1840_334# 0
C24531 net102 VPWR 0.03702f
C24532 _429_/a_244_140# _158_ 0
C24533 hold65/a_438_182# hold72/a_438_182# 0
C24534 net184 hold184/a_326_118# 0.02075f
C24535 input2/a_40_152# _705_/a_1583_191# 0
C24536 _534_/a_268_412# _021_ 0.00126f
C24537 _070_ FILLER_4_108/a_40_246# 0.02205f
C24538 hold97/a_438_182# baud_inst.counter\[10\] 0.00132f
C24539 hold97/a_326_118# _183_ 0
C24540 rx_inst.state\[3\] _191_ 0.22347f
C24541 _692_/a_843_236# net164 0
C24542 _692_/a_741_93# clknet_4_10_0_clk 0.03015f
C24543 _170_ _254_ 0
C24544 hold111/a_438_182# net64 0.00528f
C24545 hold111/a_326_118# _273_ 0
C24546 _655_/a_324_432# net181 0.00226f
C24547 tx _705_/a_741_93# 0.00159f
C24548 fanout28/a_40_152# net29 0.0242f
C24549 clknet_4_0_0_clk _681_/a_298_337# 0
C24550 _351_/a_268_412# VPWR 0
C24551 _081_ clkload1/Y 0
C24552 _156_ hold73/a_438_182# 0
C24553 _689_/a_741_93# _101_ 0.01351f
C24554 _699_/a_1489_191# _165_ 0
C24555 hold75/a_438_182# FILLER_22_43/a_40_246# 0.00941f
C24556 net35 _237_ 0.02967f
C24557 _678_/a_38_114# clknet_4_1_0_clk 0.00271f
C24558 net108 _162_ 0
C24559 _680_/a_843_236# _287_ 0
C24560 _680_/a_741_93# _038_ 0
C24561 _635_/a_741_93# _632_/a_1583_191# 0
C24562 hold117/a_326_118# hold117/a_438_182# 0
C24563 hold157/a_438_182# net40 0
C24564 _246_ FILLER_18_160/a_32_246# 0.00154f
C24565 net85 _632_/a_298_337# 0
C24566 hold87/a_56_118# _294_ 0.00124f
C24567 hold163/a_326_118# _105_ 0.00142f
C24568 rx_inst.bit_index\[2\] _452_/a_155_412# 0.00344f
C24569 clk _658_/a_741_93# 0
C24570 net111 _160_ 0.31699f
C24571 _385_/a_46_156# net38 0
C24572 net92 net97 0
C24573 _283_ net108 0
C24574 FILLER_10_147/a_32_246# _667_/a_843_236# 0
C24575 output17/a_40_152# output18/a_40_152# 0.00255f
C24576 hold59/a_326_118# _115_ 0
C24577 FILLER_20_106/a_32_246# net140 0
C24578 hold87/a_438_182# _109_ 0.00938f
C24579 _415_/a_170_412# _241_ 0
C24580 _407_/a_248_122# net175 0
C24581 net49 _701_/a_1583_191# 0.01386f
C24582 net92 net86 0
C24583 FILLER_8_63/a_40_246# net135 0
C24584 _241_ hold180/a_326_118# 0
C24585 _156_ net139 0.00519f
C24586 rx _050_ 0.00148f
C24587 _411_/a_115_308# _228_ 0.01759f
C24588 rx_inst.bit_index\[2\] clknet_0_clk 0.0402f
C24589 net121 _693_/a_843_236# 0.01599f
C24590 _636_/a_2250_412# _157_ 0
C24591 hold162/a_56_118# _696_/a_741_93# 0
C24592 tx_data[2] _387_/a_46_156# 0.00104f
C24593 _163_ _292_ 0.62152f
C24594 hold119/a_326_118# hold119/a_438_182# 0
C24595 net66 _635_/a_298_337# 0
C24596 net32 _420_/a_146_122# 0.0045f
C24597 clknet_4_11_0_clk clknet_0_clk 0.1349f
C24598 _659_/a_741_93# _659_/a_1489_191# 0
C24599 _177_ _554_/a_146_122# 0
C24600 hold181/a_438_182# VPWR 0.00572f
C24601 _171_ _206_ 0.1484f
C24602 net50 _166_ 0.13989f
C24603 hold164/a_56_118# net148 0
C24604 _643_/a_741_93# net111 0
C24605 _233_ _000_ 0
C24606 _675_/a_741_93# net38 0.02529f
C24607 net159 net137 0
C24608 _244_ _424_/a_142_412# 0.0074f
C24609 net2 _153_ 0.06074f
C24610 _158_ FILLER_28_204/a_32_246# 0
C24611 _131_ _451_/a_155_412# 0.00252f
C24612 _262_ _451_/a_257_140# 0
C24613 _158_ clkbuf_4_14_0_clk/a_27_118# 0
C24614 hold68/a_438_182# _028_ 0
C24615 hold90/a_326_118# net29 0.01461f
C24616 VPWR _633_/a_1785_429# 0
C24617 VPWR FILLER_0_54/a_40_246# 0.13012f
C24618 net51 _704_/a_38_114# 0
C24619 tx_inst.data_reg\[6\] net55 0.03232f
C24620 _050_ hold73/a_438_182# 0
C24621 net84 _635_/a_741_93# 0.00358f
C24622 _537_/a_192_429# _105_ 0
C24623 _635_/a_1583_191# FILLER_21_229/a_32_246# 0
C24624 clkbuf_4_5_0_clk/a_27_118# tx_inst.state\[2\] 0
C24625 net152 baud_inst.counter\[4\] 0.7205f
C24626 _667_/a_1840_334# net29 0
C24627 net26 _651_/a_1583_191# 0.00163f
C24628 net62 _459_/a_27_156# 0
C24629 _265_ _639_/a_298_337# 0.0369f
C24630 VPWR FILLER_4_237/a_40_246# 0.13833f
C24631 _230_ _242_ 0.04566f
C24632 _243_ clknet_0_clk 0.00224f
C24633 net173 clkbuf_4_4_0_clk/a_27_118# 0
C24634 _037_ hold95/a_438_182# 0.00982f
C24635 net93 net29 0
C24636 _707_/a_550_127# net43 0
C24637 clknet_4_8_0_clk baud_inst.counter\[17\] 0.00256f
C24638 _404_/a_268_412# VPWR 0
C24639 _226_ _248_ 0
C24640 _166_ FILLER_5_181/a_32_246# 0
C24641 FILLER_12_173/a_32_246# clknet_0_clk 0.0173f
C24642 hold52/a_438_182# _242_ 0.00341f
C24643 tx_inst.data_reg\[1\] _149_ 0
C24644 _674_/a_1583_191# _672_/a_298_337# 0
C24645 net136 _681_/a_1840_334# 0.00142f
C24646 net42 _667_/a_843_236# 0
C24647 _170_ _416_/a_146_122# 0
C24648 net49 hold180/a_438_182# 0.00326f
C24649 _011_ _096_ 0.00256f
C24650 baud_inst.counter\[28\] net105 0.55347f
C24651 net172 _665_/a_38_114# 0
C24652 net31 _252_ 0
C24653 _662_/a_298_337# net41 0.01151f
C24654 _093_ _181_ 0
C24655 _194_ _171_ 0
C24656 hold98/a_326_118# _681_/a_1489_191# 0
C24657 hold157/a_326_118# net101 0.00249f
C24658 FILLER_21_165/a_40_246# net49 0.00112f
C24659 _498_/a_165_412# baud_inst.counter\[4\] 0
C24660 _498_/a_279_412# net152 0
C24661 _407_/a_248_122# _161_ 0
C24662 clk _656_/a_681_505# 0
C24663 fanout31/a_40_152# VPWR 0.05097f
C24664 net69 net70 0
C24665 net45 _695_/a_1840_334# 0
C24666 _646_/a_1583_191# clknet_0_clk 0.02971f
C24667 _678_/a_1489_191# net40 0
C24668 net27 _651_/a_550_127# 0
C24669 net89 _014_ 0.09342f
C24670 net74 net138 0
C24671 _645_/a_612_127# clknet_4_14_0_clk 0
C24672 _029_ hold107/a_56_118# 0.05162f
C24673 net106 hold107/a_326_118# 0.01761f
C24674 net66 _632_/a_612_127# 0.00214f
C24675 net123 _685_/a_2250_412# 0.00184f
C24676 net122 _667_/a_38_114# 0.01193f
C24677 net37 _667_/a_298_337# 0.00367f
C24678 FILLER_12_166/a_40_246# net51 0
C24679 net100 _698_/a_1785_429# 0
C24680 tx_inst.data_reg\[6\] _067_ 0.00144f
C24681 hold101/a_438_182# hold104/a_56_118# 0
C24682 net48 hold112/a_438_182# 0.04919f
C24683 hold155/a_56_118# _210_ 0
C24684 _241_ _247_ 1.13766f
C24685 clknet_4_12_0_clk _447_/a_81_118# 0
C24686 tx_inst.state\[1\] hold50/a_438_182# 0.01819f
C24687 net145 net41 0.02921f
C24688 _686_/a_2250_412# clknet_4_9_0_clk 0
C24689 _444_/a_244_140# _159_ 0.00111f
C24690 _339_/a_1453_124# clknet_0_clk 0.01121f
C24691 net52 _418_/a_46_156# 0
C24692 net79 _673_/a_843_236# 0.03968f
C24693 VPWR _666_/a_324_432# 0.01934f
C24694 _636_/a_1489_191# clkbuf_4_13_0_clk/a_27_118# 0
C24695 _680_/a_324_432# FILLER_7_40/a_32_246# 0
C24696 _696_/a_38_114# _025_ 0
C24697 _696_/a_741_93# net141 0.03336f
C24698 rx_inst.bit_index\[0\] _256_ 0.00325f
C24699 _696_/a_324_432# _310_ 0.01596f
C24700 _228_ _169_ 0
C24701 FILLER_16_70/a_40_246# _294_ 0.0017f
C24702 VPWR FILLER_9_169/a_32_246# 0.0753f
C24703 _360_/a_382_118# _656_/a_1840_334# 0
C24704 net34 _166_ 0
C24705 hold160/a_438_182# _163_ 0
C24706 _140_ _137_ 0
C24707 net51 hold51/a_56_118# 0.00312f
C24708 _637_/a_298_337# net30 0
C24709 tx_inst.data_reg\[6\] _076_ 0
C24710 hold145/a_326_118# tx_inst.data_reg\[3\] 0.00577f
C24711 output15/a_40_152# clknet_4_13_0_clk 0
C24712 clknet_4_14_0_clk _424_/a_142_412# 0.01414f
C24713 hold124/a_56_118# rx_inst.data_reg\[5\] 0.02878f
C24714 FILLER_21_175/a_32_246# FILLER_22_175/a_32_246# 0
C24715 hold151/a_438_182# net48 0
C24716 VPWR net135 0.28396f
C24717 hold173/a_326_118# net56 0
C24718 _440_/a_550_140# _252_ 0
C24719 clknet_0_clk net64 0.17331f
C24720 _466_/a_22_110# _269_ 0.00241f
C24721 _697_/a_298_337# _109_ 0
C24722 net74 _047_ 0.08991f
C24723 clknet_4_5_0_clk _664_/a_38_114# 0.05233f
C24724 hold184/a_56_118# _341_/a_1453_124# 0
C24725 net34 hold174/a_326_118# 0
C24726 _676_/a_741_93# baud_inst.counter\[13\] 0
C24727 _052_ net99 0
C24728 _646_/a_1489_191# _240_ 0.00237f
C24729 FILLER_0_128/a_40_246# _210_ 0.00258f
C24730 _074_ _706_/a_741_93# 0
C24731 _699_/a_324_432# _547_/a_81_118# 0
C24732 hold136/a_56_118# _674_/a_324_432# 0
C24733 net87 _297_ 0.13253f
C24734 _304_ VPWR 0.04234f
C24735 VPWR _099_ 0.13731f
C24736 FILLER_27_46/a_32_246# _701_/a_324_432# 0
C24737 hold113/a_326_118# clknet_0_clk 0.01199f
C24738 net122 _220_ 0
C24739 _171_ _202_ 0
C24740 FILLER_27_194/a_40_246# _648_/a_324_432# 0
C24741 _642_/a_38_114# _053_ 0.05769f
C24742 _642_/a_298_337# _132_ 0.01257f
C24743 baud_inst.counter\[28\] _700_/a_1840_334# 0.05084f
C24744 _055_ _170_ 0.00215f
C24745 hold150/a_438_182# _158_ 0
C24746 hold125/a_326_118# FILLER_23_186/a_40_246# 0
C24747 _072_ _151_ 0.01264f
C24748 tx_inst.data_reg\[7\] _206_ 0
C24749 net152 _492_/a_170_412# 0
C24750 _117_ _668_/a_1840_334# 0
C24751 _246_ FILLER_17_160/a_40_246# 0.00367f
C24752 clkbuf_4_11_0_clk/a_27_118# _698_/a_843_236# 0.00299f
C24753 _655_/a_1489_191# clknet_0_clk 0
C24754 _098_ hold128/a_326_118# 0.00566f
C24755 net31 _486_/a_494_160# 0
C24756 _466_/a_120_432# _156_ 0
C24757 net156 _684_/a_843_236# 0
C24758 output12/a_40_152# _264_ 0
C24759 _656_/a_1840_334# net9 0.04721f
C24760 clk net28 0
C24761 _660_/a_843_236# _214_ 0.0129f
C24762 _198_ VPWR 0.14917f
C24763 _485_/a_120_432# net122 0
C24764 _358_/a_72_436# _358_/a_268_436# -0
C24765 _168_ VPWR 1.02784f
C24766 _192_ _203_ 0.00119f
C24767 _431_/a_81_118# _229_ 0
C24768 net99 FILLER_20_95/a_40_246# 0
C24769 _660_/a_2250_412# clknet_4_5_0_clk 0.01053f
C24770 _294_ baud_inst.counter\[13\] 0.02732f
C24771 _169_ _153_ 0
C24772 hold132/a_438_182# _254_ 0
C24773 _398_/a_358_436# net183 0
C24774 _216_ _400_/a_192_429# 0.04026f
C24775 _643_/a_324_432# FILLER_23_186/a_40_246# 0
C24776 _184_ _351_/a_46_156# 0.00268f
C24777 hold152/a_438_182# baud_inst.counter\[4\] 0.00678f
C24778 hold56/a_438_182# _166_ 0
C24779 _554_/a_146_122# VPWR 0
C24780 tx_inst.data_reg\[0\] clknet_0_clk 0.00176f
C24781 _705_/a_38_114# _166_ 0.00242f
C24782 clknet_4_11_0_clk _700_/a_843_236# 0.01241f
C24783 output21/a_40_152# net33 0
C24784 _677_/a_1583_191# _063_ 0
C24785 tx_start VPWR 0.10564f
C24786 clknet_0_clk _520_/a_257_140# 0
C24787 _692_/a_612_127# net164 0.00108f
C24788 _692_/a_1785_429# clknet_4_10_0_clk 0
C24789 _206_ net146 0
C24790 FILLER_15_185/a_32_246# _650_/a_38_114# 0
C24791 _054_ net65 0
C24792 clkbuf_4_12_0_clk/a_27_118# net25 0.05485f
C24793 _673_/a_324_432# clknet_4_1_0_clk 0.02003f
C24794 tx _705_/a_1785_429# 0
C24795 clkbuf_0_clk/a_116_82# _669_/a_1840_334# 0
C24796 clknet_4_0_0_clk _681_/a_1583_191# 0.02329f
C24797 net37 hold119/a_438_182# 0.00868f
C24798 _643_/a_298_337# FILLER_21_192/a_40_246# 0
C24799 FILLER_8_236/a_40_246# FILLER_8_238/a_32_246# 0.0524f
C24800 _189_ _684_/a_38_114# 0.00292f
C24801 _678_/a_1840_334# clknet_4_1_0_clk 0.00224f
C24802 hold137/a_438_182# net41 0.00213f
C24803 _659_/a_324_432# FILLER_7_121/a_40_246# 0
C24804 clknet_4_3_0_clk _653_/a_324_432# 0
C24805 _114_ _107_ 0.00413f
C24806 _635_/a_843_236# _632_/a_1489_191# 0
C24807 net15 hold138/a_326_118# 0.00216f
C24808 _387_/a_46_156# _210_ 0
C24809 _090_ hold92/a_438_182# 0.00452f
C24810 FILLER_28_176/a_32_246# _633_/a_38_114# 0
C24811 clk _658_/a_1785_429# 0.00142f
C24812 hold182/a_326_118# _083_ 0.00837f
C24813 net92 hold115/a_56_118# 0
C24814 baud_inst.counter\[26\] _697_/a_1583_191# 0
C24815 FILLER_14_164/a_32_246# net29 0
C24816 _138_ _633_/a_741_93# 0
C24817 net125 _633_/a_324_432# 0
C24818 _049_ clkbuf_4_15_0_clk/a_27_118# 0.0074f
C24819 _286_ _291_ 0.16755f
C24820 _109_ _517_/a_209_168# 0
C24821 net49 _701_/a_2002_114# 0
C24822 _654_/a_843_236# FILLER_2_208/a_40_246# 0
C24823 fanout37/a_40_152# _668_/a_38_114# 0
C24824 hold160/a_56_118# baud_inst.counter\[16\] 0.05918f
C24825 net31 _428_/a_354_412# 0
C24826 net121 _693_/a_612_127# 0
C24827 FILLER_16_176/a_40_246# net62 0
C24828 hold52/a_56_118# rx_inst.state\[2\] 0
C24829 _145_ FILLER_0_80/a_40_246# 0
C24830 hold119/a_326_118# _650_/a_38_114# 0
C24831 _094_ fanout38/a_40_152# 0.00496f
C24832 hold178/a_438_182# net97 0
C24833 _638_/a_741_93# clknet_4_15_0_clk 0.03959f
C24834 rx_inst.bit_index\[1\] _454_/a_155_412# 0.00531f
C24835 hold172/a_438_182# net21 0.00653f
C24836 _675_/a_1785_429# net38 0
C24837 _675_/a_2250_412# _085_ 0.00466f
C24838 net158 _688_/a_132_114# 0
C24839 baud_inst.counter\[17\] _688_/a_843_236# 0.0108f
C24840 net29 _682_/a_1840_334# 0.00392f
C24841 clknet_4_10_0_clk clknet_4_8_0_clk 0
C24842 hold86/a_56_118# net181 0
C24843 _153_ _084_ 0
C24844 _193_ _175_ 0
C24845 _092_ _679_/a_324_432# 0.02703f
C24846 net2 hold80/a_56_118# 0.05899f
C24847 rx hold80/a_326_118# 0.04548f
C24848 net83 _264_ 0
C24849 clknet_4_8_0_clk _687_/a_843_236# 0.02616f
C24850 net41 _380_/a_559_412# 0
C24851 FILLER_3_207/a_40_246# FILLER_2_208/a_40_246# 0
C24852 _511_/a_150_412# _183_ 0
C24853 _652_/a_38_114# net137 0
C24854 baud_inst.counter\[20\] _538_/a_81_118# 0.02086f
C24855 _194_ hold184/a_438_182# 0.01968f
C24856 baud_inst.counter\[27\] hold141/a_326_118# 0
C24857 baud_inst.counter\[26\] hold141/a_56_118# 0.00301f
C24858 clknet_4_1_0_clk net29 0
C24859 clkbuf_4_1_0_clk/a_27_118# _382_/a_59_156# 0.00212f
C24860 _650_/a_1583_191# _668_/a_324_432# 0
C24861 net87 net162 0
C24862 net84 _635_/a_1785_429# 0
C24863 _657_/a_298_337# _070_ 0.01197f
C24864 FILLER_10_147/a_32_246# _062_ 0.00198f
C24865 net85 net84 0
C24866 _305_ _105_ 0
C24867 hold181/a_56_118# _181_ 0
C24868 hold181/a_326_118# net60 0
C24869 _500_/a_257_140# net94 0
C24870 _500_/a_155_412# net92 0
C24871 net40 _682_/a_741_93# 0
C24872 _265_ _639_/a_1583_191# 0.01628f
C24873 _528_/a_277_118# _296_ 0.00118f
C24874 _168_ _266_ 0.04868f
C24875 tx_data[5] VPWR 0.01413f
C24876 net159 _213_ 0.06219f
C24877 hold99/a_326_118# _697_/a_843_236# 0
C24878 hold99/a_438_182# _697_/a_741_93# 0
C24879 hold88/a_326_118# _100_ 0
C24880 net28 net2 1.40813f
C24881 net26 net25 0.01096f
C24882 clknet_4_3_0_clk _652_/a_132_114# 0
C24883 _168_ _167_ 0.02305f
C24884 hold54/a_438_182# fanout33/a_40_152# 0.00888f
C24885 hold136/a_326_118# baud_inst.counter\[9\] 0
C24886 clknet_4_0_0_clk _279_ 0.00966f
C24887 _013_ _515_/a_76_160# 0.01505f
C24888 net44 _691_/a_324_432# 0.01372f
C24889 net32 net25 1.84815f
C24890 _264_ _649_/a_1489_191# 0.0151f
C24891 hold172/a_56_118# _478_/a_27_156# 0.00142f
C24892 _662_/a_1583_191# net41 0
C24893 _168_ _647_/a_741_93# 0
C24894 hold151/a_326_118# _135_ 0.01678f
C24895 hold151/a_56_118# net151 0.00438f
C24896 baud_inst.counter\[22\] _029_ 0
C24897 net153 _282_ 0
C24898 _035_ baud_inst.counter\[4\] 0.02272f
C24899 clk _656_/a_550_127# 0
C24900 _007_ net168 0.03502f
C24901 _515_/a_76_160# baud_inst.counter\[14\] 0.00263f
C24902 net35 hold180/a_326_118# 0
C24903 _260_ net62 0
C24904 _646_/a_2002_114# clknet_0_clk 0.00112f
C24905 FILLER_29_198/a_40_246# _123_ 0
C24906 net27 clknet_4_6_0_clk 0.11105f
C24907 baud_inst.counter\[31\] hold58/a_326_118# 0.00435f
C24908 _154_ clknet_4_15_0_clk 1.92916f
C24909 _664_/a_38_114# _005_ 0.04782f
C24910 net37 _667_/a_1583_191# 0
C24911 net122 _667_/a_1840_334# 0.03002f
C24912 _707_/a_681_505# net51 0
C24913 _668_/a_843_236# rx_inst.state\[1\] 0
C24914 net79 _030_ 0
C24915 net177 _292_ 0.07271f
C24916 _060_ net65 0
C24917 _021_ clknet_4_10_0_clk 0.11655f
C24918 FILLER_0_161/a_40_246# input9/a_40_152# 0.01f
C24919 _678_/a_298_337# _352_/a_46_156# 0
C24920 _655_/a_38_114# net38 0.02731f
C24921 net173 VPWR 0.11346f
C24922 net25 hold62/a_326_118# 0
C24923 _249_ _136_ 0.03378f
C24924 _191_ _205_ 0.00679f
C24925 _526_/a_248_122# _300_ 0
C24926 FILLER_8_171/a_32_246# net27 0.00138f
C24927 net44 _641_/a_298_337# 0.00256f
C24928 _498_/a_279_412# _035_ 0
C24929 _675_/a_324_432# baud_inst.counter\[3\] 0
C24930 _678_/a_324_432# hold94/a_326_118# 0
C24931 _678_/a_38_114# hold94/a_438_182# 0
C24932 _339_/a_1377_160# clknet_0_clk 0.00966f
C24933 _218_ net27 0.00599f
C24934 VPWR _685_/a_843_236# 0.00347f
C24935 _059_ _648_/a_550_127# 0
C24936 net79 _673_/a_612_127# 0.00444f
C24937 VPWR _666_/a_2250_412# 0.00283f
C24938 tx_busy VPWR 0.14702f
C24939 _158_ _154_ 0.00127f
C24940 _657_/a_38_114# clknet_4_1_0_clk 0
C24941 _677_/a_1583_191# _089_ 0
C24942 VPWR _689_/a_843_236# 0.0106f
C24943 _696_/a_1840_334# _025_ 0.00731f
C24944 clknet_4_11_0_clk _314_ 0
C24945 rx_inst.data_reg\[0\] VPWR 0.10932f
C24946 _062_ _142_ 0.05126f
C24947 _264_ _470_/a_22_110# 0.01082f
C24948 tx_inst.bit_index\[1\] _656_/a_843_236# 0
C24949 _360_/a_71_118# clknet_4_4_0_clk 0.03822f
C24950 _173_ net34 0.94917f
C24951 hold55/a_326_118# _665_/a_1840_334# 0
C24952 hold55/a_438_182# _665_/a_1583_191# 0
C24953 _663_/a_741_93# clkbuf_4_7_0_clk/a_27_118# 0
C24954 net42 _062_ 0.0672f
C24955 _637_/a_1583_191# net30 0
C24956 _646_/a_324_432# net48 0.00499f
C24957 baud_inst.counter\[20\] _694_/a_298_337# 0.01212f
C24958 _528_/a_81_118# _014_ 0.01726f
C24959 _312_ net162 0
C24960 _648_/a_324_432# rx_inst.data_reg\[5\] 0
C24961 clknet_4_5_0_clk _654_/a_843_236# 0.02684f
C24962 _658_/a_843_236# _148_ 0
C24963 _660_/a_741_93# tx_inst.data_reg\[0\] 0.00293f
C24964 net23 input2/a_40_152# 0.0123f
C24965 output23/a_40_152# rx 0.00149f
C24966 rx_inst.bit_index\[1\] _170_ 0
C24967 FILLER_4_100/a_40_246# net6 0.00434f
C24968 net55 FILLER_0_103/a_32_246# 0.01729f
C24969 clknet_4_5_0_clk _664_/a_1840_334# 0
C24970 hold184/a_56_118# _341_/a_1377_160# 0
C24971 tx_inst.state\[1\] _705_/a_843_236# 0
C24972 net16 _650_/a_1489_191# 0
C24973 _020_ _105_ 0.0081f
C24974 net132 hold132/a_326_118# 0
C24975 _055_ hold132/a_438_182# 0.00452f
C24976 _555_/a_177_436# net67 0.00135f
C24977 rx_inst.data_reg\[3\] _240_ 0
C24978 _530_/a_257_140# VPWR 0
C24979 hold99/a_438_182# clknet_0_clk 0.00732f
C24980 _394_/a_22_110# net50 0.00155f
C24981 _288_ _682_/a_38_114# 0
C24982 _458_/a_165_412# clknet_0_clk 0
C24983 _690_/a_681_505# VPWR 0
C24984 _303_ fanout45/a_40_152# 0
C24985 net136 _674_/a_741_93# 0
C24986 _680_/a_843_236# hold116/a_326_118# 0
C24987 _680_/a_741_93# hold116/a_438_182# 0
C24988 net39 hold109/a_438_182# 0.00372f
C24989 _412_/a_120_432# net29 0.00319f
C24990 FILLER_26_227/a_40_246# hold70/a_56_118# 0
C24991 FILLER_7_146/a_32_246# VPWR 0.08156f
C24992 _031_ net45 0.04098f
C24993 _029_ _694_/a_2250_412# 0
C24994 hold158/a_326_118# net161 0.00137f
C24995 _233_ _417_/a_22_110# 0.00244f
C24996 _690_/a_741_93# FILLER_17_24/a_32_246# 0
C24997 _642_/a_1583_191# _132_ 0.02158f
C24998 _113_ hold133/a_438_182# 0
C24999 _160_ clknet_4_15_0_clk 0
C25000 _282_ _280_ 0
C25001 _449_/a_229_118# clknet_0_clk 0
C25002 net55 FILLER_4_102/a_32_246# 0.00267f
C25003 tx_inst.data_reg\[1\] clknet_0_clk 0.01113f
C25004 _129_ rx_inst.data_reg\[7\] 0.21625f
C25005 net35 _247_ 0.37045f
C25006 net55 _384_/a_59_156# 0.02445f
C25007 VPWR FILLER_22_22/a_32_246# 0.07899f
C25008 net124 _648_/a_1489_191# 0.01184f
C25009 _155_ _648_/a_550_127# 0
C25010 hold64/a_56_118# _264_ 0.00189f
C25011 _341_/a_1453_124# net168 0
C25012 output16/a_40_152# _264_ 0.01178f
C25013 _042_ _665_/a_741_93# 0
C25014 net27 net29 0.086f
C25015 net156 _684_/a_612_127# 0.00173f
C25016 clknet_4_14_0_clk hold124/a_438_182# 0
C25017 clknet_4_4_0_clk input9/a_40_152# 0
C25018 _660_/a_612_127# _214_ 0.01555f
C25019 _286_ baud_inst.counter\[4\] 0
C25020 hold56/a_326_118# _651_/a_1840_334# 0
C25021 hold56/a_438_182# _651_/a_1583_191# 0
C25022 _264_ net77 0.16276f
C25023 _316_ _554_/a_350_122# 0
C25024 baud_inst.counter\[21\] _693_/a_843_236# 0
C25025 net122 _003_ 0
C25026 _021_ hold149/a_438_182# 0.00328f
C25027 hold141/a_56_118# _109_ 0
C25028 fanout33/a_40_152# _665_/a_324_432# 0
C25029 _180_ FILLER_12_82/a_32_246# 0.00232f
C25030 VPWR _131_ 0.06532f
C25031 net31 _442_/a_350_122# 0
C25032 clknet_4_4_0_clk _653_/a_38_114# 0.00107f
C25033 _035_ _492_/a_170_412# 0
C25034 _013_ net91 0
C25035 output20/a_40_152# input2/a_40_152# 0.09867f
C25036 _643_/a_741_93# clknet_4_15_0_clk 0
C25037 net31 _248_ 0.00123f
C25038 _414_/a_279_412# net49 0
C25039 tx_inst.bit_index\[2\] _176_ 0
C25040 _089_ _676_/a_550_127# 0
C25041 baud_inst.counter\[14\] net91 0.22381f
C25042 tx_inst.bit_index\[2\] _068_ 0
C25043 _194_ hold56/a_326_118# 0
C25044 _486_/a_494_160# net62 0
C25045 _646_/a_741_93# _157_ 0.00609f
C25046 hold58/a_438_182# _703_/a_843_236# 0
C25047 net65 _649_/a_741_93# 0
C25048 _041_ _277_ 0.00479f
C25049 clknet_4_11_0_clk _700_/a_612_127# 0.00179f
C25050 _677_/a_2002_114# _063_ 0
C25051 hold110/a_326_118# _505_/a_76_160# 0
C25052 hold90/a_56_118# net90 0
C25053 _447_/a_379_118# net24 0
C25054 _670_/a_1489_191# net29 0
C25055 hold175/a_438_182# net25 0.04869f
C25056 fanout27/a_40_152# net62 0.01441f
C25057 _344_/a_354_412# clknet_4_8_0_clk 0.003f
C25058 VPWR _700_/a_298_337# 0
C25059 _673_/a_2250_412# clknet_4_1_0_clk 0
C25060 _172_ clknet_4_4_0_clk 0.08697f
C25061 _657_/a_843_236# net41 0.06913f
C25062 clknet_4_0_0_clk _681_/a_2002_114# 0
C25063 _278_ VPWR 0.04133f
C25064 net28 _169_ 1.22476f
C25065 _691_/a_38_114# _164_ 0
C25066 net37 _650_/a_38_114# 0
C25067 _691_/a_324_432# _302_ 0
C25068 hold142/a_56_118# baud_inst.counter\[25\] 0.0087f
C25069 hold142/a_438_182# net99 0
C25070 _663_/a_741_93# _216_ 0
C25071 _189_ _684_/a_1840_334# 0.00952f
C25072 FILLER_15_89/a_32_246# net128 0
C25073 _240_ _647_/a_681_505# 0
C25074 hold77/a_438_182# net47 0
C25075 rx_inst.data_reg\[0\] _266_ 0.01621f
C25076 _691_/a_1583_191# _690_/a_741_93# 0
C25077 _687_/a_324_432# _687_/a_843_236# -0
C25078 _227_ net180 0.21905f
C25079 net45 _130_ 0.00243f
C25080 net10 _066_ 0
C25081 FILLER_1_173/a_32_246# VPWR 0.08211f
C25082 baud_inst.counter\[22\] _535_/a_146_122# 0.0059f
C25083 net32 _139_ 0.01041f
C25084 tx_inst.data_reg\[7\] net145 0.17176f
C25085 net123 baud_inst.counter\[4\] 0.01876f
C25086 _667_/a_324_432# net63 0.01115f
C25087 baud_inst.counter\[26\] _546_/a_435_412# 0.0023f
C25088 clk FILLER_0_161/a_40_246# 0.00124f
C25089 _114_ net106 0.00222f
C25090 FILLER_0_54/a_40_246# FILLER_0_56/a_32_246# 0.0524f
C25091 net79 _008_ 0.00826f
C25092 clk _069_ 0.00991f
C25093 FILLER_6_189/a_40_246# _365_/a_155_412# 0
C25094 _403_/a_22_110# _222_ 0.00703f
C25095 _403_/a_120_432# _141_ 0.00532f
C25096 _678_/a_1583_191# net39 0.00289f
C25097 _657_/a_38_114# _147_ 0.04607f
C25098 _657_/a_324_432# _068_ 0.02187f
C25099 _469_/a_120_432# _264_ 0.00621f
C25100 clknet_4_9_0_clk hold91/a_56_118# 0.00176f
C25101 net26 _668_/a_324_432# 0
C25102 hold98/a_56_118# net29 0.00181f
C25103 net31 _245_ 0.03258f
C25104 _224_ net52 0.07498f
C25105 net121 net149 0
C25106 _234_ _241_ 0
C25107 _246_ hold139/a_56_118# 0
C25108 _109_ baud_inst.counter\[15\] 0.00833f
C25109 net49 _440_/a_142_412# 0.00105f
C25110 _519_/a_81_118# net40 0
C25111 _087_ FILLER_3_21/a_40_246# 0.00355f
C25112 _694_/a_324_432# _693_/a_1840_334# 0
C25113 _694_/a_741_93# _693_/a_1583_191# 0.00909f
C25114 rx_inst.bit_index\[1\] _263_ 0.0098f
C25115 input10/a_40_152# tx_data[7] 0.02683f
C25116 clkbuf_4_10_0_clk/a_27_118# _549_/a_155_412# 0
C25117 _143_ _653_/a_741_93# 0.00818f
C25118 _118_ _704_/a_681_505# 0
C25119 net36 rx_inst.bit_index\[0\] 0.00245f
C25120 tx_inst.bit_index\[1\] _658_/a_2250_412# 0
C25121 rx_inst.bit_index\[1\] hold175/a_326_118# 0.0322f
C25122 net36 hold175/a_56_118# 0.00286f
C25123 _480_/a_22_110# _076_ 0
C25124 _170_ _648_/a_324_432# 0
C25125 clknet_4_8_0_clk _687_/a_612_127# 0.00362f
C25126 _550_/a_209_168# hold106/a_326_118# 0
C25127 _071_ net170 0.00737f
C25128 net41 _208_ 0.05783f
C25129 _283_ _162_ 0.00179f
C25130 FILLER_18_160/a_32_246# FILLER_17_160/a_40_246# 0
C25131 _074_ _200_ 0
C25132 hold184/a_56_118# _195_ 0
C25133 _192_ FILLER_6_191/a_32_246# 0
C25134 _293_ _191_ 0
C25135 _640_/a_298_337# net100 0
C25136 _641_/a_843_236# _262_ 0
C25137 _657_/a_1583_191# _070_ 0
C25138 tx_inst.data_reg\[0\] net43 0
C25139 _650_/a_2250_412# _668_/a_1583_191# 0
C25140 hold79/a_326_118# _672_/a_1840_334# 0
C25141 hold79/a_56_118# _672_/a_2250_412# 0
C25142 hold79/a_438_182# _672_/a_1583_191# 0
C25143 hold68/a_438_182# net49 0
C25144 _643_/a_38_114# _223_ 0
C25145 hold116/a_56_118# VPWR 0.00565f
C25146 net92 _285_ 0.61853f
C25147 hold178/a_438_182# baud_inst.counter\[17\] 0
C25148 _526_/a_146_122# _296_ 0
C25149 _129_ _639_/a_1489_191# 0
C25150 net45 net147 0
C25151 _295_ _100_ 0
C25152 net45 net46 0.95097f
C25153 net67 _702_/a_298_337# 0.00423f
C25154 _189_ _356_/a_248_122# -0
C25155 hold149/a_56_118# clknet_4_10_0_clk 0.00141f
C25156 _022_ net49 0.02239f
C25157 _674_/a_324_432# clknet_4_0_0_clk 0.03724f
C25158 net42 net63 0.00553f
C25159 net28 _084_ 0
C25160 net44 _691_/a_2250_412# 0.04945f
C25161 _264_ rx_inst.data_reg\[6\] 0.02018f
C25162 _632_/a_324_432# _264_ 0.05793f
C25163 _383_/a_268_412# _210_ 0
C25164 _654_/a_298_337# _144_ 0.00419f
C25165 _654_/a_38_114# _065_ 0.0288f
C25166 _275_ net11 0.31564f
C25167 clknet_4_12_0_clk hold143/a_438_182# 0.00114f
C25168 hold96/a_56_118# _092_ 0.00481f
C25169 _046_ _240_ 0
C25170 _680_/a_298_337# hold117/a_438_182# 0
C25171 _680_/a_38_114# hold117/a_326_118# 0
C25172 _680_/a_324_432# hold117/a_56_118# 0
C25173 _353_/a_248_122# _182_ 0.00201f
C25174 _223_ _236_ 0
C25175 clk clknet_4_4_0_clk 0.07272f
C25176 _260_ _262_ 0
C25177 net131 net150 0.02266f
C25178 hold111/a_326_118# _160_ 0
C25179 _673_/a_1583_191# _672_/a_1583_191# 0
C25180 _661_/a_324_432# net41 0
C25181 _485_/a_22_110# net63 0.01697f
C25182 _374_/a_244_412# _204_ 0.00225f
C25183 _707_/a_550_127# net51 0
C25184 _692_/a_741_93# VPWR 0.02451f
C25185 net87 _684_/a_298_337# 0
C25186 _678_/a_38_114# _185_ 0.00221f
C25187 _678_/a_741_93# baud_inst.counter\[6\] 0.01692f
C25188 FILLER_12_171/a_40_246# VPWR 0.12466f
C25189 _655_/a_1840_334# net38 0
C25190 _652_/a_132_114# baud_inst.counter\[5\] 0
C25191 _118_ tx_inst.state\[4\] 0
C25192 hold163/a_326_118# net103 0
C25193 _663_/a_741_93# _666_/a_843_236# 0.00471f
C25194 _292_ _188_ 0
C25195 FILLER_0_163/a_32_246# tx_data[6] 0
C25196 _686_/a_1840_334# hold91/a_326_118# 0
C25197 _686_/a_1583_191# hold91/a_438_182# 0
C25198 _686_/a_2250_412# hold91/a_56_118# 0
C25199 _686_/a_741_93# net91 0.00199f
C25200 net58 _551_/a_76_160# 0.00788f
C25201 _675_/a_2250_412# baud_inst.counter\[3\] 0.01235f
C25202 _143_ _652_/a_1583_191# 0
C25203 _704_/a_741_93# VPWR 0.00607f
C25204 net64 clkbuf_4_13_0_clk/a_27_118# 0.00746f
C25205 hold87/a_56_118# _190_ 0
C25206 _657_/a_1840_334# clknet_4_1_0_clk 0.00112f
C25207 VPWR _689_/a_612_127# 0.00145f
C25208 hold160/a_438_182# net157 0
C25209 _659_/a_298_337# VPWR 0.00113f
C25210 rx_inst.state\[3\] _260_ 0.0012f
C25211 clknet_4_8_0_clk _308_ 0.31498f
C25212 net116 _039_ 0.21062f
C25213 _315_ net133 0
C25214 net1 _106_ 0
C25215 _447_/a_277_118# VPWR 0
C25216 net54 _654_/a_1840_334# 0
C25217 tx_inst.bit_index\[1\] _656_/a_612_127# 0
C25218 _360_/a_1109_431# clknet_4_4_0_clk 0
C25219 net184 _656_/a_1840_334# 0
C25220 _360_/a_886_118# tx_inst.data_reg\[2\] 0.01924f
C25221 net34 _397_/a_279_412# 0.00268f
C25222 net31 _041_ 0
C25223 FILLER_24_133/a_32_246# VPWR 0.08236f
C25224 clknet_4_1_0_clk input10/a_40_152# 0
C25225 baud_inst.counter\[20\] _694_/a_1583_191# 0.00166f
C25226 _191_ FILLER_12_117/a_40_246# 0.00714f
C25227 _646_/a_2250_412# net48 0.00189f
C25228 hold142/a_326_118# net140 0.01189f
C25229 hold142/a_56_118# baud_inst.counter\[24\] 0.00128f
C25230 clknet_4_12_0_clk _136_ 0.0364f
C25231 rx_inst.bit_index\[2\] _249_ 0.00233f
C25232 _648_/a_2250_412# rx_inst.data_reg\[5\] 0.01152f
C25233 _462_/a_120_432# VPWR 0
C25234 FILLER_22_118/a_32_246# _263_ 0
C25235 _467_/a_22_110# _264_ 0.02673f
C25236 clknet_4_5_0_clk _654_/a_612_127# 0
C25237 _658_/a_612_127# _148_ 0.00113f
C25238 _660_/a_1489_191# _065_ 0.0011f
C25239 _206_ _119_ 0
C25240 net51 _671_/a_1489_191# 0.00143f
C25241 _233_ _241_ 0
C25242 _178_ hold120/a_326_118# 0.00142f
C25243 _043_ _223_ 0
C25244 _641_/a_132_114# clknet_0_clk 0
C25245 hold155/a_56_118# net159 0
C25246 tx_inst.state\[1\] _705_/a_612_127# 0.00126f
C25247 clknet_4_7_0_clk _705_/a_550_127# 0
C25248 _083_ net37 0
C25249 net16 rx_inst.data_reg\[7\] 0
C25250 hold114/a_438_182# _027_ 0.00115f
C25251 tx_inst.data_reg\[6\] _660_/a_324_432# 0.04154f
C25252 _513_/a_155_160# clknet_0_clk 0
C25253 _707_/a_298_337# VPWR 0.00243f
C25254 _646_/a_1583_191# hold143/a_326_118# 0.00367f
C25255 _206_ _656_/a_324_432# 0
C25256 net116 _682_/a_1583_191# 0
C25257 _078_ _001_ 0.00236f
C25258 _288_ _682_/a_1840_334# 0.03795f
C25259 baud_inst.counter\[21\] _701_/a_38_114# 0
C25260 _690_/a_550_127# VPWR 0
C25261 net49 _108_ 0
C25262 _447_/a_277_118# _239_ 0
C25263 _699_/a_1840_334# net113 0.0025f
C25264 hold165/a_326_118# hold165/a_438_182# 0
C25265 _231_ net29 0.31024f
C25266 net34 FILLER_4_172/a_32_246# 0.00304f
C25267 _314_ _550_/a_209_168# 0
C25268 net106 _107_ 0
C25269 _642_/a_2002_114# _132_ 0
C25270 _691_/a_843_236# _692_/a_843_236# 0
C25271 net126 clknet_0_clk 0
C25272 output16/a_40_152# _269_ 0
C25273 baud_inst.counter\[26\] clknet_4_9_0_clk 0
C25274 _203_ net168 0
C25275 _201_ _200_ 0.03613f
C25276 tx_inst.bit_index\[1\] clknet_4_3_0_clk 0
C25277 FILLER_5_156/a_32_246# clknet_4_4_0_clk 0.0024f
C25278 hold123/a_56_118# net123 0
C25279 hold101/a_56_118# net156 0
C25280 net42 FILLER_8_191/a_32_246# 0
C25281 _043_ _240_ 0
C25282 VPWR _546_/a_192_429# 0.00771f
C25283 _341_/a_1377_160# net168 0
C25284 _662_/a_1583_191# _706_/a_843_236# 0
C25285 _680_/a_741_93# hold115/a_56_118# 0.00153f
C25286 hold160/a_438_182# _298_ 0
C25287 _668_/a_741_93# FILLER_12_208/a_32_246# 0
C25288 net124 rx_inst.data_reg\[5\] 0.21314f
C25289 _699_/a_38_114# baud_inst.counter\[29\] 0
C25290 _010_ _505_/a_76_160# 0
C25291 hold123/a_326_118# _191_ 0.04235f
C25292 net37 fanout37/a_40_152# 0.00853f
C25293 hold147/a_438_182# _107_ 0
C25294 _636_/a_324_432# net30 0.00998f
C25295 clknet_4_14_0_clk _648_/a_843_236# 0.02755f
C25296 hold155/a_438_182# tx_inst.data_reg\[1\] 0.00365f
C25297 VPWR hold51/a_438_182# 0.00218f
C25298 _642_/a_38_114# VPWR 0.00155f
C25299 _305_ _694_/a_843_236# 0.04258f
C25300 _023_ _694_/a_741_93# 0
C25301 baud_inst.counter\[22\] _693_/a_1840_334# 0
C25302 baud_inst.counter\[21\] _693_/a_612_127# 0
C25303 _672_/a_1583_191# net40 0
C25304 hold162/a_326_118# net99 0
C25305 net31 _255_ 0.10793f
C25306 clknet_4_4_0_clk _653_/a_1840_334# 0
C25307 FILLER_8_189/a_40_246# _217_ 0.00602f
C25308 _705_/a_2250_412# FILLER_8_236/a_40_246# 0.00162f
C25309 net105 net59 0
C25310 rx_done rx 0.22016f
C25311 net20 net2 0
C25312 _671_/a_38_114# VPWR 0.00418f
C25313 _529_/a_45_160# net103 0.00799f
C25314 FILLER_8_70/a_32_246# FILLER_9_70/a_40_246# 0
C25315 hold122/a_438_182# _216_ 0
C25316 net45 _313_ 0.22419f
C25317 hold143/a_326_118# net64 0.00908f
C25318 net143 _473_/a_22_110# 0
C25319 _660_/a_132_114# VPWR 0
C25320 hold182/a_326_118# _676_/a_324_432# 0.00102f
C25321 _293_ hold91/a_438_182# 0
C25322 _083_ _670_/a_843_236# 0.00196f
C25323 VPWR _686_/a_38_114# 0.00244f
C25324 hold58/a_56_118# _703_/a_1489_191# 0
C25325 _646_/a_1785_429# _157_ 0.00306f
C25326 hold160/a_438_182# _188_ 0.00717f
C25327 _241_ FILLER_17_199/a_40_246# 0
C25328 _250_ _435_/a_72_436# 0
C25329 _660_/a_2250_412# FILLER_1_201/a_40_246# 0.01012f
C25330 _259_ net24 0.00106f
C25331 _040_ _275_ 0.00323f
C25332 _409_/a_73_118# net62 0.026f
C25333 baud_inst.counter\[30\] _703_/a_324_432# 0.03069f
C25334 baud_inst.counter\[31\] _703_/a_741_93# 0.00979f
C25335 baud_inst.counter\[28\] _703_/a_843_236# 0
C25336 _179_ _703_/a_38_114# 0
C25337 VPWR _700_/a_1583_191# 0.00369f
C25338 _177_ clknet_4_8_0_clk 0.24086f
C25339 net79 _672_/a_843_236# 0.0074f
C25340 hold104/a_56_118# net103 0.00152f
C25341 _657_/a_612_127# net41 0.01459f
C25342 net87 baud_inst.counter\[16\] 0
C25343 hold137/a_326_118# baud_inst.counter\[6\] 0
C25344 _240_ _647_/a_550_127# 0
C25345 fanout43/a_40_152# net62 0.00765f
C25346 _691_/a_298_337# _103_ 0
C25347 _691_/a_1489_191# _690_/a_843_236# 0
C25348 _125_ rx_inst.data_reg\[4\] 0.06992f
C25349 _270_ net138 0
C25350 hold126/a_326_118# clknet_4_15_0_clk 0.00114f
C25351 hold54/a_56_118# FILLER_4_237/a_40_246# 0
C25352 _103_ baud_inst.counter\[19\] 0
C25353 net45 _552_/a_257_140# 0
C25354 hold69/a_438_182# rx_inst.data_reg\[6\] 0
C25355 hold125/a_326_118# clknet_0_clk 0.01622f
C25356 _694_/a_1583_191# _701_/a_298_337# 0
C25357 _275_ _006_ 0.04909f
C25358 _101_ _688_/a_741_93# 0.00237f
C25359 rx_data[7] VPWR 0.04867f
C25360 _646_/a_298_337# clknet_4_12_0_clk 0.01894f
C25361 VPWR hold72/a_56_118# 0.0108f
C25362 _551_/a_76_160# _027_ 0.00206f
C25363 baud_inst.counter\[26\] _026_ 0.16586f
C25364 _093_ _681_/a_1583_191# 0.00939f
C25365 hold76/a_438_182# baud_inst.counter\[21\] 0.00821f
C25366 hold76/a_56_118# baud_inst.counter\[23\] 0
C25367 _697_/a_1583_191# FILLER_20_106/a_32_246# 0
C25368 _644_/a_2250_412# net150 0.00206f
C25369 _462_/a_22_110# net30 0
C25370 _462_/a_120_432# _266_ 0.00294f
C25371 clknet_4_5_0_clk _368_/a_257_140# 0
C25372 _678_/a_1489_191# _090_ 0
C25373 _637_/a_38_114# net47 0.00656f
C25374 _635_/a_1583_191# hold84/a_326_118# 0.00358f
C25375 VPWR _385_/a_46_156# 0.02673f
C25376 net133 _700_/a_681_505# 0
C25377 _028_ _700_/a_741_93# 0
C25378 _659_/a_843_236# tx_inst.data_reg\[1\] 0.0072f
C25379 hold162/a_56_118# _180_ 0
C25380 net30 hold81/a_56_118# 0.01846f
C25381 _170_ fanout28/a_40_152# 0.04934f
C25382 clknet_4_11_0_clk _703_/a_298_337# 0
C25383 net17 VPWR 0.23729f
C25384 tx_inst.data_reg\[1\] net43 0
C25385 FILLER_26_227/a_40_246# rx_inst.data_reg\[5\] 0
C25386 net49 _158_ 0.10593f
C25387 net128 net40 0.00167f
C25388 _645_/a_1840_334# net150 0.00106f
C25389 _663_/a_38_114# clknet_0_clk 0
C25390 _041_ _404_/a_46_156# 0.02526f
C25391 net131 _633_/a_132_114# 0
C25392 _372_/a_120_432# clknet_0_clk 0.00105f
C25393 _643_/a_324_432# clknet_0_clk 0.02162f
C25394 baud_inst.counter\[17\] net161 0
C25395 clkbuf_4_10_0_clk/a_27_118# _027_ 0.07837f
C25396 hold144/a_56_118# clknet_0_clk 0.00584f
C25397 hold168/a_438_182# _198_ 0.01197f
C25398 _143_ _653_/a_1785_429# 0
C25399 _013_ clkbuf_4_8_0_clk/a_27_118# 0.00162f
C25400 _642_/a_2250_412# net24 0.00381f
C25401 rx_data[0] clknet_4_13_0_clk 0
C25402 _675_/a_741_93# VPWR 0.02571f
C25403 clkload0/Y _280_ 0.00101f
C25404 hold98/a_438_182# net40 0
C25405 _270_ _047_ 0
C25406 _392_/a_59_156# FILLER_2_183/a_32_246# 0.01108f
C25407 _673_/a_1583_191# FILLER_5_59/a_40_246# 0
C25408 hold121/a_438_182# net120 0
C25409 hold121/a_56_118# _022_ 0.01614f
C25410 net99 _310_ 0.14951f
C25411 hold63/a_326_118# clk 0.06936f
C25412 clkbuf_4_8_0_clk/a_27_118# baud_inst.counter\[14\] 0.04157f
C25413 hold126/a_326_118# _637_/a_324_432# 0
C25414 hold126/a_438_182# _637_/a_38_114# 0
C25415 net45 fanout49/a_40_152# 0.00265f
C25416 _642_/a_324_432# _641_/a_324_432# 0
C25417 _642_/a_38_114# _641_/a_741_93# 0
C25418 _660_/a_2250_412# hold179/a_438_182# 0.00126f
C25419 hold119/a_56_118# _264_ 0.00117f
C25420 output16/a_40_152# _153_ 0
C25421 _641_/a_612_127# _262_ 0
C25422 _680_/a_741_93# net38 0.01184f
C25423 net101 _015_ 0
C25424 _687_/a_324_432# _308_ 0
C25425 hold99/a_438_182# _110_ 0
C25426 _126_ clknet_0_clk 0.00131f
C25427 net67 _702_/a_1583_191# 0.0159f
C25428 _671_/a_1583_191# _459_/a_27_156# 0.00228f
C25429 _190_ baud_inst.counter\[13\] 0.02464f
C25430 _080_ net62 0
C25431 _109_ clknet_4_9_0_clk 0
C25432 _699_/a_741_93# _311_ 0.00138f
C25433 net155 _658_/a_132_114# 0
C25434 _670_/a_1583_191# _670_/a_2250_412# 0
C25435 _662_/a_38_114# _200_ 0
C25436 _674_/a_2250_412# clknet_4_0_0_clk 0.04638f
C25437 _183_ FILLER_9_70/a_40_246# 0.00602f
C25438 net178 _688_/a_324_432# 0
C25439 _017_ _299_ 0
C25440 net102 net157 0
C25441 _636_/a_1840_334# VPWR 0.00144f
C25442 _127_ hold72/a_56_118# 0.01797f
C25443 hold180/a_438_182# net25 0
C25444 _632_/a_2250_412# _264_ 0.00161f
C25445 _654_/a_681_505# tx_inst.data_reg\[0\] 0
C25446 _064_ _090_ 0
C25447 _200_ tx_inst.state\[3\] 0
C25448 net36 hold176/a_326_118# 0
C25449 output18/a_40_152# rx_data[6] 0
C25450 hold76/a_56_118# _694_/a_1840_334# 0
C25451 _144_ _664_/a_612_127# 0
C25452 _195_ net168 0
C25453 _081_ VPWR 0.3532f
C25454 _171_ _479_/a_22_110# 0.02175f
C25455 _683_/a_741_93# net29 0.0051f
C25456 net26 _667_/a_1583_191# 0.00143f
C25457 net84 FILLER_19_228/a_40_246# 0.03325f
C25458 hold148/a_56_118# _106_ 0
C25459 _093_ _279_ 0
C25460 _673_/a_324_432# clknet_4_0_0_clk 0
C25461 _090_ net40 0
C25462 net128 _670_/a_38_114# 0
C25463 FILLER_16_176/a_40_246# _058_ 0
C25464 _661_/a_2250_412# net41 0
C25465 _664_/a_1489_191# tx_inst.state\[2\] 0.00109f
C25466 clknet_4_1_0_clk net41 1.30464f
C25467 net35 _234_ 0
C25468 hold162/a_56_118# net140 0
C25469 _692_/a_1785_429# VPWR 0
C25470 _127_ net17 0
C25471 _352_/a_268_412# hold95/a_56_118# 0
C25472 _678_/a_1785_429# baud_inst.counter\[6\] 0
C25473 _073_ net27 0.11233f
C25474 rx_inst.state\[3\] FILLER_15_127/a_32_246# 0
C25475 _486_/a_115_308# net166 0.00645f
C25476 _278_ _652_/a_741_93# 0
C25477 rx_inst.state\[3\] _652_/a_843_236# 0
C25478 _691_/a_38_114# hold164/a_56_118# 0
C25479 _691_/a_298_337# hold164/a_326_118# 0
C25480 _283_ clkbuf_4_3_0_clk/a_27_118# 0
C25481 _663_/a_1583_191# _666_/a_1583_191# 0
C25482 _663_/a_2250_412# output22/a_40_152# 0
C25483 hold172/a_438_182# _199_ 0
C25484 _686_/a_1785_429# net91 0
C25485 rx_data[7] _266_ 0
C25486 net30 hold72/a_326_118# 0
C25487 _032_ net105 0
C25488 _378_/a_59_156# net55 0.06414f
C25489 VPWR net130 0.08478f
C25490 _132_ _450_/a_127_436# 0.0031f
C25491 tx_inst.data_reg\[7\] _657_/a_843_236# 0
C25492 _489_/a_494_160# hold135/a_56_118# 0
C25493 clkload0/Y _191_ 0.00461f
C25494 net182 _676_/a_741_93# 0
C25495 VPWR net158 0.26667f
C25496 _180_ net141 0
C25497 _181_ _348_/a_248_122# 0.00189f
C25498 _659_/a_1583_191# VPWR 0.00526f
C25499 _644_/a_324_432# _158_ 0.00552f
C25500 _646_/a_843_236# _473_/a_22_110# 0
C25501 net2 _223_ 0.00676f
C25502 _075_ clkbuf_4_7_0_clk/a_27_118# 0.00232f
C25503 _294_ net29 0.0096f
C25504 _045_ net13 0.22065f
C25505 hold121/a_56_118# _108_ 0
C25506 _094_ hold117/a_438_182# 0
C25507 net37 clkbuf_4_6_0_clk/a_27_118# 0
C25508 _128_ VPWR 0.12274f
C25509 clknet_4_5_0_clk _144_ 0.78759f
C25510 hold98/a_56_118# _288_ 0.03057f
C25511 rx_data[2] hold83/a_326_118# 0
C25512 net14 hold83/a_438_182# 0
C25513 _480_/a_120_432# clknet_0_clk 0
C25514 FILLER_9_79/a_32_246# _291_ 0
C25515 _641_/a_1489_191# clknet_0_clk 0.00154f
C25516 net36 hold180/a_56_118# 0
C25517 _645_/a_38_114# _158_ 0
C25518 _654_/a_38_114# VPWR 0.00389f
C25519 _447_/a_81_118# _236_ 0
C25520 _698_/a_1840_334# net99 0.00178f
C25521 hold58/a_326_118# VPWR 0.00641f
C25522 _179_ clknet_4_11_0_clk 0.00106f
C25523 hold54/a_56_118# tx_start 0
C25524 FILLER_19_77/a_32_246# VPWR 0.06734f
C25525 _058_ _647_/a_843_236# 0.00181f
C25526 tx_inst.data_reg\[6\] _660_/a_2250_412# 0.02021f
C25527 VPWR _664_/a_681_505# 0
C25528 _707_/a_1583_191# VPWR 0.00349f
C25529 _206_ _656_/a_2250_412# 0.01344f
C25530 clknet_0_clk _684_/a_38_114# 0
C25531 _516_/a_279_412# net40 0
C25532 _041_ net62 0.02352f
C25533 net55 _665_/a_843_236# 0.01558f
C25534 _185_ net29 0.00111f
C25535 baud_inst.counter\[22\] _701_/a_681_505# 0
C25536 baud_inst.counter\[1\] _085_ 0
C25537 net39 _670_/a_324_432# 0
C25538 _432_/a_146_122# _170_ 0
C25539 rx_inst.data_reg\[2\] hold78/a_326_118# 0
C25540 clknet_4_8_0_clk VPWR 0.89581f
C25541 net2 _240_ 0
C25542 _467_/a_120_432# _156_ 0
C25543 _031_ hold134/a_438_182# 0
C25544 clknet_4_0_0_clk net29 0.01144f
C25545 _137_ net25 0.00158f
C25546 clknet_0_clk _066_ 0
C25547 net55 _166_ 0
C25548 _103_ FILLER_17_24/a_32_246# 0
C25549 _690_/a_741_93# baud_inst.counter\[16\] 0
C25550 net44 hold103/a_438_182# 0
C25551 _691_/a_1840_334# _692_/a_1583_191# 0
C25552 hold107/a_326_118# _701_/a_612_127# 0
C25553 clknet_4_12_0_clk rx_inst.bit_index\[2\] 0.13476f
C25554 _678_/a_2250_412# _677_/a_843_236# 0
C25555 clknet_0_clk _647_/a_1489_191# 0
C25556 FILLER_5_84/a_40_246# baud_inst.counter\[6\] 0
C25557 hold98/a_438_182# _682_/a_741_93# 0.00364f
C25558 hold98/a_326_118# _682_/a_843_236# 0
C25559 _009_ _682_/a_298_337# 0
C25560 hold159/a_56_118# _149_ 0.00118f
C25561 hold108/a_438_182# _186_ 0.02688f
C25562 hold63/a_326_118# net2 0
C25563 net14 _634_/a_681_505# 0
C25564 rx_data[2] _634_/a_843_236# 0
C25565 fanout35/a_40_152# net175 0
C25566 _396_/a_257_140# VPWR 0
C25567 net87 FILLER_16_56/a_32_246# 0
C25568 clknet_4_15_0_clk _649_/a_38_114# 0.01019f
C25569 _073_ _706_/a_298_337# 0
C25570 _662_/a_2250_412# _706_/a_2250_412# 0
C25571 _662_/a_298_337# _119_ 0.00194f
C25572 _680_/a_1840_334# hold115/a_438_182# 0
C25573 net87 _356_/a_146_122# 0
C25574 _699_/a_1840_334# baud_inst.counter\[29\] 0
C25575 _206_ _382_/a_285_412# 0.00306f
C25576 baud_inst.counter\[28\] FILLER_25_36/a_32_246# 0
C25577 hold65/a_438_182# VPWR 0.00524f
C25578 _639_/a_2250_412# _668_/a_1583_191# 0.00218f
C25579 _639_/a_1583_191# _668_/a_2250_412# 0.00218f
C25580 _636_/a_1840_334# _266_ 0.00168f
C25581 _636_/a_2250_412# net30 0.00155f
C25582 clknet_4_14_0_clk _648_/a_612_127# 0.00983f
C25583 _682_/a_38_114# clknet_4_2_0_clk 0.00322f
C25584 _642_/a_1840_334# VPWR 0.0033f
C25585 _305_ _694_/a_612_127# 0
C25586 hold53/a_326_118# net53 0.00489f
C25587 VPWR net5 0.02822f
C25588 _672_/a_1489_191# _086_ 0
C25589 _135_ _161_ 0
C25590 _222_ clkbuf_4_4_0_clk/a_27_118# 0
C25591 net141 net140 0.00828f
C25592 _091_ _352_/a_46_156# 0
C25593 _392_/a_59_156# _071_ 0
C25594 _392_/a_382_118# net41 0.01303f
C25595 _081_ _266_ 0.0022f
C25596 _671_/a_1840_334# VPWR 0.02483f
C25597 _358_/a_72_436# VPWR 0.03843f
C25598 net131 _158_ 0.07186f
C25599 _660_/a_1489_191# VPWR 0.00175f
C25600 _224_ clknet_0_clk 0.02168f
C25601 _267_ _638_/a_298_337# 0
C25602 _230_ net52 0.48593f
C25603 _635_/a_741_93# FILLER_19_228/a_40_246# 0.00104f
C25604 tx_inst.bit_index\[0\] _217_ 0
C25605 _390_/a_382_118# _655_/a_843_236# 0.00104f
C25606 _083_ _670_/a_612_127# 0
C25607 VPWR _686_/a_1840_334# 0.00202f
C25608 _637_/a_843_236# _634_/a_843_236# 0
C25609 hold52/a_438_182# net52 0.00691f
C25610 _378_/a_59_156# _389_/a_46_156# 0
C25611 hold168/a_326_118# clkbuf_4_5_0_clk/a_27_118# 0.00481f
C25612 net48 _647_/a_38_114# 0.02312f
C25613 _127_ _128_ 0.2932f
C25614 _021_ VPWR 0.2326f
C25615 net35 _233_ 0
C25616 _348_/a_146_122# _066_ 0
C25617 FILLER_3_177/a_32_246# _196_ 0
C25618 _364_/a_155_412# _197_ 0.01941f
C25619 net39 _682_/a_843_236# 0.00128f
C25620 _174_ tx_inst.bit_index\[2\] 0
C25621 hold183/a_56_118# clknet_4_6_0_clk 0
C25622 fanout39/a_40_152# net158 0
C25623 baud_inst.counter\[31\] _703_/a_1785_429# 0.0032f
C25624 baud_inst.counter\[28\] _703_/a_612_127# 0
C25625 baud_inst.counter\[27\] baud_inst.counter\[31\] 0
C25626 net79 _672_/a_612_127# 0
C25627 hold118/a_56_118# net51 0
C25628 hold87/a_56_118# net87 0.00192f
C25629 net37 hold62/a_438_182# 0.00639f
C25630 input3/a_40_152# net165 0.00104f
C25631 net3 _388_/a_496_118# 0
C25632 _661_/a_1489_191# clknet_4_1_0_clk 0.0159f
C25633 _661_/a_324_432# tx_inst.data_reg\[7\] 0.02201f
C25634 net27 net41 0
C25635 net26 _650_/a_38_114# 0.00303f
C25636 _265_ _047_ 0
C25637 tx_inst.data_reg\[4\] _360_/a_886_118# 0
C25638 _147_ net41 0.08178f
C25639 hold104/a_56_118# net101 0.0015f
C25640 hold112/a_438_182# VPWR 0.01087f
C25641 _075_ _216_ 0
C25642 _118_ hold172/a_326_118# 0
C25643 hold63/a_438_182# _080_ 0.00351f
C25644 _691_/a_1583_191# _103_ 0
C25645 _640_/a_843_236# rx_inst.bit_index\[0\] 0
C25646 net179 _654_/a_298_337# 0
C25647 hold179/a_438_182# _654_/a_843_236# 0
C25648 _353_/a_146_122# baud_inst.counter\[4\] 0
C25649 _344_/a_150_412# _308_ 0
C25650 hold165/a_326_118# tx_inst.data_reg\[0\] 0.00359f
C25651 _646_/a_1583_191# clknet_4_12_0_clk 0.00538f
C25652 _089_ _351_/a_268_412# 0
C25653 fanout40/a_40_152# _688_/a_324_432# 0
C25654 hold124/a_326_118# net65 0
C25655 _655_/a_298_337# _145_ 0.0053f
C25656 net163 _301_ 0
C25657 _128_ _266_ 0.01069f
C25658 fanout35/a_40_152# _161_ 0
C25659 net92 FILLER_8_63/a_40_246# 0.00268f
C25660 baud_inst.counter\[12\] _281_ 0
C25661 hold132/a_326_118# _159_ 0.01857f
C25662 net36 _229_ 0.6277f
C25663 _378_/a_496_118# _209_ 0.00323f
C25664 _677_/a_298_337# net40 0
C25665 _153_ clknet_4_6_0_clk 0.00227f
C25666 net2 _261_ 0
C25667 _264_ hold70/a_56_118# 0.007f
C25668 _550_/a_209_168# net134 0
C25669 net133 _700_/a_550_127# 0
C25670 rx_inst.state\[3\] _409_/a_73_118# 0.02447f
C25671 hold65/a_438_182# _127_ 0
C25672 baud_inst.counter\[8\] FILLER_6_54/a_32_246# 0.01379f
C25673 _290_ _684_/a_843_236# 0
C25674 net166 clkbuf_0_clk/a_116_82# 0.01033f
C25675 clknet_4_11_0_clk _703_/a_1583_191# 0.00488f
C25676 net179 net21 0.00149f
C25677 _522_/a_474_130# _015_ 0
C25678 net142 net162 0
C25679 _051_ _130_ 0.00228f
C25680 net30 _157_ 0.00237f
C25681 hold151/a_438_182# VPWR 0.00513f
C25682 hold74/a_438_182# rx_data[7] 0.00453f
C25683 _107_ _693_/a_1583_191# 0.00275f
C25684 FILLER_6_191/a_32_246# net168 0.00356f
C25685 _663_/a_1840_334# clknet_0_clk 0.00515f
C25686 _228_ net29 0.23977f
C25687 hold131/a_326_118# net78 0.00625f
C25688 _216_ _651_/a_38_114# 0
C25689 _374_/a_244_412# VPWR 0
C25690 rx_data[4] clknet_4_13_0_clk 0.01033f
C25691 _284_ baud_inst.counter\[4\] 0.28345f
C25692 _132_ net175 0
C25693 _427_/a_350_122# _244_ -0
C25694 _661_/a_1840_334# FILLER_0_130/a_32_246# 0
C25695 _675_/a_1785_429# VPWR 0
C25696 net62 FILLER_14_185/a_32_246# 0
C25697 clknet_0_clk _235_ 0
C25698 baud_inst.counter\[30\] hold113/a_438_182# 0
C25699 _179_ hold113/a_326_118# 0
C25700 tx_data[2] VPWR 0.01803f
C25701 net33 _202_ 0
C25702 _282_ hold93/a_438_182# 0.0084f
C25703 _688_/a_132_114# net161 0
C25704 net44 net49 0.35632f
C25705 _117_ net50 0.67329f
C25706 _157_ _647_/a_324_432# 0.01467f
C25707 hold56/a_56_118# _142_ 0
C25708 _223_ _169_ 0.05886f
C25709 _698_/a_1583_191# net140 0
C25710 net48 _448_/a_244_412# 0
C25711 _642_/a_298_337# _641_/a_612_127# 0
C25712 hold65/a_438_182# _266_ 0.001f
C25713 clknet_4_12_0_clk net64 0.00127f
C25714 _642_/a_741_93# _641_/a_1840_334# 0
C25715 _642_/a_843_236# _641_/a_1583_191# 0
C25716 net176 _262_ 0
C25717 _052_ _131_ 0
C25718 _368_/a_257_140# _199_ 0
C25719 _476_/a_248_122# _274_ 0
C25720 VPWR _402_/a_154_118# 0
C25721 net159 net38 0.78884f
C25722 hold153/a_56_118# net153 0
C25723 _002_ FILLER_15_116/a_40_246# 0
C25724 _411_/a_115_308# _261_ 0
C25725 _687_/a_2250_412# _308_ 0
C25726 _463_/a_120_432# VPWR 0
C25727 _555_/a_380_412# net68 0.00125f
C25728 net67 _702_/a_2002_114# 0
C25729 _671_/a_1840_334# _266_ 0.00228f
C25730 _671_/a_2250_412# net30 0.00139f
C25731 _671_/a_1785_429# _000_ 0
C25732 hold126/a_56_118# clknet_0_clk 0
C25733 net79 net136 0
C25734 _354_/a_170_412# baud_inst.counter\[16\] 0
C25735 _675_/a_324_432# net60 0
C25736 net178 _688_/a_2250_412# 0.015f
C25737 _114_ _701_/a_843_236# 0.00175f
C25738 FILLER_9_79/a_32_246# baud_inst.counter\[4\] 0.00476f
C25739 _079_ hold122/a_438_182# 0
C25740 net39 _281_ 0.01503f
C25741 hold101/a_438_182# _017_ 0.00137f
C25742 baud_inst.counter\[18\] hold102/a_438_182# 0
C25743 _489_/a_358_436# _038_ 0.00101f
C25744 _653_/a_2250_412# clknet_0_clk 0
C25745 FILLER_12_89/a_40_246# _281_ 0.01979f
C25746 _240_ _169_ 0.07243f
C25747 hold171/a_56_118# net171 0
C25748 _679_/a_741_93# _037_ 0.00106f
C25749 _234_ _416_/a_146_122# 0.00336f
C25750 _642_/a_1583_191# _260_ 0
C25751 hold114/a_438_182# net49 0
C25752 clknet_4_11_0_clk hold113/a_56_118# 0
C25753 output16/a_40_152# net28 0
C25754 net49 FILLER_18_158/a_40_246# 0.00112f
C25755 hold173/a_56_118# net183 0
C25756 _683_/a_1785_429# net29 0
C25757 clknet_4_1_0_clk _672_/a_2250_412# 0
C25758 _673_/a_2250_412# clknet_4_0_0_clk 0.008f
C25759 _344_/a_150_412# _177_ 0
C25760 _344_/a_252_412# baud_inst.counter\[26\] 0.00219f
C25761 _232_ _447_/a_277_118# 0.00252f
C25762 _448_/a_244_140# _259_ 0
C25763 _344_/a_354_412# baud_inst.counter\[27\] 0.00144f
C25764 _296_ _521_/a_170_412# 0
C25765 _511_/a_150_412# _182_ 0.00135f
C25766 _640_/a_2250_412# net32 0
C25767 net109 baud_inst.counter\[9\] 0
C25768 hold74/a_438_182# _636_/a_1840_334# 0.00107f
C25769 net74 _636_/a_843_236# 0.02101f
C25770 VPWR _687_/a_324_432# 0.00652f
C25771 hold178/a_56_118# net178 0
C25772 _153_ net29 0.01052f
C25773 FILLER_16_70/a_40_246# net87 0.00316f
C25774 _075_ _666_/a_843_236# 0.00102f
C25775 _080_ rx_inst.state\[3\] 0.15148f
C25776 _044_ net150 0.03475f
C25777 _655_/a_38_114# VPWR 0.00957f
C25778 FILLER_15_17/a_40_246# baud_inst.counter\[17\] 0.00522f
C25779 hold74/a_56_118# net48 0.02358f
C25780 _178_ _703_/a_38_114# 0
C25781 _378_/a_496_118# _207_ 0
C25782 _519_/a_175_118# baud_inst.counter\[12\] 0.00121f
C25783 _519_/a_81_118# net128 0.03008f
C25784 _132_ _161_ 0.12766f
C25785 _264_ _648_/a_1489_191# 0.01208f
C25786 net37 _242_ 0
C25787 _206_ FILLER_6_205/a_40_246# 0.00909f
C25788 _663_/a_38_114# net43 0.00208f
C25789 hold88/a_56_118# baud_inst.counter\[12\] 0.00371f
C25790 hold155/a_56_118# _384_/a_382_118# 0
C25791 net50 net11 0
C25792 _118_ net54 0
C25793 _644_/a_2250_412# _158_ 0.05365f
C25794 _689_/a_2250_412# baud_inst.counter\[16\] 0
C25795 hold166/a_326_118# net49 0.00102f
C25796 net45 _700_/a_132_114# 0
C25797 _032_ hold58/a_438_182# 0.00223f
C25798 _214_ tx_inst.data_reg\[0\] 0.28681f
C25799 _193_ clknet_4_4_0_clk 0.03382f
C25800 hold57/a_56_118# net56 0.02771f
C25801 net42 _497_/a_170_412# 0
C25802 VPWR _688_/a_843_236# 0.021f
C25803 hold142/a_56_118# _697_/a_38_114# 0.00116f
C25804 net136 net116 0
C25805 _486_/a_494_160# _205_ 0
C25806 net109 hold109/a_438_182# 0
C25807 _292_ hold109/a_326_118# 0
C25808 _010_ hold109/a_56_118# 0
C25809 _223_ _084_ 0
C25810 _306_ _695_/a_324_432# 0
C25811 baud_inst.counter\[22\] _695_/a_741_93# 0.01773f
C25812 baud_inst.counter\[23\] _695_/a_843_236# 0.0391f
C25813 baud_inst.counter\[28\] _556_/a_435_412# 0.00165f
C25814 baud_inst.counter\[31\] _556_/a_192_429# 0
C25815 net92 VPWR 0.15046f
C25816 net6 net7 0
C25817 net98 net116 0
C25818 _499_/a_209_168# _280_ 0.00225f
C25819 _519_/a_81_118# _014_ 0
C25820 _464_/a_22_110# net71 0.00463f
C25821 FILLER_27_194/a_40_246# _264_ 0.0078f
C25822 _464_/a_120_432# _268_ 0.00217f
C25823 _660_/a_843_236# clk 0.02249f
C25824 _645_/a_1840_334# _158_ 0.00139f
C25825 _654_/a_1840_334# VPWR 0.00131f
C25826 FILLER_8_21/a_32_246# _681_/a_324_432# 0
C25827 hold88/a_56_118# net88 0
C25828 net16 rx_inst.data_reg\[4\] 0
C25829 _675_/a_38_114# _088_ 0.05658f
C25830 tx_inst.data_reg\[0\] FILLER_3_177/a_32_246# 0
C25831 hold153/a_438_182# _162_ 0.00123f
C25832 hold153/a_56_118# _280_ 0.02108f
C25833 _411_/a_358_436# clknet_0_clk 0
C25834 _634_/a_1489_191# clknet_4_15_0_clk 0.02446f
C25835 net92 _499_/a_474_130# 0
C25836 _283_ _499_/a_380_412# 0.02594f
C25837 _058_ _647_/a_612_127# 0.00146f
C25838 VPWR _664_/a_550_127# 0
C25839 _663_/a_1583_191# _215_ 0
C25840 clknet_0_clk _684_/a_1840_334# 0.04296f
C25841 _451_/a_257_140# net175 0.00145f
C25842 rx_inst.data_reg\[3\] hold143/a_438_182# 0.00114f
C25843 _466_/a_22_110# _240_ 0.00293f
C25844 net55 _665_/a_612_127# 0.02717f
C25845 _283_ hold153/a_438_182# 0
C25846 _651_/a_741_93# FILLER_9_169/a_32_246# 0
C25847 net155 net6 0
C25848 _283_ hold93/a_56_118# 0
C25849 net94 hold93/a_438_182# 0
C25850 net92 hold93/a_326_118# 0.00595f
C25851 hold107/a_326_118# net107 0.00462f
C25852 FILLER_2_110/a_32_246# net159 0.00209f
C25853 _653_/a_324_432# net43 0.03251f
C25854 _663_/a_1840_334# hold146/a_56_118# 0
C25855 _678_/a_324_432# net154 0
C25856 _663_/a_1583_191# hold146/a_326_118# 0
C25857 _240_ _084_ 0
C25858 FILLER_0_128/a_40_246# _384_/a_382_118# 0.01053f
C25859 net179 FILLER_2_208/a_40_246# 0.00234f
C25860 tx_inst.data_reg\[0\] FILLER_3_150/a_40_246# 0
C25861 net98 _682_/a_132_114# 0
C25862 _007_ _666_/a_324_432# 0.00324f
C25863 _166_ _666_/a_681_505# 0
C25864 _009_ _682_/a_1583_191# 0.02564f
C25865 net42 _200_ 0
C25866 net2 _704_/a_38_114# 0
C25867 hold119/a_56_118# _153_ 0
C25868 hold89/a_326_118# net87 0.03272f
C25869 rx_data[2] _634_/a_612_127# 0
C25870 _551_/a_76_160# net49 0.00665f
C25871 _505_/a_170_160# net135 0
C25872 _505_/a_76_160# _287_ 0.00293f
C25873 hold130/a_56_118# _186_ 0
C25874 _463_/a_22_110# net30 0.02106f
C25875 _636_/a_38_114# hold73/a_326_118# 0
C25876 _636_/a_324_432# hold73/a_56_118# 0
C25877 clknet_4_15_0_clk _649_/a_1840_334# 0.00975f
C25878 net26 fanout37/a_40_152# 0
C25879 net87 baud_inst.counter\[13\] 0
C25880 baud_inst.counter\[14\] _684_/a_741_93# 0
C25881 _490_/a_139_160# _038_ 0
C25882 _206_ net137 0.04168f
C25883 clknet_4_7_0_clk _168_ 0
C25884 _431_/a_81_118# FILLER_17_162/a_32_246# 0
C25885 _267_ _049_ 0.00423f
C25886 _350_/a_279_412# net29 0
C25887 clknet_4_13_0_clk _668_/a_843_236# 0
C25888 _639_/a_741_93# rx_inst.state\[1\] 0.00677f
C25889 rx_inst.data_reg\[1\] _633_/a_324_432# 0
C25890 baud_inst.counter\[0\] _086_ 0.04888f
C25891 hold149/a_56_118# VPWR 0.03103f
C25892 _023_ _107_ 0
C25893 _392_/a_382_118# _392_/a_496_118# 0
C25894 FILLER_8_118/a_32_246# _652_/a_38_114# 0
C25895 _041_ rx_inst.state\[3\] 0
C25896 net37 FILLER_16_203/a_32_246# 0
C25897 _699_/a_298_337# net46 0
C25898 _698_/a_324_432# _130_ 0
C25899 tx_inst.data_reg\[5\] _339_/a_886_118# 0.02083f
C25900 hold123/a_438_182# VPWR 0.00559f
C25901 _134_ _242_ 0.06135f
C25902 net49 _302_ 0.05238f
C25903 _671_/a_741_93# _417_/a_22_110# 0
C25904 net49 _690_/a_1840_334# 0.02843f
C25905 hold66/a_438_182# clknet_4_13_0_clk 0.01157f
C25906 hold177/a_326_118# net128 0.00345f
C25907 hold177/a_438_182# baud_inst.counter\[12\] 0.02366f
C25908 _267_ _638_/a_1583_191# 0.00136f
C25909 _637_/a_1840_334# _634_/a_1583_191# 0.00154f
C25910 hold120/a_438_182# net45 0
C25911 net118 _668_/a_1840_334# 0
C25912 _378_/a_382_118# _213_ 0
C25913 net26 _176_ 0
C25914 baud_inst.counter\[8\] _505_/a_272_160# 0
C25915 _171_ net27 0.37132f
C25916 FILLER_12_166/a_40_246# net2 0
C25917 net35 _407_/a_146_122# 0
C25918 net48 _647_/a_1840_334# 0.01138f
C25919 rx net19 0
C25920 baud_inst.counter\[28\] net59 0.4742f
C25921 _661_/a_550_127# _072_ 0
C25922 _661_/a_2250_412# tx_inst.data_reg\[7\] 0.01787f
C25923 _689_/a_843_236# net157 0
C25924 _702_/a_38_114# net68 0.03609f
C25925 _702_/a_324_432# _115_ 0.03863f
C25926 tx_inst.data_reg\[7\] clknet_4_1_0_clk 0.51893f
C25927 hold153/a_56_118# _191_ 0
C25928 net87 _544_/a_46_156# 0
C25929 _547_/a_379_118# _165_ 0
C25930 _117_ _705_/a_38_114# 0.03082f
C25931 _222_ VPWR 0.03421f
C25932 FILLER_19_139/a_40_246# clknet_0_clk 0.00162f
C25933 baud_inst.counter\[23\] baud_inst.counter\[25\] -0
C25934 _092_ _287_ 0.00623f
C25935 _691_/a_550_127# clknet_4_8_0_clk 0
C25936 hold179/a_56_118# _654_/a_1489_191# 0
C25937 baud_inst.counter\[1\] baud_inst.counter\[3\] 0
C25938 net179 _654_/a_1583_191# 0
C25939 _184_ _282_ 0
C25940 _677_/a_1840_334# _142_ 0.00128f
C25941 baud_inst.counter\[27\] _308_ 0
C25942 _694_/a_741_93# net107 0.00127f
C25943 hold66/a_326_118# _122_ 0.01581f
C25944 hold97/a_438_182# hold115/a_326_118# 0
C25945 hold97/a_326_118# hold115/a_438_182# 0
C25946 _357_/a_354_412# net29 0
C25947 hold85/a_326_118# _269_ 0
C25948 _655_/a_1583_191# _145_ 0
C25949 output21/a_40_152# tx_inst.state\[4\] 0
C25950 tx hold146/a_326_118# 0
C25951 rx hold51/a_326_118# 0
C25952 net2 hold51/a_56_118# 0.00374f
C25953 FILLER_6_205/a_40_246# _202_ 0
C25954 tx_inst.data_reg\[6\] hold165/a_56_118# 0.05264f
C25955 tx_inst.bit_index\[1\] clknet_0_clk 0.74157f
C25956 hold91/a_326_118# net91 0
C25957 _690_/a_843_236# FILLER_17_22/a_40_246# 0
C25958 clknet_0_clk _649_/a_298_337# 0.00829f
C25959 input11/a_40_152# FILLER_8_236/a_40_246# 0.00183f
C25960 hold65/a_56_118# _043_ 0
C25961 _290_ _684_/a_612_127# 0
C25962 _415_/a_170_412# fanout28/a_40_152# 0
C25963 _646_/a_324_432# VPWR 0.02881f
C25964 VPWR _210_ 0.13582f
C25965 baud_inst.counter\[7\] _678_/a_38_114# 0.01294f
C25966 clknet_4_3_0_clk _678_/a_324_432# 0.01318f
C25967 _346_/a_252_412# _027_ 0
C25968 net3 _656_/a_38_114# 0
C25969 tx_data[0] _656_/a_324_432# 0
C25970 _650_/a_324_432# rx_inst.data_reg\[7\] 0
C25971 hold77/a_56_118# _271_ 0
C25972 _344_/a_150_412# VPWR 0
C25973 _216_ _651_/a_1840_334# 0
C25974 VPWR _703_/a_741_93# 0.01682f
C25975 net41 _388_/a_285_412# 0
C25976 hold152/a_56_118# _652_/a_38_114# 0
C25977 _635_/a_843_236# _156_ 0
C25978 input4/a_40_152# input6/a_40_152# 0.0015f
C25979 _126_ clkbuf_4_13_0_clk/a_27_118# 0
C25980 hold85/a_56_118# _156_ 0.0101f
C25981 _178_ clknet_4_11_0_clk 0.06855f
C25982 net50 _006_ 0.00354f
C25983 hold66/a_56_118# net111 0
C25984 _282_ FILLER_9_72/a_32_246# 0
C25985 net156 hold157/a_326_118# 0.0053f
C25986 net28 clknet_4_6_0_clk 0
C25987 clknet_4_0_0_clk _288_ 0
C25988 hold151/a_56_118# _236_ 0
C25989 _157_ _647_/a_2250_412# 0.00574f
C25990 _044_ _633_/a_132_114# 0
C25991 _552_/a_155_412# FILLER_27_46/a_32_246# 0.0055f
C25992 hold169/a_56_118# _215_ 0
C25993 clkbuf_0_clk/a_116_82# clknet_4_9_0_clk 0.00849f
C25994 net176 _697_/a_550_127# 0
C25995 FILLER_26_88/a_40_246# hold67/a_326_118# 0
C25996 net100 _263_ 0.01422f
C25997 hold126/a_56_118# _048_ 0.00135f
C25998 hold147/a_438_182# _693_/a_1583_191# 0
C25999 hold147/a_326_118# _693_/a_1840_334# 0.0017f
C26000 _398_/a_358_436# _397_/a_279_412# 0
C26001 _194_ _216_ 0
C26002 _053_ _641_/a_38_114# 0
C26003 _642_/a_298_337# net176 0.0028f
C26004 _642_/a_38_114# _052_ 0
C26005 clknet_4_5_0_clk net179 0.15121f
C26006 net120 _694_/a_324_432# 0
C26007 net147 _105_ 0.00489f
C26008 _105_ net46 0
C26009 _705_/a_38_114# net11 0
C26010 _341_/a_805_385# tx_inst.data_reg\[2\] 0
C26011 _341_/a_295_385# clknet_4_4_0_clk 0.00286f
C26012 _248_ _058_ 0
C26013 net49 hold106/a_56_118# 0.00314f
C26014 clk _120_ 0
C26015 baud_inst.counter\[8\] _502_/a_165_412# 0
C26016 _228_ net122 0
C26017 net44 FILLER_17_81/a_32_246# 0.00175f
C26018 _538_/a_81_118# _108_ 0.0926f
C26019 _548_/a_272_160# _310_ 0
C26020 _268_ VPWR 0.09265f
C26021 tx_inst.bit_index\[1\] _386_/a_59_156# 0
C26022 baud_inst.counter\[13\] _685_/a_324_432# 0.01098f
C26023 _295_ _296_ 0.12232f
C26024 hold162/a_438_182# net46 0.03506f
C26025 clknet_4_10_0_clk _106_ 0.0199f
C26026 _158_ _471_/a_22_110# 0.00415f
C26027 _646_/a_324_432# net144 0.00395f
C26028 _675_/a_2250_412# net60 0.00289f
C26029 _675_/a_1840_334# _181_ 0
C26030 VPWR _473_/a_22_110# 0
C26031 _114_ _701_/a_612_127# 0
C26032 _206_ FILLER_0_163/a_32_246# 0.01408f
C26033 net48 hold144/a_438_182# 0.05086f
C26034 rx_data[6] _264_ 0
C26035 tx_inst.data_reg\[4\] _148_ 0.0023f
C26036 _679_/a_1489_191# net29 0.0014f
C26037 rx_inst.bit_index\[2\] _449_/a_27_156# 0
C26038 _676_/a_843_236# _281_ 0
C26039 clkbuf_4_8_0_clk/a_27_118# _687_/a_843_236# 0.00152f
C26040 _264_ hold84/a_56_118# 0.00118f
C26041 _699_/a_38_114# _312_ 0
C26042 net18 _637_/a_1489_191# 0.00209f
C26043 _699_/a_298_337# _313_ 0.03453f
C26044 hold122/a_56_118# net43 0.01659f
C26045 _098_ hold90/a_326_118# 0
C26046 FILLER_7_121/a_40_246# VPWR 0.16313f
C26047 tx_inst.data_reg\[6\] _654_/a_612_127# 0
C26048 _096_ net29 0.03334f
C26049 hold162/a_56_118# _697_/a_298_337# 0
C26050 baud_inst.counter\[27\] _177_ 0.01381f
C26051 _457_/a_22_110# hold73/a_438_182# 0
C26052 _421_/a_252_412# net24 0
C26053 hold183/a_56_118# net122 0
C26054 _663_/a_741_93# clkload1/Y 0
C26055 VPWR _687_/a_2250_412# 0.00424f
C26056 rx_data[7] hold73/a_326_118# 0.00189f
C26057 net74 _636_/a_612_127# 0.00531f
C26058 _112_ _547_/a_81_118# 0
C26059 clknet_4_7_0_clk _666_/a_2250_412# 0
C26060 clknet_4_7_0_clk tx_busy 0.49403f
C26061 _296_ clknet_4_2_0_clk 0.00323f
C26062 clknet_4_13_0_clk _635_/a_324_432# 0.01879f
C26063 _679_/a_1840_334# net40 0
C26064 _655_/a_1840_334# VPWR 0.00811f
C26065 clkbuf_4_2_0_clk/a_27_118# _684_/a_741_93# 0.00112f
C26066 net32 _419_/a_154_118# 0
C26067 _264_ rx_inst.data_reg\[5\] 0.00282f
C26068 _077_ _665_/a_741_93# 0.00226f
C26069 hold96/a_326_118# _037_ 0
C26070 hold86/a_438_182# baud_inst.counter\[1\] 0.00348f
C26071 _663_/a_1840_334# net43 0.01508f
C26072 _355_/a_252_412# baud_inst.counter\[19\] 0.00176f
C26073 baud_inst.counter\[31\] FILLER_23_83/a_32_246# 0
C26074 hold134/a_326_118# _700_/a_298_337# 0.00282f
C26075 VPWR _688_/a_612_127# 0.002f
C26076 _092_ clkbuf_4_0_0_clk/a_27_118# 0.00962f
C26077 _652_/a_132_114# net152 0
C26078 clkbuf_4_1_0_clk/a_27_118# _385_/a_46_156# 0
C26079 FILLER_12_166/a_40_246# _169_ 0
C26080 net26 clkbuf_4_6_0_clk/a_27_118# 0.03093f
C26081 net28 net29 0.09333f
C26082 baud_inst.counter\[23\] _695_/a_612_127# 0.00263f
C26083 baud_inst.counter\[22\] _695_/a_1785_429# 0
C26084 baud_inst.counter\[23\] baud_inst.counter\[24\] -0
C26085 _241_ _436_/a_244_412# 0.00152f
C26086 baud_inst.counter\[30\] net58 0.05718f
C26087 baud_inst.counter\[28\] _032_ 0.16487f
C26088 baud_inst.counter\[31\] _316_ 0.00921f
C26089 _095_ net116 0
C26090 net37 net118 0
C26091 clknet_4_14_0_clk _244_ 0.08372f
C26092 _127_ _268_ 0.03989f
C26093 _633_/a_1840_334# net77 0.00127f
C26094 _660_/a_612_127# clk 0
C26095 baud_inst.counter\[24\] _100_ 0
C26096 _201_ _369_/a_146_122# 0
C26097 _202_ _369_/a_248_122# 0
C26098 net48 fanout48/a_40_152# 0.01127f
C26099 _230_ clknet_0_clk 0.03413f
C26100 _058_ net139 0.02799f
C26101 _646_/a_741_93# _647_/a_324_432# 0
C26102 _646_/a_324_432# _647_/a_741_93# 0
C26103 clknet_4_3_0_clk hold137/a_56_118# 0
C26104 net39 _494_/a_165_412# 0
C26105 net167 hold90/a_438_182# 0
C26106 fanout43/a_40_152# _205_ 0
C26107 net173 _363_/a_22_110# 0
C26108 _361_/a_248_122# _194_ 0
C26109 FILLER_8_14/a_32_246# _681_/a_38_114# 0
C26110 net173 _007_ 0
C26111 hold178/a_438_182# VPWR 0.00208f
C26112 _294_ FILLER_14_72/a_32_246# 0.00184f
C26113 net146 net27 0.00596f
C26114 _041_ _671_/a_298_337# 0
C26115 hold149/a_438_182# _106_ 0.00483f
C26116 FILLER_14_148/a_40_246# _667_/a_741_93# 0
C26117 _103_ baud_inst.counter\[16\] 0
C26118 _390_/a_382_118# _390_/a_496_118# 0
C26119 _095_ _682_/a_132_114# 0
C26120 _663_/a_1785_429# tx_inst.state\[4\] 0
C26121 _025_ net46 0.07101f
C26122 net98 _682_/a_1489_191# 0
C26123 _166_ _666_/a_550_127# -0
C26124 hold98/a_56_118# clknet_4_2_0_clk 0
C26125 _676_/a_2250_412# _670_/a_843_236# 0
C26126 net2 _704_/a_1840_334# 0.02855f
C26127 rx _704_/a_2250_412# 0.00967f
C26128 hold121/a_56_118# _302_ 0
C26129 _637_/a_1583_191# hold71/a_56_118# 0.00308f
C26130 rx_data[2] net83 0
C26131 _178_ hold113/a_326_118# 0
C26132 net118 _650_/a_298_337# 0
C26133 _268_ _266_ 0.29324f
C26134 _048_ hold83/a_438_182# 0.0015f
C26135 _358_/a_411_436# _186_ 0
C26136 _339_/a_71_118# tx_inst.data_reg\[1\] 0.03364f
C26137 net26 _276_ 0.34407f
C26138 tx_data[4] _213_ 0.00117f
C26139 _266_ _473_/a_22_110# 0
C26140 _639_/a_1785_429# rx_inst.state\[1\] 0
C26141 _634_/a_324_432# hold72/a_56_118# 0
C26142 _634_/a_1583_191# hold82/a_56_118# 0
C26143 _699_/a_1583_191# net46 0.01566f
C26144 _227_ net26 0.05681f
C26145 FILLER_4_183/a_40_246# net54 0
C26146 _403_/a_120_432# _221_ 0
C26147 _230_ hold166/a_438_182# 0
C26148 hold112/a_438_182# _232_ 0
C26149 hold112/a_326_118# _133_ 0
C26150 _170_ _231_ 0.05403f
C26151 _672_/a_324_432# clknet_4_0_0_clk 0.02288f
C26152 _176_ FILLER_5_181/a_32_246# 0.00599f
C26153 _671_/a_843_236# _140_ 0
C26154 _227_ net32 0
C26155 net53 VPWR 0.34132f
C26156 _100_ FILLER_15_42/a_40_246# 0
C26157 net28 hold119/a_56_118# 0.00159f
C26158 _128_ _638_/a_1489_191# 0
C26159 _390_/a_382_118# _145_ 0.00188f
C26160 net72 _634_/a_843_236# 0
C26161 _048_ _634_/a_681_505# 0
C26162 net17 _634_/a_324_432# 0
C26163 _206_ _213_ 0.18552f
C26164 _023_ hold147/a_438_182# 0.00178f
C26165 FILLER_7_40/a_32_246# _681_/a_2250_412# 0.01061f
C26166 net2 _707_/a_681_505# 0
C26167 hold138/a_438_182# _635_/a_843_236# 0
C26168 _359_/a_120_432# net168 0
C26169 _705_/a_324_432# _275_ 0
C26170 FILLER_12_166/a_40_246# _084_ 0.00486f
C26171 net26 hold62/a_438_182# 0
C26172 _044_ _158_ 0.01214f
C26173 baud_inst.counter\[22\] net120 0.03326f
C26174 _438_/a_146_122# net24 0.00237f
C26175 _117_ _705_/a_1840_334# 0
C26176 FILLER_16_203/a_32_246# _650_/a_1583_191# 0
C26177 net47 hold72/a_438_182# 0
C26178 clknet_4_11_0_clk net133 0.02634f
C26179 net143 _647_/a_1840_334# 0
C26180 _080_ _205_ 0
C26181 _515_/a_76_160# VPWR 0.00695f
C26182 _116_ _702_/a_1583_191# 0
C26183 hold179/a_56_118# tx_inst.data_reg\[0\] 0.05549f
C26184 _125_ FILLER_18_210/a_32_246# 0
C26185 _175_ net41 0.01844f
C26186 _174_ _071_ 0.00773f
C26187 _076_ FILLER_5_192/a_40_246# 0.00484f
C26188 _652_/a_1489_191# net43 0.00209f
C26189 _190_ net29 0.56477f
C26190 _029_ _701_/a_741_93# 0.00402f
C26191 net106 _701_/a_843_236# 0
C26192 baud_inst.counter\[20\] _693_/a_843_236# 0.00101f
C26193 hold67/a_438_182# _702_/a_1583_191# 0
C26194 hold67/a_326_118# _702_/a_1840_334# 0
C26195 VPWR FILLER_17_0/a_40_246# 0.1344f
C26196 _678_/a_843_236# net137 0
C26197 _078_ net183 0
C26198 hold88/a_326_118# _294_ 0.0128f
C26199 _421_/a_150_412# VPWR 0.00102f
C26200 hold69/a_438_182# rx_data[6] 0
C26201 net145 net137 0.00112f
C26202 _018_ FILLER_17_22/a_40_246# 0.03076f
C26203 net173 _341_/a_1453_124# 0
C26204 _283_ _652_/a_324_432# 0
C26205 _541_/a_380_412# _308_ 0.0014f
C26206 net15 _636_/a_132_114# 0
C26207 net58 _703_/a_132_114# 0
C26208 _032_ _703_/a_843_236# 0.00134f
C26209 _177_ _556_/a_192_429# 0
C26210 hold77/a_438_182# _648_/a_324_432# 0
C26211 hold77/a_326_118# _648_/a_741_93# 0.00171f
C26212 clknet_0_clk _649_/a_1583_191# 0.00779f
C26213 hold171/a_326_118# _206_ 0
C26214 net34 _176_ 0.01284f
C26215 FILLER_17_79/a_40_246# net46 0
C26216 _646_/a_2250_412# VPWR 0.00297f
C26217 _698_/a_2250_412# net46 0
C26218 clknet_4_3_0_clk _678_/a_2250_412# 0.00499f
C26219 baud_inst.counter\[30\] _027_ 0
C26220 VPWR _435_/a_72_436# 0.00398f
C26221 hold140/a_56_118# net100 0
C26222 net3 _656_/a_1840_334# 0
C26223 hold101/a_438_182# _690_/a_843_236# 0
C26224 _650_/a_550_127# _061_ 0
C26225 _650_/a_2250_412# rx_inst.data_reg\[7\] 0.00646f
C26226 net31 _251_ 0
C26227 _489_/a_358_436# net86 0.00174f
C26228 _489_/a_494_160# net181 0
C26229 _663_/a_324_432# _078_ 0
C26230 _260_ _450_/a_127_436# 0.00662f
C26231 _062_ tx_inst.bit_index\[0\] 0
C26232 hold124/a_56_118# _637_/a_38_114# 0
C26233 baud_inst.counter\[27\] VPWR 0.18404f
C26234 net41 net165 0.00824f
C26235 tx_data[1] net6 0
C26236 net4 tx_data[3] 0.13371f
C26237 net182 _190_ 0
C26238 hold118/a_438_182# VPWR 0.00306f
C26239 _544_/a_268_412# clknet_0_clk 0
C26240 net7 net8 0.04061f
C26241 net41 FILLER_3_123/a_32_246# 0.01855f
C26242 _315_ FILLER_27_46/a_32_246# 0
C26243 _136_ _647_/a_550_127# 0
C26244 hold163/a_56_118# _104_ 0.00389f
C26245 _438_/a_350_122# _161_ 0.00265f
C26246 _398_/a_494_160# _219_ 0
C26247 clknet_0_clk FILLER_9_70/a_40_246# 0
C26248 _132_ _641_/a_1583_191# 0
C26249 _313_ _543_/a_248_122# 0
C26250 _705_/a_1840_334# net11 0
C26251 _650_/a_1489_191# _264_ 0
C26252 _341_/a_500_118# clknet_4_4_0_clk 0
C26253 hold183/a_326_118# _062_ 0.00351f
C26254 net48 _241_ 0.02521f
C26255 net48 hold131/a_56_118# 0.07601f
C26256 FILLER_8_189/a_40_246# FILLER_8_191/a_32_246# 0.0524f
C26257 _292_ net40 0.03695f
C26258 _633_/a_843_236# _648_/a_741_93# 0
C26259 _633_/a_741_93# _648_/a_843_236# 0
C26260 net53 _641_/a_741_93# 0
C26261 _699_/a_324_432# clknet_0_clk 0
C26262 _350_/a_165_412# net116 0.00133f
C26263 _350_/a_279_412# _288_ 0.00388f
C26264 _083_ _676_/a_1840_334# 0
C26265 net70 hold72/a_438_182# 0
C26266 net18 hold72/a_56_118# 0
C26267 _390_/a_285_412# VPWR 0
C26268 net155 net8 0.00327f
C26269 _680_/a_741_93# VPWR 0.0138f
C26270 baud_inst.counter\[13\] _685_/a_2250_412# 0.00653f
C26271 net48 net47 0.87546f
C26272 _646_/a_1583_191# rx_inst.data_reg\[3\] 0
C26273 _699_/a_741_93# hold114/a_438_182# 0.0027f
C26274 hold132/a_56_118# clknet_4_14_0_clk 0.01149f
C26275 _302_ FILLER_24_4/a_40_246# 0
C26276 _114_ net107 0.01306f
C26277 FILLER_0_161/a_40_246# _380_/a_59_156# 0.00885f
C26278 _041_ _205_ 0
C26279 _300_ FILLER_15_0/a_40_246# 0
C26280 baud_inst.counter\[7\] net29 0
C26281 clknet_4_3_0_clk net95 0
C26282 _224_ _249_ 0.3339f
C26283 _002_ _670_/a_1840_334# 0
C26284 hold167/a_56_118# _670_/a_1489_191# 0
C26285 _198_ _203_ 0.77642f
C26286 _676_/a_612_127# _281_ 0
C26287 net18 net17 0.34574f
C26288 _440_/a_244_140# _253_ 0
C26289 _699_/a_1583_191# _313_ 0
C26290 _520_/a_257_140# _297_ 0.0012f
C26291 tx_inst.data_reg\[6\] _144_ 0.33895f
C26292 tx_inst.bit_index\[1\] _659_/a_843_236# 0
C26293 _643_/a_1840_334# hold143/a_438_182# 0
C26294 _643_/a_843_236# net143 0
C26295 hold56/a_326_118# net27 0.05308f
C26296 hold165/a_438_182# input9/a_40_152# 0
C26297 tx_inst.bit_index\[1\] hold173/a_326_118# 0
C26298 FILLER_27_135/a_32_246# VPWR 0.09486f
C26299 net143 hold144/a_438_182# 0
C26300 tx_inst.bit_index\[1\] net43 0.33843f
C26301 _227_ hold175/a_438_182# 0
C26302 net179 _199_ 0.03177f
C26303 hold54/a_326_118# net21 0.00184f
C26304 _186_ _280_ 0.00385f
C26305 tx_inst.state\[1\] _704_/a_324_432# 0.00149f
C26306 clknet_4_7_0_clk _704_/a_741_93# 0.0676f
C26307 net13 rx_data[1] 0.00675f
C26308 hold156/a_326_118# _682_/a_1583_191# 0
C26309 net177 clknet_4_8_0_clk 0
C26310 hold121/a_438_182# _692_/a_843_236# 0
C26311 net44 baud_inst.counter\[18\] 0
C26312 VPWR net91 0.06064f
C26313 net71 _049_ 0
C26314 tx_data[2] _384_/a_559_412# 0
C26315 net108 _505_/a_76_160# 0.03005f
C26316 FILLER_9_70/a_40_246# _182_ 0.02609f
C26317 net32 _242_ 0.23962f
C26318 net55 _380_/a_285_412# 0.00168f
C26319 _661_/a_1583_191# _658_/a_324_432# 0.00263f
C26320 _658_/a_298_337# clknet_4_1_0_clk 0.00349f
C26321 rx_inst.data_reg\[3\] net64 0.00573f
C26322 baud_inst.counter\[8\] baud_inst.counter\[9\] 0.05224f
C26323 clkbuf_4_7_0_clk/a_27_118# _668_/a_741_93# 0.00141f
C26324 VPWR net161 0.02026f
C26325 clk _391_/a_46_156# 0.00192f
C26326 _646_/a_2250_412# _266_ 0.00787f
C26327 _688_/a_324_432# baud_inst.counter\[16\] 0
C26328 net49 _692_/a_1489_191# 0.00917f
C26329 baud_inst.counter\[23\] net76 0
C26330 hold137/a_438_182# net137 0.00166f
C26331 _487_/a_248_122# net172 0
C26332 FILLER_12_171/a_40_246# _651_/a_741_93# 0
C26333 _241_ _250_ 0.00672f
C26334 _698_/a_843_236# clknet_0_clk 0.01204f
C26335 _165_ net99 0.00575f
C26336 output21/a_40_152# hold172/a_326_118# 0.00107f
C26337 _118_ VPWR 0.15633f
C26338 _638_/a_298_337# _273_ 0.00508f
C26339 hold127/a_438_182# clknet_0_clk 0.00117f
C26340 _087_ _085_ 0
C26341 clkbuf_4_4_0_clk/a_27_118# _400_/a_192_429# 0
C26342 _004_ FILLER_15_162/a_40_246# 0
C26343 clknet_4_7_0_clk _707_/a_298_337# 0.00284f
C26344 _167_ _435_/a_72_436# 0.00187f
C26345 output13/a_40_152# net30 0
C26346 FILLER_6_23/a_32_246# net136 0
C26347 clknet_4_6_0_clk _666_/a_298_337# 0
C26348 _009_ net98 0.02125f
C26349 clknet_4_13_0_clk _650_/a_741_93# 0.02906f
C26350 _639_/a_324_432# rx_inst.data_reg\[7\] 0
C26351 _699_/a_741_93# _551_/a_76_160# 0
C26352 _675_/a_324_432# hold61/a_56_118# 0
C26353 _249_ _235_ 0
C26354 _225_ _435_/a_72_436# 0.01288f
C26355 _644_/a_298_337# hold151/a_56_118# 0
C26356 tx_inst.data_reg\[7\] _388_/a_285_412# 0
C26357 _656_/a_2250_412# _208_ 0.0618f
C26358 net122 net28 0.0164f
C26359 hold160/a_438_182# net40 0.00368f
C26360 _180_ hold90/a_438_182# 0
C26361 _641_/a_843_236# net175 0
C26362 _641_/a_324_432# net24 0.0012f
C26363 _090_ _677_/a_298_337# 0.02973f
C26364 net39 _677_/a_38_114# 0
C26365 _075_ tx_inst.state\[4\] 0
C26366 tx_inst.state\[1\] hold146/a_438_182# 0
C26367 _270_ output19/a_40_152# 0.00268f
C26368 _694_/a_38_114# FILLER_25_25/a_40_246# 0
C26369 hold100/a_326_118# net99 0.01636f
C26370 _092_ net108 0
C26371 FILLER_14_70/a_40_246# _296_ 0
C26372 net73 _639_/a_298_337# 0
C26373 net43 _665_/a_741_93# 0.02082f
C26374 _153_ _650_/a_132_114# 0
C26375 net118 _650_/a_1583_191# 0.00327f
C26376 _674_/a_1583_191# net135 0.00113f
C26377 _632_/a_843_236# clknet_4_15_0_clk 0
C26378 _092_ net181 0.00172f
C26379 _195_ FILLER_9_169/a_32_246# 0
C26380 _191_ _186_ 0
C26381 clknet_4_7_0_clk hold51/a_438_182# 0.00107f
C26382 output16/a_40_152# _240_ 0.0015f
C26383 _139_ _158_ 0
C26384 _643_/a_324_432# clknet_4_12_0_clk 0.05444f
C26385 _634_/a_1489_191# hold82/a_326_118# 0
C26386 _112_ _701_/a_1840_334# 0
C26387 _050_ rx_inst.state\[1\] 0.00253f
C26388 _694_/a_843_236# net46 0.00204f
C26389 clknet_4_12_0_clk hold144/a_56_118# 0
C26390 _697_/a_681_505# _025_ 0
C26391 net44 _538_/a_81_118# 0.0041f
C26392 _556_/a_192_429# VPWR 0.00891f
C26393 _699_/a_2002_114# net46 0
C26394 _531_/a_209_168# _104_ 0.01688f
C26395 clkbuf_4_10_0_clk/a_27_118# _699_/a_741_93# 0
C26396 _141_ _221_ 0.16179f
C26397 _260_ net175 0
C26398 _657_/a_38_114# _209_ 0.00108f
C26399 _143_ hold137/a_326_118# 0.01619f
C26400 _429_/a_550_140# VPWR 0
C26401 _672_/a_2250_412# clknet_4_0_0_clk 0
C26402 _407_/a_248_122# net25 0
C26403 _128_ net18 0
C26404 hold66/a_56_118# clknet_4_15_0_clk 0
C26405 _218_ clknet_4_4_0_clk 0
C26406 net72 _634_/a_612_127# 0
C26407 _048_ _634_/a_550_127# 0
C26408 net17 _634_/a_2250_412# 0
C26409 baud_inst.counter\[20\] _701_/a_38_114# 0
C26410 rx_inst.bit_index\[2\] _236_ 0.36182f
C26411 _660_/a_38_114# _206_ 0.00851f
C26412 _288_ _096_ 0.03386f
C26413 hold59/a_326_118# _314_ 0
C26414 rx _707_/a_1489_191# 0
C26415 net138 _635_/a_1583_191# 0
C26416 net102 _527_/a_341_118# 0
C26417 _644_/a_741_93# net48 0
C26418 _045_ hold83/a_326_118# 0.00241f
C26419 _192_ net168 0.2062f
C26420 _537_/a_155_160# _305_ 0
C26421 _537_/a_341_118# net75 0.01261f
C26422 _675_/a_1489_191# _087_ 0
C26423 _394_/a_120_432# clknet_0_clk 0.00129f
C26424 net50 hold50/a_56_118# 0.00602f
C26425 net158 net157 0.08767f
C26426 _398_/a_115_308# FILLER_6_151/a_40_246# 0
C26427 net21 _665_/a_38_114# 0
C26428 _499_/a_177_436# VPWR 0
C26429 _097_ _189_ 0.00598f
C26430 net34 _276_ 0
C26431 _175_ _171_ 0.01441f
C26432 _422_/a_146_122# net29 0
C26433 _692_/a_324_432# _105_ 0.02982f
C26434 hold77/a_326_118# _059_ 0
C26435 _662_/a_324_432# _198_ 0
C26436 net76 FILLER_21_33/a_32_246# 0.02803f
C26437 hold153/a_326_118# VPWR 0.00626f
C26438 _658_/a_741_93# net41 0.01087f
C26439 tx_inst.data_reg\[5\] _652_/a_843_236# 0
C26440 net37 _057_ 0
C26441 _158_ _648_/a_38_114# 0
C26442 _107_ net107 0
C26443 _424_/a_550_140# clknet_0_clk 0
C26444 _177_ FILLER_23_83/a_32_246# 0
C26445 FILLER_1_90/a_32_246# input10/a_40_152# 0.00624f
C26446 _683_/a_741_93# clknet_4_2_0_clk 0.02957f
C26447 _645_/a_324_432# net48 0.01013f
C26448 _550_/a_380_412# VPWR 0
C26449 hold165/a_438_182# clk 0.00144f
C26450 _688_/a_2250_412# _684_/a_298_337# 0
C26451 _295_ _294_ 0.00958f
C26452 _270_ _636_/a_843_236# 0
C26453 _125_ _636_/a_741_93# 0
C26454 baud_inst.counter\[20\] net163 0
C26455 net48 _468_/a_120_432# 0.00287f
C26456 _045_ _634_/a_843_236# 0
C26457 net173 _341_/a_1377_160# 0.00121f
C26458 hold128/a_438_182# clknet_4_9_0_clk 0
C26459 _032_ _703_/a_612_127# 0.01846f
C26460 _177_ _316_ 0
C26461 _019_ _655_/a_298_337# 0
C26462 _499_/a_209_168# hold93/a_438_182# 0.00959f
C26463 _633_/a_681_505# _123_ 0
C26464 _243_ _236_ 0
C26465 hold167/a_438_182# net26 0
C26466 _212_ net171 0.09275f
C26467 _489_/a_115_308# hold115/a_326_118# 0
C26468 hold153/a_326_118# hold93/a_326_118# 0
C26469 baud_inst.counter\[18\] _302_ 0
C26470 hold101/a_438_182# _018_ 0
C26471 _287_ _503_/a_279_412# 0
C26472 hold101/a_56_118# _690_/a_1489_191# 0
C26473 baud_inst.counter\[18\] _690_/a_1840_334# 0
C26474 rx_inst.bit_index\[1\] _407_/a_146_122# 0
C26475 net30 FILLER_27_210/a_40_246# 0
C26476 _260_ _161_ 0.01891f
C26477 hold178/a_56_118# _011_ 0.05206f
C26478 hold178/a_438_182# _163_ 0
C26479 _234_ fanout28/a_40_152# 0.03149f
C26480 _550_/a_209_168# net133 0.00815f
C26481 FILLER_12_106/a_40_246# _670_/a_38_114# 0
C26482 FILLER_15_0/a_40_246# net160 0.00285f
C26483 _059_ _633_/a_843_236# 0
C26484 _691_/a_741_93# VPWR 0.01612f
C26485 _172_ _196_ 0
C26486 _671_/a_1583_191# FILLER_14_185/a_32_246# 0
C26487 VPWR _541_/a_380_412# 0
C26488 FILLER_0_237/a_40_246# FILLER_1_237/a_40_246# 0.00322f
C26489 _159_ _633_/a_843_236# 0
C26490 _252_ _161_ 0.01095f
C26491 hold155/a_56_118# _206_ 0
C26492 _307_ baud_inst.counter\[23\] 0.0461f
C26493 _242_ FILLER_25_150/a_32_246# 0
C26494 hold76/a_438_182# baud_inst.counter\[20\] 0.00431f
C26495 clknet_4_12_0_clk _641_/a_1489_191# 0.00686f
C26496 _706_/a_38_114# _200_ 0.00572f
C26497 net39 _497_/a_170_412# 0
C26498 hold77/a_326_118# _155_ 0
C26499 net48 _649_/a_324_432# 0.00177f
C26500 net75 _693_/a_2250_412# 0
C26501 _023_ _693_/a_1583_191# 0
C26502 _046_ net64 0.01609f
C26503 _093_ _288_ 0
C26504 rx_inst.data_reg\[7\] _264_ 0
C26505 _307_ _100_ 0
C26506 _633_/a_1583_191# _648_/a_1583_191# 0
C26507 _699_/a_2250_412# clknet_0_clk 0.00132f
C26508 net179 FILLER_1_201/a_40_246# 0.02392f
C26509 _183_ net116 0.14661f
C26510 baud_inst.counter\[10\] _039_ 0.00727f
C26511 _231_ _410_/a_257_140# 0
C26512 _170_ _228_ 0.19601f
C26513 _135_ net49 0.04346f
C26514 net159 VPWR 0.17897f
C26515 _447_/a_379_118# _257_ 0
C26516 _024_ _296_ 0.02551f
C26517 tx_data[3] net40 0.00291f
C26518 _641_/a_38_114# VPWR 0.00184f
C26519 hold100/a_56_118# net140 0.00209f
C26520 _679_/a_38_114# FILLER_5_59/a_40_246# 0
C26521 net112 net48 0.09632f
C26522 _549_/a_257_140# VPWR 0
C26523 clknet_4_7_0_clk _081_ 0
C26524 net51 _224_ 0.02343f
C26525 VPWR _000_ 0.39545f
C26526 hold162/a_326_118# _546_/a_192_429# 0
C26527 _468_/a_22_110# _157_ 0.00172f
C26528 _034_ _281_ 0.02289f
C26529 FILLER_18_158/a_40_246# net25 0.02732f
C26530 hold181/a_438_182# _673_/a_1583_191# 0
C26531 hold181/a_326_118# _673_/a_1840_334# 0
C26532 hold181/a_56_118# _673_/a_2250_412# 0.00308f
C26533 FILLER_11_134/a_32_246# _142_ 0
C26534 net143 net47 0
C26535 baud_inst.counter\[26\] FILLER_20_106/a_32_246# 0
C26536 net42 FILLER_11_134/a_32_246# 0.01894f
C26537 _384_/a_559_412# _210_ 0.0049f
C26538 rx_inst.data_reg\[0\] _632_/a_298_337# 0
C26539 baud_inst.counter\[10\] _682_/a_1583_191# 0.00292f
C26540 VPWR _647_/a_38_114# 0.03173f
C26541 clknet_4_11_0_clk _111_ 0.02402f
C26542 clkload2/Y net45 0.0075f
C26543 net44 _698_/a_550_127# 0
C26544 _206_ FILLER_0_128/a_40_246# 0.00224f
C26545 hold170/a_438_182# tx_inst.data_reg\[6\] 0.00376f
C26546 _678_/a_324_432# clknet_0_clk 0.04725f
C26547 _539_/a_139_160# _301_ 0
C26548 output19/a_40_152# _265_ 0
C26549 net121 _692_/a_1583_191# 0
C26550 _485_/a_22_110# FILLER_11_134/a_32_246# 0
C26551 hold76/a_56_118# net75 0.02648f
C26552 clknet_4_12_0_clk _224_ 0.0208f
C26553 _339_/a_1453_124# _172_ 0.00325f
C26554 _696_/a_298_337# _024_ 0.00108f
C26555 _360_/a_71_118# tx_inst.data_reg\[0\] 0.04736f
C26556 net55 net170 1.58217f
C26557 _049_ _273_ 0.18629f
C26558 _206_ _659_/a_324_432# 0.02957f
C26559 _541_/a_209_168# net162 0.01467f
C26560 net49 fanout35/a_40_152# 0.00741f
C26561 _693_/a_741_93# fanout46/a_40_152# 0
C26562 hold109/a_56_118# _290_ 0.06746f
C26563 hold104/a_438_182# _020_ 0
C26564 net35 net48 0
C26565 _286_ _511_/a_150_412# 0
C26566 _216_ _220_ 1.08834f
C26567 _688_/a_2250_412# baud_inst.counter\[16\] 0.02487f
C26568 net116 net115 0.00233f
C26569 _240_ clknet_4_6_0_clk 0
C26570 _698_/a_612_127# clknet_0_clk 0.00228f
C26571 _169_ _136_ 0
C26572 net36 fanout25/a_40_152# 0.01123f
C26573 net34 fanout34/a_40_152# 0.01534f
C26574 _170_ _153_ 0
C26575 _638_/a_1583_191# _273_ 0
C26576 FILLER_7_7/a_40_246# net38 0
C26577 clknet_4_7_0_clk _707_/a_1583_191# 0.00307f
C26578 net16 FILLER_18_210/a_32_246# 0
C26579 clknet_4_6_0_clk _666_/a_1583_191# 0.00397f
C26580 _009_ _095_ 0.0164f
C26581 _519_/a_81_118# _292_ 0.03176f
C26582 _043_ net64 0
C26583 hold179/a_438_182# net179 0.01481f
C26584 _662_/a_1489_191# net55 0
C26585 _117_ tx_done 0.00478f
C26586 _531_/a_474_130# _020_ 0
C26587 _646_/a_38_114# net139 0
C26588 hold130/a_438_182# baud_inst.counter\[13\] 0.00324f
C26589 clknet_4_13_0_clk _650_/a_1785_429# 0
C26590 _639_/a_2250_412# rx_inst.data_reg\[7\] 0
C26591 _640_/a_38_114# net52 0
C26592 net51 _235_ 0
C26593 net38 _681_/a_741_93# 0.02479f
C26594 _206_ _664_/a_298_337# 0
C26595 net173 _195_ 0.02213f
C26596 _705_/a_38_114# hold50/a_56_118# 0
C26597 _428_/a_150_412# net24 0.00427f
C26598 _675_/a_741_93# net61 0.00303f
C26599 _706_/a_298_337# _119_ 0
C26600 _031_ _555_/a_177_436# 0
C26601 _644_/a_38_114# net151 0.00105f
C26602 FILLER_0_115/a_40_246# _209_ 0
C26603 _661_/a_38_114# net55 0.0076f
C26604 tx_inst.data_reg\[7\] net165 0.01568f
C26605 net43 FILLER_8_236/a_40_246# 0
C26606 _078_ hold169/a_438_182# 0.01667f
C26607 _690_/a_38_114# _527_/a_192_429# 0
C26608 _641_/a_2250_412# net24 0.04714f
C26609 net49 _688_/a_1583_191# 0
C26610 _556_/a_341_118# net58 0.0177f
C26611 net100 baud_inst.counter\[25\] 0.02827f
C26612 net39 _677_/a_1840_334# 0.00317f
C26613 _090_ _677_/a_1583_191# 0.01046f
C26614 _678_/a_324_432# _182_ 0
C26615 net104 _104_ 0.20489f
C26616 _153_ _650_/a_1489_191# 0
C26617 net17 hold71/a_326_118# 0.00264f
C26618 _070_ _382_/a_382_118# 0.00149f
C26619 FILLER_6_205/a_40_246# _479_/a_22_110# 0
C26620 _440_/a_244_412# _056_ 0
C26621 VPWR FILLER_23_83/a_32_246# 0.08174f
C26622 net45 _703_/a_2250_412# 0
C26623 _674_/a_1489_191# _287_ 0
C26624 _674_/a_2002_114# net135 0
C26625 VPWR _400_/a_192_429# 0.00526f
C26626 _677_/a_324_432# _676_/a_741_93# 0
C26627 _448_/a_244_412# VPWR 0.00224f
C26628 _409_/a_269_412# net51 0.00101f
C26629 tx_data[1] net8 0
C26630 net4 tx_data[5] 0.02527f
C26631 _129_ _636_/a_741_93# 0
C26632 _546_/a_192_429# _310_ 0.01424f
C26633 _645_/a_38_114# _135_ 0
C26634 _645_/a_298_337# net151 0
C26635 VPWR _106_ 0.22955f
C26636 _198_ FILLER_6_191/a_32_246# 0
C26637 _010_ _682_/a_2250_412# 0
C26638 _694_/a_612_127# net46 0.00306f
C26639 _316_ VPWR 0.16617f
C26640 _000_ _266_ 0.09265f
C26641 _206_ _387_/a_46_156# 0.00815f
C26642 _223_ net29 0.02359f
C26643 baud_inst.counter\[1\] net60 0.1729f
C26644 _673_/a_1583_191# net135 0
C26645 clkbuf_4_8_0_clk/a_27_118# VPWR 0.04188f
C26646 baud_inst.counter\[30\] net49 0.03226f
C26647 hold159/a_438_182# net38 0.00205f
C26648 _000_ _167_ 0.00698f
C26649 _231_ hold180/a_326_118# 0
C26650 _227_ hold180/a_438_182# 0.01034f
C26651 FILLER_15_17/a_40_246# VPWR 0.13804f
C26652 net28 _650_/a_132_114# 0
C26653 _499_/a_209_168# _184_ 0
C26654 _162_ FILLER_12_82/a_32_246# 0.01275f
C26655 rx_inst.state\[2\] rx_inst.bit_index\[0\] 0.00174f
C26656 _379_/a_46_156# _656_/a_1583_191# 0.0025f
C26657 hold102/a_438_182# _300_ 0
C26658 _017_ net101 0.03233f
C26659 net35 _250_ 0.35437f
C26660 input10/a_40_152# _209_ 0
C26661 _378_/a_382_118# net38 0.00297f
C26662 _660_/a_1840_334# _206_ 0
C26663 _291_ _502_/a_279_412# 0
C26664 FILLER_16_176/a_40_246# fanout30/a_40_152# 0.01016f
C26665 _232_ _421_/a_150_412# 0
C26666 hold175/a_56_118# rx_inst.state\[2\] 0.00514f
C26667 hold135/a_56_118# baud_inst.counter\[2\] 0.00335f
C26668 net138 _635_/a_2002_114# 0
C26669 FILLER_4_183/a_40_246# VPWR 0.15581f
C26670 _172_ tx_inst.data_reg\[0\] 0
C26671 baud_inst.counter\[3\] _087_ 0.00171f
C26672 net94 FILLER_6_54/a_32_246# 0
C26673 clk _339_/a_1453_124# 0.01976f
C26674 hold56/a_438_182# fanout34/a_40_152# 0
C26675 net21 _665_/a_1840_334# 0.00216f
C26676 _216_ FILLER_6_151/a_40_246# 0
C26677 _036_ VPWR 0.00989f
C26678 FILLER_15_162/a_40_246# fanout31/a_40_152# 0.01f
C26679 _240_ net29 0.09886f
C26680 _646_/a_550_127# _160_ 0
C26681 _349_/a_146_122# _037_ 0
C26682 _688_/a_324_432# _016_ 0
C26683 baud_inst.counter\[20\] fanout46/a_40_152# 0
C26684 _658_/a_1785_429# net41 0.00285f
C26685 hold177/a_326_118# _292_ 0.01141f
C26686 net180 clknet_0_clk 0.00176f
C26687 _158_ _648_/a_1840_334# 0
C26688 baud_inst.counter\[20\] net149 0
C26689 hold137/a_56_118# clknet_0_clk 0.00179f
C26690 _685_/a_324_432# net29 0.00228f
C26691 hold74/a_56_118# VPWR 0.00658f
C26692 net106 net107 0.05305f
C26693 net45 hold113/a_438_182# 0.0019f
C26694 _499_/a_474_130# _036_ 0
C26695 hold63/a_326_118# net29 0
C26696 baud_inst.counter\[25\] _296_ 0
C26697 _645_/a_2250_412# net48 0.00535f
C26698 hold168/a_326_118# tx_inst.state\[2\] 0.0087f
C26699 baud_inst.counter\[8\] hold95/a_326_118# 0
C26700 _125_ _636_/a_1785_429# 0
C26701 _490_/a_139_160# net38 0
C26702 _696_/a_612_127# _294_ 0
C26703 hold133/a_438_182# VPWR 0.01097f
C26704 hold76/a_326_118# hold76/a_438_182# 0
C26705 tx_inst.data_reg\[6\] net179 0.30559f
C26706 hold57/a_438_182# net57 0
C26707 net44 _527_/a_192_429# 0.00193f
C26708 net48 _125_ 0.17096f
C26709 _045_ _634_/a_612_127# 0
C26710 net69 _264_ 0.13464f
C26711 _170_ FILLER_20_177/a_32_246# 0.00648f
C26712 rx_inst.bit_index\[2\] net2 0.02705f
C26713 clknet_4_5_0_clk _665_/a_38_114# 0.02112f
C26714 net55 net11 0.47199f
C26715 _032_ net59 0.07196f
C26716 _343_/a_155_412# FILLER_3_177/a_32_246# 0
C26717 _036_ hold93/a_326_118# 0.00944f
C26718 net42 _666_/a_741_93# 0.02053f
C26719 _069_ _657_/a_1840_334# 0
C26720 net62 _667_/a_843_236# 0
C26721 _129_ hold81/a_326_118# 0
C26722 _265_ hold81/a_438_182# 0.00336f
C26723 _152_ _705_/a_681_505# 0
C26724 net39 _676_/a_1489_191# 0.00122f
C26725 _677_/a_843_236# baud_inst.counter\[6\] 0.00114f
C26726 hold169/a_56_118# _476_/a_248_122# 0
C26727 net50 _705_/a_324_432# 0.00547f
C26728 _265_ _707_/a_741_93# 0
C26729 net156 _015_ 0
C26730 _411_/a_358_436# net51 0
C26731 hold119/a_56_118# _223_ 0.00217f
C26732 hold101/a_326_118# clknet_4_8_0_clk 0.00348f
C26733 _230_ _249_ 0.1349f
C26734 clknet_0_clk _668_/a_38_114# 0.00434f
C26735 hold111/a_56_118# _635_/a_38_114# 0
C26736 hold111/a_326_118# _635_/a_298_337# 0
C26737 net34 _174_ 0.04283f
C26738 _190_ FILLER_14_72/a_32_246# 0
C26739 net178 _684_/a_38_114# 0.05217f
C26740 hold133/a_56_118# net133 0.00192f
C26741 _638_/a_843_236# VPWR 0.00996f
C26742 net182 _685_/a_324_432# 0
C26743 _639_/a_843_236# net81 0.01656f
C26744 _639_/a_741_93# clknet_4_13_0_clk 0.03138f
C26745 hold87/a_326_118# baud_inst.counter\[24\] 0
C26746 _059_ _633_/a_612_127# 0
C26747 _463_/a_22_110# _649_/a_741_93# 0
C26748 tx_inst.bit_index\[1\] hold165/a_326_118# 0.00631f
C26749 _691_/a_1785_429# VPWR 0.00368f
C26750 _269_ rx_inst.data_reg\[7\] 0
C26751 _696_/a_324_432# net99 0
C26752 _696_/a_298_337# baud_inst.counter\[25\] 0
C26753 _267_ hold71/a_438_182# 0
C26754 _355_/a_252_412# baud_inst.counter\[16\] 0.00557f
C26755 net138 hold84/a_438_182# 0.00163f
C26756 _159_ _633_/a_612_127# 0.01825f
C26757 hold182/a_326_118# clknet_0_clk 0.00271f
C26758 _688_/a_843_236# _298_ 0.00203f
C26759 _706_/a_1840_334# _200_ 0
C26760 hold119/a_56_118# _240_ 0.01198f
C26761 _643_/a_681_505# net24 0
C26762 _187_ _687_/a_38_114# 0
C26763 _411_/a_115_308# rx_inst.bit_index\[2\] 0
C26764 baud_inst.counter\[28\] hold134/a_56_118# 0
C26765 net53 _052_ 0
C26766 _661_/a_132_114# _209_ 0
C26767 hold109/a_56_118# net108 0.00332f
C26768 hold162/a_326_118# clknet_4_8_0_clk 0.0026f
C26769 hold123/a_438_182# _063_ 0
C26770 _633_/a_1840_334# FILLER_29_198/a_40_246# 0
C26771 _207_ input10/a_40_152# 0
C26772 _643_/a_1583_191# _273_ 0.02213f
C26773 _643_/a_1840_334# net64 0
C26774 _259_ _257_ 0.30763f
C26775 net49 _703_/a_132_114# 0
C26776 _303_ _693_/a_324_432# 0
C26777 _641_/a_1840_334# VPWR 0.00184f
C26778 _675_/a_741_93# _674_/a_298_337# 0
C26779 net120 hold147/a_326_118# 0.00429f
C26780 clk tx_inst.data_reg\[0\] 0.10841f
C26781 _675_/a_1840_334# _279_ 0
C26782 hold162/a_56_118# _026_ 0
C26783 _652_/a_38_114# VPWR 0
C26784 _009_ hold156/a_438_182# 0.00119f
C26785 _260_ FILLER_18_148/a_40_246# 0
C26786 net105 hold107/a_56_118# 0
C26787 _442_/a_146_122# net24 0.00581f
C26788 FILLER_26_227/a_40_246# FILLER_26_229/a_32_246# 0.0524f
C26789 _673_/a_741_93# clknet_0_clk 0.0011f
C26790 _219_ clknet_0_clk 0.00151f
C26791 _078_ _166_ 0.58615f
C26792 net156 net88 0.04817f
C26793 _657_/a_1840_334# clknet_4_4_0_clk 0.00255f
C26794 FILLER_10_14/a_40_246# net117 0
C26795 hold128/a_56_118# _191_ 0
C26796 net2 hold118/a_56_118# 0
C26797 VPWR _647_/a_1840_334# 0.00135f
C26798 _047_ hold84/a_438_182# 0
C26799 _678_/a_2250_412# clknet_0_clk 0.00207f
C26800 _294_ FILLER_14_70/a_40_246# 0
C26801 hold74/a_326_118# net30 0.01034f
C26802 hold121/a_326_118# clknet_4_10_0_clk 0
C26803 net89 clknet_4_8_0_clk 0.00778f
C26804 hold59/a_56_118# _703_/a_38_114# 0
C26805 _519_/a_379_118# _189_ 0
C26806 baud_inst.counter\[12\] _180_ 0.02309f
C26807 clknet_4_15_0_clk hold70/a_438_182# 0.04977f
C26808 hold88/a_438_182# _189_ 0
C26809 _696_/a_38_114# _180_ 0.01651f
C26810 _339_/a_1377_160# _172_ 0.00191f
C26811 _360_/a_1109_431# tx_inst.data_reg\[0\] 0
C26812 _679_/a_741_93# clknet_4_0_0_clk 0.00176f
C26813 tx_inst.data_reg\[7\] _658_/a_741_93# 0.03165f
C26814 net66 hold111/a_438_182# 0.01329f
C26815 _206_ _659_/a_2250_412# 0
C26816 _121_ _668_/a_1840_334# 0
C26817 hold76/a_56_118# _695_/a_298_337# 0
C26818 FILLER_10_222/a_32_246# net22 0.02325f
C26819 net156 net39 0.03041f
C26820 clknet_4_12_0_clk FILLER_19_139/a_40_246# 0.00211f
C26821 net45 _550_/a_177_436# 0.00174f
C26822 _282_ _502_/a_165_412# 0.00731f
C26823 baud_inst.counter\[24\] _296_ 0
C26824 clkbuf_4_12_0_clk/a_27_118# _057_ 0
C26825 _638_/a_681_505# net30 0
C26826 _638_/a_843_236# _266_ 0.00106f
C26827 clknet_4_6_0_clk _666_/a_2002_114# 0
C26828 net128 _292_ 1.51625f
C26829 _530_/a_155_412# net103 0
C26830 _461_/a_120_432# net30 0.0049f
C26831 _040_ net55 0
C26832 FILLER_19_77/a_32_246# _310_ 0
C26833 clknet_4_13_0_clk _061_ 0.00564f
C26834 _690_/a_843_236# net103 0
C26835 net16 _636_/a_741_93# 0.00533f
C26836 rx_data[4] _636_/a_324_432# 0.02448f
C26837 _206_ _664_/a_1583_191# 0.03917f
C26838 net38 _681_/a_1785_429# 0
C26839 clknet_4_8_0_clk _543_/a_146_122# 0
C26840 _138_ _429_/a_550_140# 0.00101f
C26841 _673_/a_741_93# _182_ 0
C26842 net6 _070_ 0
C26843 _302_ _527_/a_192_429# 0
C26844 _409_/a_73_118# _161_ 0
C26845 clknet_4_8_0_clk _310_ 0.23145f
C26846 _442_/a_350_122# _161_ 0.00263f
C26847 _661_/a_1840_334# net55 0.00262f
C26848 clknet_0_clk net95 0
C26849 net145 _386_/a_496_118# 0.00123f
C26850 _098_ _294_ 0
C26851 hold164/a_438_182# _105_ 0.00657f
C26852 _232_ _429_/a_550_140# 0.00109f
C26853 hold98/a_326_118# _010_ 0
C26854 hold98/a_438_182# _292_ 0
C26855 _034_ _494_/a_165_412# 0.0019f
C26856 hold102/a_438_182# net160 0
C26857 hold102/a_326_118# _296_ 0.006f
C26858 _638_/a_38_114# net126 0.0023f
C26859 _353_/a_350_122# _184_ 0
C26860 _170_ net28 0.50381f
C26861 net82 _637_/a_550_127# 0
C26862 net55 _006_ 0
C26863 _465_/a_22_110# clknet_4_13_0_clk 0.00341f
C26864 _637_/a_843_236# hold70/a_56_118# 0
C26865 _637_/a_741_93# hold70/a_326_118# 0
C26866 hold69/a_438_182# net69 0.01125f
C26867 _233_ FILLER_14_164/a_32_246# 0
C26868 net41 _209_ 0.03383f
C26869 _410_/a_257_140# _228_ 0
C26870 _410_/a_155_412# rx_inst.state\[2\] 0.01857f
C26871 baud_inst.counter\[2\] _287_ 0.02922f
C26872 _677_/a_1840_334# _676_/a_843_236# 0
C26873 _677_/a_2250_412# _676_/a_741_93# 0
C26874 _694_/a_1583_191# _302_ 0
C26875 net39 _180_ 0.13204f
C26876 _026_ net141 0
C26877 tx_data[4] net38 0
C26878 _172_ tx_inst.data_reg\[1\] 0
C26879 baud_inst.counter\[20\] _695_/a_132_114# 0
C26880 _360_/a_295_385# VPWR 0.00167f
C26881 tx_inst.bit_index\[2\] clknet_0_clk 0.0232f
C26882 _117_ output22/a_40_152# 0
C26883 FILLER_20_57/a_32_246# baud_inst.counter\[22\] 0
C26884 net48 _129_ 0
C26885 net184 _364_/a_155_412# 0.00265f
C26886 _423_/a_165_412# VPWR -0
C26887 _650_/a_324_432# FILLER_17_199/a_40_246# 0
C26888 net145 _659_/a_324_432# 0.00634f
C26889 net172 _200_ 0.45053f
C26890 _696_/a_298_337# baud_inst.counter\[24\] 0.00305f
C26891 _073_ clknet_4_4_0_clk 0
C26892 hold56/a_56_118# tx_inst.bit_index\[0\] 0.02845f
C26893 _673_/a_1489_191# _287_ 0.00249f
C26894 _508_/a_474_130# baud_inst.counter\[16\] 0
C26895 _483_/a_120_432# rx_inst.state\[4\] 0
C26896 net28 hold62/a_56_118# 0.00794f
C26897 _555_/a_177_436# _313_ 0.00114f
C26898 FILLER_7_121/a_40_246# _063_ 0.00113f
C26899 _663_/a_741_93# VPWR 0.0123f
C26900 _296_ FILLER_15_42/a_40_246# 0.0196f
C26901 _643_/a_843_236# VPWR 0.00641f
C26902 _206_ net38 0.03326f
C26903 _266_ _647_/a_1840_334# 0.00441f
C26904 hold144/a_438_182# VPWR 0.02447f
C26905 tx_inst.bit_index\[1\] FILLER_3_150/a_40_246# 0.01439f
C26906 VPWR _417_/a_22_110# 0.00134f
C26907 _025_ _686_/a_1583_191# 0
C26908 _170_ _633_/a_38_114# 0
C26909 _503_/a_279_412# net181 0.00105f
C26910 _055_ net48 0.01779f
C26911 _641_/a_298_337# net45 0
C26912 net45 _549_/a_155_412# 0.00271f
C26913 clk _339_/a_1377_160# 0.05152f
C26914 _122_ _264_ 0.19165f
C26915 _202_ FILLER_7_210/a_40_246# 0
C26916 net16 hold81/a_326_118# 0
C26917 rx_data[4] hold81/a_56_118# 0
C26918 input1/a_40_152# net1 0
C26919 net47 FILLER_29_179/a_40_246# 0.0065f
C26920 _283_ _092_ 0.00975f
C26921 _182_ net95 0.00644f
C26922 _537_/a_341_118# _303_ 0.00123f
C26923 hold99/a_438_182# _111_ 0.00101f
C26924 _069_ net41 0.248f
C26925 clknet_4_1_0_clk net137 0.15195f
C26926 net73 FILLER_16_221/a_32_246# 0.01177f
C26927 _678_/a_741_93# FILLER_6_98/a_40_246# 0.00249f
C26928 net72 rx_inst.data_reg\[6\] 0
C26929 baud_inst.counter\[30\] hold59/a_438_182# 0.0468f
C26930 hold147/a_56_118# net76 0.02642f
C26931 clk hold179/a_326_118# 0.01348f
C26932 _096_ clknet_4_2_0_clk 0.54187f
C26933 net44 _526_/a_350_122# 0
C26934 _305_ _695_/a_741_93# 0
C26935 net75 _695_/a_843_236# 0.01052f
C26936 _023_ _695_/a_324_432# 0
C26937 net7 _383_/a_46_156# 0.0281f
C26938 tx_data[6] VPWR 0.01725f
C26939 _418_/a_46_156# _236_ 0
C26940 FILLER_0_109/a_32_246# _209_ 0.0062f
C26941 rx_inst.state\[2\] hold176/a_326_118# 0
C26942 hold124/a_56_118# hold72/a_438_182# 0.00113f
C26943 _045_ net83 0.00912f
C26944 hold120/a_56_118# baud_inst.counter\[21\] 0.01186f
C26945 _646_/a_612_127# net47 0
C26946 clknet_4_5_0_clk _665_/a_1840_334# 0
C26947 _653_/a_843_236# VPWR 0.00485f
C26948 net42 _666_/a_1785_429# 0
C26949 baud_inst.counter\[14\] _100_ 0
C26950 tx_inst.bit_index\[1\] _339_/a_71_118# 0.01989f
C26951 hold169/a_326_118# _274_ 0
C26952 hold154/a_56_118# net153 0
C26953 net144 hold144/a_438_182# 0.01944f
C26954 net56 _651_/a_681_505# 0
C26955 _222_ _651_/a_741_93# 0
C26956 _141_ _651_/a_324_432# 0.00478f
C26957 net55 _392_/a_59_156# 0
C26958 baud_inst.counter\[20\] _536_/a_155_160# 0
C26959 net155 _383_/a_46_156# 0
C26960 net39 baud_inst.counter\[11\] 0.0016f
C26961 input2/a_40_152# VPWR 0.00443f
C26962 _689_/a_843_236# net40 0.00173f
C26963 hold63/a_326_118# net122 0.00139f
C26964 hold63/a_56_118# net37 0.01141f
C26965 fanout48/a_40_152# VPWR 0.05034f
C26966 _464_/a_120_432# net47 0.00266f
C26967 _638_/a_612_127# VPWR 0.00286f
C26968 net182 _685_/a_2250_412# 0
C26969 FILLER_12_166/a_40_246# net29 0.00169f
C26970 baud_inst.counter\[21\] _692_/a_1583_191# 0
C26971 clknet_4_11_0_clk hold59/a_56_118# 0.00178f
C26972 VPWR _384_/a_382_118# 0.00329f
C26973 _657_/a_38_114# _386_/a_382_118# 0
C26974 output21/a_40_152# VPWR 0.00696f
C26975 input11/a_40_152# _275_ 0
C26976 _639_/a_612_127# net81 0.00423f
C26977 _639_/a_1785_429# clknet_4_13_0_clk 0
C26978 _056_ FILLER_26_141/a_40_246# 0
C26979 _268_ _649_/a_843_236# 0
C26980 net66 clknet_0_clk 0.00275f
C26981 clk tx_inst.data_reg\[1\] 0
C26982 _256_ FILLER_25_141/a_32_246# 0.00262f
C26983 _054_ net24 0.11018f
C26984 net79 _349_/a_350_122# 0.00344f
C26985 _202_ _664_/a_1583_191# 0
C26986 rx_inst.state\[3\] _667_/a_843_236# 0
C26987 net89 _687_/a_324_432# 0.01063f
C26988 rx_inst.data_reg\[4\] _264_ 0.05038f
C26989 _159_ net78 0.02115f
C26990 _683_/a_298_337# _096_ 0.03279f
C26991 net27 FILLER_6_205/a_40_246# 0.00619f
C26992 _230_ clknet_4_12_0_clk 0.80554f
C26993 hold168/a_56_118# VPWR 0.04059f
C26994 _199_ _665_/a_38_114# 0.04339f
C26995 hold77/a_56_118# clknet_4_14_0_clk 0
C26996 _658_/a_298_337# net165 0
C26997 _513_/a_192_429# _186_ 0
C26998 net49 _435_/a_411_436# 0
C26999 _547_/a_81_118# _311_ 0.03265f
C27000 _547_/a_175_118# baud_inst.counter\[25\] 0.00118f
C27001 _547_/a_379_118# net99 0.00152f
C27002 baud_inst.counter\[1\] _019_ 0
C27003 _228_ hold180/a_326_118# 0.00545f
C27004 rx_inst.state\[2\] hold180/a_56_118# 0.03035f
C27005 _643_/a_2002_114# _273_ 0.00168f
C27006 FILLER_12_173/a_32_246# _084_ 0.00311f
C27007 _639_/a_298_337# net80 0.03073f
C27008 net49 _703_/a_1489_191# 0.00572f
C27009 _672_/a_843_236# hold60/a_438_182# 0
C27010 FILLER_2_110/a_32_246# _206_ 0
C27011 net57 net183 0.32439f
C27012 _643_/a_843_236# _266_ 0
C27013 _675_/a_1840_334# _674_/a_324_432# 0
C27014 _675_/a_1583_191# _674_/a_741_93# 0.00325f
C27015 clknet_4_4_0_clk net41 1.85683f
C27016 _660_/a_298_337# net3 0
C27017 hold137/a_56_118# _659_/a_843_236# 0
C27018 hold137/a_326_118# _659_/a_741_93# 0
C27019 hold137/a_438_182# _659_/a_324_432# 0
C27020 _678_/a_324_432# net152 0
C27021 hold182/a_326_118# FILLER_10_110/a_40_246# 0
C27022 _225_ _423_/a_165_412# 0
C27023 FILLER_19_178/a_40_246# _058_ 0
C27024 hold137/a_56_118# net43 0.02168f
C27025 _652_/a_1840_334# VPWR 0.00437f
C27026 _095_ hold156/a_326_118# 0
C27027 baud_inst.counter\[13\] _688_/a_2250_412# 0
C27028 VPWR _684_/a_741_93# 0.01274f
C27029 _537_/a_192_429# net120 0
C27030 _638_/a_741_93# _049_ 0.0011f
C27031 _414_/a_165_412# _231_ 0
C27032 _233_ _412_/a_120_432# 0
C27033 _045_ _470_/a_22_110# 0.00108f
C27034 hold120/a_438_182# _694_/a_843_236# 0
C27035 net58 net45 0
C27036 _167_ _417_/a_22_110# 0.01723f
C27037 _673_/a_1489_191# clkbuf_4_0_0_clk/a_27_118# 0
C27038 _643_/a_298_337# _154_ 0.00167f
C27039 FILLER_24_218/a_40_246# _128_ 0.0248f
C27040 _704_/a_38_114# _668_/a_1583_191# 0
C27041 _392_/a_59_156# _076_ 0
C27042 hold154/a_56_118# _280_ 0.01058f
C27043 hold79/a_56_118# net86 0
C27044 net84 _636_/a_38_114# 0
C27045 clknet_4_14_0_clk _633_/a_741_93# 0.04836f
C27046 _267_ _632_/a_38_114# 0
C27047 _043_ _638_/a_324_432# 0
C27048 hold178/a_56_118# baud_inst.counter\[13\] 0
C27049 _241_ FILLER_18_169/a_40_246# 0
C27050 _313_ _702_/a_298_337# 0.00285f
C27051 _696_/a_1840_334# _180_ 0
C27052 _259_ _238_ 0
C27053 FILLER_4_108/a_40_246# _211_ 0.01266f
C27054 _661_/a_1489_191# _069_ 0
C27055 fanout38/a_40_152# _288_ 0.00705f
C27056 hold55/a_56_118# _705_/a_1583_191# 0.00119f
C27057 _147_ net137 0.03681f
C27058 clknet_4_3_0_clk hold94/a_56_118# 0.00484f
C27059 hold75/a_438_182# _023_ 0.00127f
C27060 _176_ _076_ 0
C27061 _245_ clkbuf_4_14_0_clk/a_27_118# 0.07963f
C27062 _224_ FILLER_23_143/a_32_246# 0
C27063 _680_/a_324_432# FILLER_5_32/a_40_246# 0.00167f
C27064 _080_ FILLER_11_142/a_40_246# 0
C27065 tx_inst.data_reg\[6\] _360_/a_886_118# 0.07249f
C27066 net45 _028_ 2.27869f
C27067 _673_/a_132_114# net181 0
C27068 _400_/a_435_412# _221_ 0
C27069 _400_/a_341_118# net183 0.00853f
C27070 FILLER_24_218/a_40_246# hold65/a_438_182# 0.00941f
C27071 _448_/a_142_412# _133_ -0
C27072 _448_/a_244_412# _232_ 0.01461f
C27073 _656_/a_298_337# _146_ 0.00256f
C27074 _656_/a_324_432# net165 0.00173f
C27075 _003_ _484_/a_154_118# 0
C27076 hold133/a_326_118# net45 0.00184f
C27077 _638_/a_550_127# net30 0
C27078 _638_/a_612_127# _266_ 0.00223f
C27079 net32 _440_/a_244_412# 0
C27080 _097_ clknet_0_clk 0.02081f
C27081 _168_ _650_/a_843_236# 0.04124f
C27082 _018_ net103 0.00119f
C27083 _164_ _301_ 0
C27084 _154_ _049_ 0.12715f
C27085 _530_/a_155_412# net101 0
C27086 clknet_4_8_0_clk _528_/a_81_118# 0
C27087 _690_/a_2250_412# _301_ 0
C27088 rx_data[4] _636_/a_2250_412# 0
C27089 _640_/a_1489_191# _130_ 0
C27090 clknet_4_14_0_clk _455_/a_257_140# 0
C27091 _286_ FILLER_9_70/a_40_246# 0.00101f
C27092 _690_/a_38_114# _300_ 0.01977f
C27093 _690_/a_843_236# net101 0.04038f
C27094 _228_ _247_ 0
C27095 VPWR _634_/a_298_337# 0
C27096 hold65/a_56_118# _632_/a_324_432# 0
C27097 hold65/a_56_118# rx_inst.data_reg\[6\] 0
C27098 net48 net16 0.34843f
C27099 net90 _685_/a_38_114# 0
C27100 _486_/a_115_308# clkbuf_0_clk/a_116_82# 0
C27101 _255_ _161_ 0.34349f
C27102 _060_ net24 0
C27103 _022_ _693_/a_843_236# 0
C27104 tx_data[7] _213_ 0.02182f
C27105 _074_ _654_/a_2250_412# 0
C27106 _662_/a_843_236# _120_ 0.00167f
C27107 _662_/a_681_505# net43 0
C27108 net33 _706_/a_1583_191# 0
C27109 net49 _438_/a_350_122# 0
C27110 _184_ _186_ 0.03031f
C27111 _643_/a_298_337# _160_ 0
C27112 _493_/a_139_160# clknet_0_clk 0.0013f
C27113 hold122/a_438_182# VPWR 0.00486f
C27114 _079_ _667_/a_1840_334# 0
C27115 _518_/a_139_160# _296_ 0
C27116 rx_inst.state\[2\] _229_ 0.09522f
C27117 _043_ net126 0
C27118 hold173/a_326_118# _219_ 0
C27119 hold173/a_438_182# _218_ 0.00814f
C27120 _677_/a_38_114# _034_ 0
C27121 net154 _676_/a_38_114# 0.03305f
C27122 _248_ fanout30/a_40_152# 0
C27123 _116_ _180_ 0.01811f
C27124 _641_/a_298_337# net176 0.00361f
C27125 _641_/a_38_114# _052_ 0.03081f
C27126 _219_ net43 0
C27127 hold154/a_56_118# _191_ 0
C27128 _216_ net27 0.45513f
C27129 _509_/a_155_412# _682_/a_2250_412# 0
C27130 net67 hold114/a_56_118# 0
C27131 baud_inst.counter\[31\] _699_/a_843_236# 0.00155f
C27132 _179_ _699_/a_324_432# 0
C27133 _360_/a_500_118# VPWR 0
C27134 _143_ _068_ 0
C27135 _241_ VPWR 0.19298f
C27136 VPWR FILLER_25_163/a_32_246# 0.08574f
C27137 net184 _197_ 0
C27138 _193_ _196_ 0
C27139 hold131/a_56_118# VPWR 0.05665f
C27140 net145 _659_/a_2250_412# 0.00529f
C27141 _696_/a_1583_191# baud_inst.counter\[24\] 0.00312f
C27142 _206_ net54 1.80964f
C27143 _226_ hold180/a_56_118# 0.00367f
C27144 net37 clknet_0_clk 0.89329f
C27145 net92 hold92/a_438_182# 0.00893f
C27146 _004_ rx_inst.state\[4\] 0
C27147 net47 VPWR 1.32468f
C27148 FILLER_8_21/a_32_246# _039_ 0.00146f
C27149 _513_/a_192_429# _684_/a_324_432# 0
C27150 net94 _678_/a_298_337# 0.00106f
C27151 _511_/a_354_412# VPWR 0
C27152 _643_/a_612_127# VPWR 0.00289f
C27153 tx_inst.data_reg\[7\] _656_/a_550_127# 0
C27154 _379_/a_268_412# tx_inst.data_reg\[2\] 0.00106f
C27155 _291_ net29 0.01408f
C27156 _231_ _234_ 0
C27157 hold174/a_56_118# _274_ 0
C27158 clknet_4_13_0_clk _156_ 0.02463f
C27159 _045_ _469_/a_120_432# 0.0017f
C27160 _025_ _686_/a_2002_114# 0
C27161 net12 _128_ 0
C27162 baud_inst.counter\[26\] hold142/a_326_118# 0.00394f
C27163 _072_ net6 0
C27164 _037_ net86 0
C27165 _186_ FILLER_9_72/a_32_246# 0.01192f
C27166 net71 hold71/a_438_182# 0
C27167 _660_/a_298_337# _150_ 0
C27168 _660_/a_324_432# net170 0
C27169 _660_/a_38_114# _208_ 0
C27170 _046_ _126_ 0.0042f
C27171 net45 _027_ 0.02952f
C27172 _078_ _394_/a_22_110# 0
C27173 net13 _634_/a_681_505# 0
C27174 hold88/a_326_118# net87 0
C27175 _160_ _049_ 0
C27176 hold161/a_326_118# _296_ 0.01167f
C27177 hold161/a_438_182# net160 0.00808f
C27178 hold161/a_56_118# _015_ 0.07523f
C27179 hold77/a_438_182# _264_ 0.03424f
C27180 _556_/a_341_118# net49 0.00372f
C27181 net161 net157 0.21363f
C27182 _153_ _247_ 0
C27183 _647_/a_298_337# net139 0
C27184 _680_/a_1489_191# _489_/a_115_308# 0
C27185 _195_ _396_/a_257_140# 0.00177f
C27186 hold101/a_326_118# _688_/a_612_127# 0
C27187 baud_inst.counter\[18\] _688_/a_1583_191# 0
C27188 rx_data[4] _157_ 0
C27189 hold155/a_326_118# _657_/a_741_93# 0
C27190 _292_ _683_/a_681_505# 0
C27191 _674_/a_681_505# net38 0
C27192 _674_/a_843_236# _085_ 0
C27193 _493_/a_139_160# _182_ 0.00108f
C27194 _012_ _180_ 0
C27195 net44 _300_ 0.02836f
C27196 net75 _695_/a_612_127# 0.00404f
C27197 hold126/a_438_182# VPWR 0.00635f
C27198 _281_ _685_/a_741_93# 0
C27199 _518_/a_45_160# net88 0.01511f
C27200 _443_/a_354_412# net24 0
C27201 _202_ FILLER_5_207/a_32_246# 0.0025f
C27202 net32 net52 0.00586f
C27203 rx_inst.data_reg\[3\] _643_/a_2250_412# 0
C27204 tx_inst.bit_index\[1\] _339_/a_1109_431# 0.00187f
C27205 _680_/a_298_337# _681_/a_1840_334# 0
C27206 net154 baud_inst.counter\[6\] 0
C27207 _670_/a_843_236# clknet_0_clk 0.00377f
C27208 _170_ _422_/a_146_122# 0.00506f
C27209 _684_/a_1840_334# _297_ 0
C27210 _194_ _364_/a_257_140# 0
C27211 net169 _197_ 0
C27212 _679_/a_843_236# FILLER_8_70/a_32_246# 0
C27213 _478_/a_27_156# tx_inst.state\[3\] 0.0133f
C27214 _689_/a_612_127# net40 0
C27215 _676_/a_132_114# _034_ 0
C27216 net85 rx_inst.data_reg\[0\] 0
C27217 hold173/a_326_118# tx_inst.bit_index\[2\] 0.01849f
C27218 net110 _683_/a_132_114# 0
C27219 hold182/a_326_118# net152 0
C27220 hold182/a_56_118# baud_inst.counter\[4\] 0.02836f
C27221 tx_inst.bit_index\[2\] net43 0
C27222 clknet_4_3_0_clk _676_/a_38_114# 0.07636f
C27223 _127_ net47 0.01778f
C27224 FILLER_8_70/a_32_246# _683_/a_1840_334# 0
C27225 net70 VPWR 0.14707f
C27226 _679_/a_1583_191# _679_/a_2250_412# 0
C27227 hold167/a_326_118# _669_/a_843_236# 0
C27228 _050_ clknet_4_13_0_clk 0.02033f
C27229 hold167/a_438_182# _669_/a_741_93# 0
C27230 _269_ rx_inst.data_reg\[4\] 0
C27231 _643_/a_324_432# _043_ 0
C27232 FILLER_16_176/a_40_246# _140_ 0
C27233 net48 _472_/a_120_432# 0.0027f
C27234 net2 _418_/a_46_156# 0.05766f
C27235 net79 _182_ 0.06062f
C27236 hold87/a_438_182# baud_inst.counter\[12\] 0
C27237 _304_ _693_/a_298_337# 0.00227f
C27238 net161 _298_ 0
C27239 hold87/a_438_182# _696_/a_38_114# 0
C27240 _693_/a_38_114# net46 0.03034f
C27241 net35 _421_/a_354_412# 0
C27242 net27 _666_/a_843_236# 0
C27243 hold131/a_56_118# _266_ 0
C27244 hold131/a_326_118# net30 0
C27245 net125 _154_ 0
C27246 net53 _698_/a_38_114# 0.04158f
C27247 clknet_4_11_0_clk _698_/a_741_93# 0.03168f
C27248 net31 hold132/a_326_118# 0
C27249 tx_data[0] _387_/a_46_156# 0
C27250 _658_/a_1583_191# net165 0.00829f
C27251 _171_ clknet_4_4_0_clk 0
C27252 _226_ _229_ 0.08929f
C27253 _307_ _296_ 0.46464f
C27254 net113 baud_inst.counter\[25\] 0.01107f
C27255 _133_ _154_ 0
C27256 _659_/a_741_93# _657_/a_741_93# 0.00803f
C27257 _241_ _167_ 0.05913f
C27258 hold126/a_56_118# _638_/a_38_114# 0
C27259 net47 _266_ 1.00133f
C27260 net100 _697_/a_38_114# 0
C27261 _094_ _681_/a_38_114# 0.01379f
C27262 hold57/a_438_182# _041_ 0
C27263 _639_/a_1583_191# net80 0
C27264 _701_/a_843_236# net107 0
C27265 _657_/a_324_432# net43 0
C27266 net35 _435_/a_268_436# 0.00436f
C27267 hold126/a_438_182# _127_ 0.01131f
C27268 hold68/a_438_182# _115_ 0.00146f
C27269 _081_ _668_/a_681_505# 0
C27270 _678_/a_1583_191# _211_ 0
C27271 rx_inst.state\[2\] _669_/a_38_114# 0
C27272 _678_/a_1583_191# _282_ 0.00172f
C27273 _678_/a_2250_412# net152 0
C27274 hold130/a_438_182# net29 0.04707f
C27275 _225_ _241_ 0
C27276 _029_ _313_ 0.00463f
C27277 _305_ net120 0.01819f
C27278 net3 FILLER_0_156/a_32_246# 0.00218f
C27279 _233_ _231_ 0.05309f
C27280 hold120/a_56_118# _694_/a_1489_191# 0
C27281 _677_/a_741_93# net154 0
C27282 _017_ hold104/a_438_182# 0
C27283 clknet_0_clk net90 0.00302f
C27284 hold102/a_326_118# net104 0
C27285 _012_ baud_inst.counter\[11\] 0
C27286 hold157/a_56_118# baud_inst.counter\[17\] 0.00141f
C27287 net73 _047_ 0.13928f
C27288 net48 _648_/a_324_432# 0.01755f
C27289 net42 _671_/a_324_432# 0
C27290 _643_/a_1583_191# _154_ 0
C27291 _276_ _076_ 0
C27292 _275_ clknet_0_clk 0
C27293 _536_/a_192_429# _532_/a_155_412# 0
C27294 _306_ clknet_4_8_0_clk 0
C27295 net55 _388_/a_382_118# 0.00983f
C27296 _661_/a_324_432# hold155/a_56_118# 0
C27297 _013_ hold90/a_326_118# 0
C27298 _310_ _687_/a_2250_412# 0
C27299 hold163/a_56_118# _307_ 0
C27300 _644_/a_741_93# VPWR 0.01338f
C27301 _678_/a_324_432# _035_ 0
C27302 hold128/a_326_118# VPWR 0.00569f
C27303 FILLER_16_154/a_32_246# net37 0
C27304 hold126/a_438_182# _266_ 0
C27305 net155 _655_/a_2250_412# 0
C27306 hold55/a_56_118# net33 0.0279f
C27307 _127_ net70 0.00677f
C27308 baud_inst.counter\[28\] hold107/a_56_118# 0.02191f
C27309 hold172/a_56_118# tx_inst.state\[3\] 0.01893f
C27310 clknet_4_3_0_clk baud_inst.counter\[6\] 1.39442f
C27311 baud_inst.counter\[14\] hold90/a_326_118# 0
C27312 net108 _682_/a_324_432# 0
C27313 _694_/a_38_114# clknet_4_10_0_clk 0.02758f
C27314 _193_ tx_inst.data_reg\[0\] 0
C27315 net44 _083_ 0
C27316 tx_inst.data_reg\[7\] _069_ 0.07428f
C27317 hold55/a_326_118# _705_/a_1489_191# 0
C27318 baud_inst.counter\[2\] net181 0
C27319 hold125/a_438_182# net125 0
C27320 fanout35/a_40_152# net25 0
C27321 _653_/a_843_236# _652_/a_741_93# 0
C27322 _653_/a_741_93# _652_/a_843_236# 0.00214f
C27323 FILLER_19_149/a_40_246# hold180/a_56_118# 0
C27324 _181_ _066_ 0.00539f
C27325 _118_ clknet_4_7_0_clk 0.01128f
C27326 hold151/a_326_118# _251_ 0
C27327 _645_/a_324_432# VPWR 0
C27328 hold151/a_56_118# _253_ 0
C27329 baud_inst.counter\[26\] _698_/a_298_337# 0
C27330 _192_ _198_ 0.0783f
C27331 _077_ _275_ 0.01254f
C27332 _413_/a_170_412# rx_inst.bit_index\[2\] 0
C27333 _691_/a_324_432# FILLER_17_22/a_40_246# 0
C27334 hold112/a_438_182# _258_ 0.00658f
C27335 FILLER_19_132/a_40_246# _642_/a_2250_412# 0
C27336 baud_inst.counter\[4\] net29 0.23955f
C27337 net177 clkbuf_4_8_0_clk/a_27_118# 0
C27338 _673_/a_1489_191# net181 0
C27339 net27 _375_/a_170_412# 0
C27340 _260_ net49 0.00244f
C27341 _160_ _133_ 0.02273f
C27342 _488_/a_474_130# _181_ 0
C27343 _067_ _388_/a_382_118# 0.00153f
C27344 net70 _266_ 0.19549f
C27345 _206_ _065_ 0.00695f
C27346 _489_/a_358_436# VPWR 0.01038f
C27347 _183_ _683_/a_1840_334# 0
C27348 _168_ _650_/a_612_127# 0.02717f
C27349 FILLER_7_7/a_40_246# VPWR 0.13637f
C27350 hold75/a_56_118# _695_/a_843_236# 0.00232f
C27351 hold75/a_326_118# _695_/a_741_93# 0.0011f
C27352 hold75/a_438_182# _695_/a_324_432# 0
C27353 hold136/a_56_118# _038_ 0.03291f
C27354 _680_/a_2250_412# FILLER_6_54/a_32_246# 0.01061f
C27355 _202_ _368_/a_155_412# 0
C27356 _302_ _300_ 0.01149f
C27357 _018_ net101 0.04102f
C27358 hold181/a_438_182# FILLER_5_59/a_40_246# 0
C27359 hold142/a_56_118# VPWR 0.00888f
C27360 hold154/a_438_182# clkbuf_4_3_0_clk/a_27_118# 0
C27361 _690_/a_612_127# net101 0.01446f
C27362 VPWR _634_/a_1583_191# 0.00594f
C27363 _314_ _694_/a_1489_191# 0
C27364 _443_/a_252_412# VPWR 0
C27365 _224_ _236_ 0.00688f
C27366 net22 hold50/a_438_182# 0
C27367 hold156/a_56_118# _096_ 0
C27368 VPWR _681_/a_741_93# 0.0398f
C27369 _673_/a_38_114# _655_/a_298_337# 0
C27370 _673_/a_298_337# _655_/a_38_114# 0
C27371 net128 _099_ 0
C27372 net120 _693_/a_1489_191# 0.00156f
C27373 _536_/a_435_412# net149 0
C27374 FILLER_1_67/a_40_246# baud_inst.counter\[0\] 0.0243f
C27375 _662_/a_612_127# _120_ 0
C27376 net33 _706_/a_2002_114# 0
C27377 _696_/a_324_432# _099_ 0
C27378 _696_/a_741_93# net46 0.01455f
C27379 net49 _252_ 0.02548f
C27380 _048_ hold70/a_326_118# 0
C27381 _643_/a_1583_191# _160_ 0.01322f
C27382 hold63/a_438_182# net63 0.00148f
C27383 _205_ _667_/a_843_236# 0
C27384 fanout43/a_40_152# _405_/a_27_156# 0.08015f
C27385 baud_inst.counter\[27\] hold162/a_326_118# 0
C27386 baud_inst.counter\[26\] hold162/a_56_118# 0
C27387 hold144/a_326_118# _133_ 0
C27388 _641_/a_1840_334# _052_ 0
C27389 FILLER_26_229/a_32_246# _264_ 0
C27390 net182 baud_inst.counter\[4\] 0.01086f
C27391 _060_ net30 0.00149f
C27392 baud_inst.counter\[30\] _699_/a_1785_429# 0
C27393 clknet_4_3_0_clk _677_/a_741_93# 0.07275f
C27394 VPWR _649_/a_324_432# 0.00795f
C27395 baud_inst.counter\[18\] _101_ 0
C27396 hold145/a_438_182# tx_inst.data_reg\[5\] 0
C27397 net52 FILLER_25_150/a_32_246# 0
C27398 _402_/a_154_118# _401_/a_22_110# 0
C27399 net34 _398_/a_494_160# 0
C27400 _414_/a_165_412# _228_ 0
C27401 _245_ _154_ 0.0017f
C27402 _657_/a_298_337# _211_ 0
C27403 _163_ _684_/a_741_93# 0.01307f
C27404 net92 _678_/a_132_114# 0
C27405 _189_ _683_/a_1840_334# 0
C27406 _190_ _683_/a_1583_191# 0
C27407 _075_ VPWR 0.1792f
C27408 hold159/a_438_182# VPWR 0.00803f
C27409 tx_inst.data_reg\[7\] clknet_4_4_0_clk 0.11631f
C27410 net112 VPWR 0.14784f
C27411 rx_inst.state\[3\] _670_/a_2250_412# 0.00419f
C27412 net113 baud_inst.counter\[24\] 0.06259f
C27413 _198_ _706_/a_324_432# 0
C27414 FILLER_8_14/a_32_246# net116 0
C27415 _378_/a_382_118# VPWR 0.01046f
C27416 _305_ _533_/a_248_122# 0
C27417 hold110/a_326_118# net109 0
C27418 hold110/a_56_118# _292_ 0.01398f
C27419 _230_ _449_/a_27_156# 0
C27420 _653_/a_1583_191# net183 0
C27421 _073_ hold146/a_326_118# 0
C27422 _514_/a_257_140# net40 0
C27423 hold76/a_438_182# _022_ 0
C27424 _360_/a_382_118# net9 0
C27425 _295_ net87 0.10105f
C27426 FILLER_17_199/a_40_246# _264_ 0
C27427 _660_/a_741_93# FILLER_2_183/a_32_246# 0.00112f
C27428 _002_ FILLER_17_131/a_32_246# 0
C27429 FILLER_22_133/a_40_246# _224_ 0
C27430 clknet_4_11_0_clk _699_/a_1840_334# 0
C27431 hold121/a_326_118# VPWR 0.02795f
C27432 hold147/a_438_182# FILLER_22_22/a_32_246# 0.00985f
C27433 _083_ _685_/a_1583_191# 0
C27434 hold85/a_56_118# _636_/a_1583_191# 0
C27435 _132_ net25 0.05238f
C27436 _170_ _223_ 0.17035f
C27437 _127_ _634_/a_1583_191# 0
C27438 _662_/a_298_337# net54 0.01615f
C27439 _671_/a_1489_191# clknet_4_6_0_clk 0.00343f
C27440 _229_ FILLER_19_149/a_40_246# 0
C27441 _010_ _683_/a_612_127# 0
C27442 _674_/a_550_127# net38 0
C27443 net75 net76 0.02643f
C27444 VPWR _651_/a_38_114# 0.00548f
C27445 _257_ net24 0.07278f
C27446 _662_/a_741_93# clknet_4_5_0_clk 0.03287f
C27447 _350_/a_165_412# baud_inst.counter\[10\] 0
C27448 _468_/a_120_432# _266_ 0.00344f
C27449 _637_/a_38_114# _264_ 0
C27450 hold68/a_438_182# hold105/a_56_118# 0
C27451 hold68/a_56_118# hold105/a_438_182# 0
C27452 _256_ net24 0.00295f
C27453 hold110/a_326_118# net110 0
C27454 _112_ clknet_0_clk 0.00839f
C27455 VPWR _490_/a_139_160# 0
C27456 net66 clkbuf_4_13_0_clk/a_27_118# 0
C27457 hold143/a_56_118# _635_/a_298_337# 0
C27458 _701_/a_1489_191# baud_inst.counter\[29\] 0
C27459 _080_ _405_/a_27_156# 0
C27460 hold138/a_326_118# rx_inst.data_reg\[4\] 0
C27461 hold138/a_56_118# net138 0
C27462 baud_inst.counter\[31\] _698_/a_1489_191# 0
C27463 net144 net112 0
C27464 net3 _654_/a_324_432# 0
C27465 clknet_4_5_0_clk _217_ 0
C27466 _670_/a_612_127# clknet_0_clk 0.00228f
C27467 _673_/a_681_505# net38 0
C27468 FILLER_5_59/a_40_246# net135 0.02644f
C27469 _686_/a_324_432# hold90/a_438_182# 0
C27470 _686_/a_741_93# hold90/a_326_118# 0.00165f
C27471 net35 VPWR 0.59758f
C27472 net56 clknet_4_6_0_clk 0.03037f
C27473 _170_ _240_ 0.30528f
C27474 net130 net40 0
C27475 _486_/a_494_160# net49 0
C27476 _171_ _666_/a_1583_191# 0
C27477 net158 net40 0.00168f
C27478 hold110/a_438_182# _096_ 0.00185f
C27479 _555_/a_474_130# _314_ 0.00375f
C27480 net67 net105 0
C27481 clknet_4_3_0_clk _676_/a_1840_334# 0
C27482 _098_ _190_ 0
C27483 _702_/a_324_432# _700_/a_843_236# 0.00136f
C27484 baud_inst.counter\[27\] _310_ 0.03413f
C27485 baud_inst.counter\[26\] net141 0.00226f
C27486 FILLER_8_171/a_32_246# net56 0
C27487 net167 _669_/a_132_114# 0
C27488 _002_ _669_/a_1583_191# 0.00375f
C27489 baud_inst.counter\[23\] clknet_4_10_0_clk 0.41296f
C27490 _679_/a_741_93# baud_inst.counter\[7\] 0
C27491 _679_/a_843_236# clknet_4_3_0_clk 0.01771f
C27492 hold88/a_438_182# clknet_0_clk 0.06911f
C27493 _643_/a_2250_412# _043_ 0.00504f
C27494 _195_ _222_ 0.00496f
C27495 _218_ net56 0
C27496 net37 net43 0.13083f
C27497 net48 _123_ 0.06098f
C27498 hold174/a_438_182# VPWR 0.00835f
C27499 hold55/a_56_118# net23 0
C27500 hold126/a_326_118# _049_ 0
C27501 rx_inst.state\[3\] net63 0.20134f
C27502 _341_/a_295_385# tx_inst.data_reg\[0\] 0.00771f
C27503 _201_ tx_inst.state\[2\] 0
C27504 _240_ hold62/a_56_118# 0.00104f
C27505 _420_/a_350_122# net24 0
C27506 _100_ _687_/a_843_236# 0.00181f
C27507 baud_inst.counter\[12\] _517_/a_209_168# 0.00143f
C27508 _430_/a_170_412# rx_inst.bit_index\[2\] 0
C27509 net124 hold72/a_438_182# 0
C27510 net35 _239_ 0.02828f
C27511 _693_/a_1840_334# net46 0.00871f
C27512 _080_ net183 0
C27513 _240_ _650_/a_1489_191# 0
C27514 _266_ _649_/a_324_432# 0
C27515 net30 _649_/a_741_93# 0.00215f
C27516 _352_/a_46_156# _287_ 0
C27517 _126_ net2 0
C27518 _177_ _699_/a_843_236# 0.0228f
C27519 net53 _698_/a_1840_334# 0
C27520 clknet_4_11_0_clk _698_/a_1785_429# 0
C27521 fanout24/a_40_152# net24 0
C27522 net3 _212_ 0
C27523 _658_/a_2002_114# net165 0.00142f
C27524 FILLER_25_9/a_32_246# fanout49/a_40_152# 0.00624f
C27525 FILLER_15_17/a_40_246# net157 0.00177f
C27526 _242_ _158_ 0
C27527 hold53/a_56_118# net36 0
C27528 hold76/a_438_182# _108_ 0.0045f
C27529 net41 FILLER_3_141/a_40_246# 0.02418f
C27530 hold183/a_56_118# _398_/a_115_308# 0
C27531 hold138/a_56_118# _047_ 0
C27532 net100 _697_/a_1840_334# 0
C27533 _689_/a_1583_191# net160 0
C27534 net81 hold80/a_438_182# 0.00266f
C27535 hold162/a_56_118# _109_ 0
C27536 _701_/a_612_127# net107 0.00113f
C27537 _206_ _390_/a_285_118# 0.00381f
C27538 clknet_4_0_0_clk hold60/a_326_118# 0.05671f
C27539 _254_ _438_/a_248_122# 0
C27540 _230_ FILLER_23_143/a_32_246# 0.00516f
C27541 _178_ _699_/a_324_432# 0.02198f
C27542 _460_/a_120_432# VPWR 0
C27543 _228_ _234_ 0.05384f
C27544 hold52/a_438_182# FILLER_23_143/a_32_246# 0.00985f
C27545 rx_inst.state\[2\] _669_/a_1840_334# 0
C27546 _341_/a_886_118# clkbuf_4_4_0_clk/a_27_118# 0
C27547 _282_ hold95/a_326_118# 0.00167f
C27548 baud_inst.counter\[4\] hold95/a_438_182# 0
C27549 _691_/a_1489_191# net49 0.0023f
C27550 _706_/a_2250_412# FILLER_4_237/a_40_246# 0
C27551 _291_ _288_ 0
C27552 net31 hold180/a_56_118# 0.00198f
C27553 net71 _124_ 0
C27554 clknet_0_clk _454_/a_257_140# 0
C27555 hold139/a_438_182# _223_ 0.00211f
C27556 _268_ _271_ 0
C27557 _037_ net38 0
C27558 baud_inst.counter\[16\] _684_/a_38_114# 0.03748f
C27559 _670_/a_298_337# clknet_4_9_0_clk 0
C27560 _205_ _670_/a_324_432# 0
C27561 hold65/a_56_118# hold70/a_56_118# 0
C27562 _374_/a_244_412# _667_/a_741_93# 0
C27563 net42 _671_/a_2250_412# 0
C27564 net103 _687_/a_38_114# 0.02116f
C27565 hold144/a_326_118# net139 0
C27566 baud_inst.counter\[28\] baud_inst.counter\[22\] 0
C27567 hold135/a_326_118# clknet_4_0_0_clk 0.0129f
C27568 _041_ _405_/a_27_156# 0.00952f
C27569 _536_/a_192_429# _303_ 0.02294f
C27570 hold116/a_326_118# _682_/a_2250_412# 0
C27571 _704_/a_324_432# rx_inst.state\[1\] 0
C27572 _638_/a_132_114# net70 0
C27573 hold155/a_56_118# clknet_4_1_0_clk 0.02954f
C27574 _395_/a_248_122# net27 0.00131f
C27575 _644_/a_1785_429# VPWR 0
C27576 net49 _428_/a_354_412# 0
C27577 FILLER_8_19/a_40_246# _681_/a_324_432# 0.00155f
C27578 net147 FILLER_24_19/a_40_246# 0
C27579 hold111/a_56_118# _264_ 0
C27580 net120 _695_/a_38_114# 0
C27581 net180 net51 0
C27582 clkbuf_4_12_0_clk/a_27_118# clknet_0_clk 0.0812f
C27583 hold69/a_326_118# clknet_4_15_0_clk 0.00175f
C27584 FILLER_24_19/a_40_246# net46 0.00367f
C27585 _378_/a_496_118# tx_inst.data_reg\[1\] 0
C27586 net128 _685_/a_843_236# 0.00346f
C27587 _357_/a_150_412# _189_ 0.00518f
C27588 _358_/a_72_436# net40 0.0091f
C27589 _690_/a_1840_334# net160 0
C27590 _690_/a_1583_191# _296_ 0
C27591 hold181/a_438_182# _679_/a_38_114# 0
C27592 output22/a_40_152# hold50/a_56_118# 0.02752f
C27593 _694_/a_1840_334# clknet_4_10_0_clk 0.01574f
C27594 _659_/a_38_114# _070_ 0.02045f
C27595 net108 _682_/a_2250_412# 0
C27596 net97 _682_/a_1840_334# 0
C27597 net182 hold123/a_56_118# 0
C27598 net67 _700_/a_1840_334# 0
C27599 net114 clknet_4_10_0_clk 0.0166f
C27600 _699_/a_1583_191# hold113/a_438_182# 0.00138f
C27601 _545_/a_350_122# _309_ 0
C27602 _695_/a_2250_412# net99 0
C27603 _660_/a_324_432# _392_/a_59_156# 0
C27604 _403_/a_22_110# _220_ 0
C27605 _222_ _401_/a_22_110# 0.04659f
C27606 _403_/a_120_432# _142_ 0.00197f
C27607 net23 _705_/a_741_93# 0.00167f
C27608 hold55/a_326_118# net22 0.00423f
C27609 tx_done _705_/a_324_432# 0
C27610 hold139/a_438_182# _240_ 0
C27611 _653_/a_1583_191# _652_/a_1583_191# 0
C27612 _645_/a_2250_412# VPWR 0.00564f
C27613 baud_inst.counter\[26\] _698_/a_1583_191# 0.00168f
C27614 baud_inst.counter\[27\] _698_/a_1840_334# 0
C27615 _660_/a_843_236# net41 0
C27616 _695_/a_1840_334# FILLER_19_55/a_40_246# 0
C27617 FILLER_23_158/a_40_246# _236_ 0.01982f
C27618 hold103/a_326_118# baud_inst.counter\[16\] 0
C27619 _125_ VPWR 0.0227f
C27620 FILLER_8_189/a_40_246# _666_/a_741_93# 0.00119f
C27621 hold178/a_438_182# hold109/a_326_118# 0
C27622 _041_ net183 0
C27623 _483_/a_120_432# _004_ 0.00993f
C27624 _483_/a_22_110# _277_ 0.0069f
C27625 net35 _167_ 0.15661f
C27626 _168_ rx_inst.state\[4\] 0.08144f
C27627 net51 _668_/a_38_114# 0.031f
C27628 hold87/a_326_118# _013_ 0
C27629 hold134/a_438_182# _028_ 0.01102f
C27630 hold125/a_56_118# _649_/a_298_337# 0
C27631 baud_inst.counter\[6\] baud_inst.counter\[5\] 0
C27632 clknet_4_1_0_clk net86 0.04546f
C27633 _174_ _076_ 0
C27634 net57 _651_/a_298_337# 0
C27635 rx_inst.state\[1\] net19 0.03713f
C27636 clknet_4_12_0_clk net180 0
C27637 hold131/a_56_118# _138_ 0
C27638 clknet_4_1_0_clk _386_/a_496_118# 0.00114f
C27639 _168_ net119 0.00104f
C27640 _234_ _153_ 0.01795f
C27641 net55 _705_/a_324_432# 0
C27642 baud_inst.counter\[4\] _493_/a_45_160# 0.00246f
C27643 hold177/a_56_118# baud_inst.counter\[15\] 0
C27644 net45 net49 0.90768f
C27645 hold64/a_56_118# net64 0
C27646 hold56/a_56_118# _666_/a_38_114# 0.02058f
C27647 _689_/a_324_432# clknet_4_2_0_clk 0.01065f
C27648 hold87/a_326_118# baud_inst.counter\[14\] 0
C27649 hold179/a_56_118# FILLER_1_212/a_32_246# 0.00404f
C27650 hold131/a_56_118# _232_ 0.00515f
C27651 _254_ VPWR 0.1076f
C27652 _232_ FILLER_25_163/a_32_246# 0
C27653 net35 _225_ 0.85965f
C27654 _654_/a_843_236# net170 0
C27655 _082_ net26 0
C27656 _553_/a_170_412# _314_ 0
C27657 hold170/a_326_118# _206_ 0
C27658 _360_/a_71_118# tx_inst.bit_index\[1\] 0.04824f
C27659 VPWR _681_/a_1785_429# 0
C27660 hold85/a_438_182# clkbuf_4_13_0_clk/a_27_118# 0.00186f
C27661 _369_/a_146_122# net172 0.00503f
C27662 hold90/a_438_182# clknet_4_9_0_clk 0.05786f
C27663 _022_ net149 0.001f
C27664 _696_/a_1785_429# net46 0
C27665 _696_/a_2250_412# _099_ 0
C27666 _073_ _120_ 0.04702f
C27667 _041_ _372_/a_22_110# 0.01313f
C27668 _232_ net47 0
C27669 rx_inst.bit_index\[1\] _451_/a_155_412# 0
C27670 _109_ net141 0.01462f
C27671 _643_/a_2002_114# _160_ 0
C27672 net122 baud_inst.counter\[4\] 0
C27673 _659_/a_324_432# clknet_4_1_0_clk 0.02669f
C27674 fanout33/a_40_152# net33 0.00349f
C27675 hold96/a_438_182# _183_ 0
C27676 rx_inst.state\[1\] hold51/a_326_118# 0.05123f
C27677 _091_ _282_ 0
C27678 net39 _689_/a_681_505# 0
C27679 baud_inst.counter\[31\] net114 0
C27680 net109 _010_ 0.03364f
C27681 clknet_4_3_0_clk _677_/a_1785_429# 0
C27682 _372_/a_120_432# _169_ 0.00705f
C27683 VPWR _649_/a_2250_412# 0.0048f
C27684 fanout36/a_40_152# _255_ 0.07605f
C27685 tx_data[4] VPWR 0.01466f
C27686 _662_/a_298_337# _065_ 0
C27687 _275_ net43 0.15437f
C27688 net43 _667_/a_1489_191# 0.01821f
C27689 _460_/a_120_432# _266_ 0
C27690 _697_/a_38_114# _696_/a_1583_191# 0
C27691 _697_/a_298_337# _696_/a_1840_334# 0
C27692 _314_ _702_/a_324_432# 0
C27693 hold99/a_438_182# _698_/a_741_93# 0
C27694 hold99/a_326_118# _698_/a_843_236# 0
C27695 clk _653_/a_2250_412# 0.04642f
C27696 hold154/a_326_118# VPWR 0.00613f
C27697 FILLER_19_75/a_40_246# _311_ 0
C27698 net26 clknet_0_clk 0.15714f
C27699 _113_ net68 0
C27700 _536_/a_192_429# _536_/a_341_118# -0
C27701 _073_ _664_/a_741_93# 0.00266f
C27702 net132 net24 0
C27703 _233_ _228_ 0.08164f
C27704 net31 _229_ 0.19678f
C27705 net2 _224_ 0.51979f
C27706 _652_/a_38_114# _063_ 0.00479f
C27707 _705_/a_843_236# net22 0.01565f
C27708 _163_ _684_/a_1785_429# 0.00297f
C27709 _420_/a_248_122# VPWR 0
C27710 net32 clknet_0_clk 0.08002f
C27711 net94 hold95/a_326_118# 0.00472f
C27712 net92 hold95/a_56_118# 0.0363f
C27713 _080_ _652_/a_1583_191# 0
C27714 hold158/a_326_118# _296_ 0
C27715 hold158/a_56_118# _015_ 0.00602f
C27716 FILLER_2_79/a_40_246# _181_ 0.00195f
C27717 hold182/a_326_118# net123 0.00732f
C27718 hold160/a_326_118# net156 0.01208f
C27719 net125 net49 0.00176f
C27720 clknet_0_clk hold94/a_56_118# 0.00367f
C27721 net98 FILLER_8_21/a_32_246# 0
C27722 net39 _290_ 0.00223f
C27723 _023_ _304_ 0
C27724 _479_/a_22_110# _664_/a_1583_191# 0
C27725 _206_ VPWR 1.37055f
C27726 _672_/a_324_432# FILLER_2_46/a_40_246# 0.00155f
C27727 net110 _010_ 0.0083f
C27728 _677_/a_741_93# baud_inst.counter\[5\] 0
C27729 _152_ _666_/a_2250_412# 0
C27730 hold182/a_438_182# _191_ 0.01236f
C27731 _639_/a_1583_191# _121_ 0
C27732 net146 _666_/a_1583_191# 0
C27733 _679_/a_38_114# net135 0.01161f
C27734 _679_/a_298_337# _287_ 0.03165f
C27735 _669_/a_741_93# _669_/a_843_236# 0
C27736 tx_inst.bit_index\[1\] _653_/a_38_114# 0
C27737 net173 hold184/a_56_118# 0.05395f
C27738 net42 _475_/a_170_412# 0
C27739 clknet_0_clk hold62/a_326_118# 0.00389f
C27740 hold117/a_438_182# _288_ 0.00623f
C27741 hold117/a_326_118# net116 0.01615f
C27742 hold117/a_56_118# _039_ 0.03456f
C27743 _424_/a_244_412# clkbuf_4_14_0_clk/a_27_118# 0
C27744 _345_/a_150_412# baud_inst.counter\[23\] 0.00373f
C27745 _662_/a_1583_191# net54 0.01445f
C27746 _239_ _420_/a_248_122# 0
C27747 net50 _121_ 0.00133f
C27748 _670_/a_741_93# baud_inst.counter\[4\] 0
C27749 _439_/a_252_412# _161_ 0.00577f
C27750 _699_/a_843_236# VPWR 0.00894f
C27751 _021_ _107_ 0
C27752 hold166/a_438_182# net26 0.02571f
C27753 net111 _057_ 0
C27754 _263_ _261_ 0
C27755 _661_/a_2250_412# _387_/a_46_156# 0
C27756 hold96/a_438_182# net115 0.00225f
C27757 VPWR _651_/a_1840_334# 0.00592f
C27758 _662_/a_1785_429# clknet_4_5_0_clk 0
C27759 net145 clkbuf_4_4_0_clk/a_27_118# 0
C27760 baud_inst.counter\[10\] _183_ 0.10421f
C27761 _013_ _296_ 0
C27762 net44 _696_/a_132_114# 0
C27763 hold130/a_326_118# net90 0
C27764 _227_ hold166/a_326_118# 0
C27765 _125_ _266_ 0.01038f
C27766 output15/a_40_152# hold73/a_56_118# 0
C27767 _637_/a_1840_334# _264_ 0
C27768 VPWR _416_/a_146_122# 0
C27769 _248_ _140_ 0
C27770 clknet_4_8_0_clk _165_ 0.02902f
C27771 _070_ _385_/a_268_412# 0
C27772 tx_inst.bit_index\[1\] _172_ 0.22284f
C27773 _680_/a_324_432# baud_inst.counter\[9\] 0
C27774 net39 hold108/a_56_118# 0.00579f
C27775 baud_inst.counter\[14\] _296_ 0.1323f
C27776 _408_/a_154_118# net24 0
C27777 hold175/a_56_118# _262_ 0.00856f
C27778 _655_/a_38_114# net40 0.04427f
C27779 _127_ _649_/a_2250_412# 0
C27780 _658_/a_298_337# _069_ 0.03381f
C27781 _285_ _037_ 0
C27782 _191_ _667_/a_298_337# 0
C27783 _695_/a_298_337# net76 0
C27784 net79 hold115/a_438_182# 0
C27785 _194_ VPWR 0.28097f
C27786 _542_/a_257_140# baud_inst.counter\[24\] 0.00137f
C27787 clknet_4_0_0_clk _349_/a_146_122# 0
C27788 _286_ net95 0.00102f
C27789 _468_/a_22_110# _647_/a_2250_412# 0
C27790 _233_ _153_ 0.12336f
C27791 _091_ _655_/a_298_337# 0
C27792 VPWR hold92/a_56_118# 0.00141f
C27793 net177 _684_/a_741_93# 0
C27794 net2 _235_ 0
C27795 net72 rx_inst.data_reg\[5\] 0.18892f
C27796 net168 _666_/a_324_432# 0.00122f
C27797 _079_ _231_ 0
C27798 net49 _409_/a_73_118# 0.00267f
C27799 net48 _650_/a_324_432# 0
C27800 _702_/a_843_236# _700_/a_2250_412# 0
C27801 _688_/a_843_236# net40 0.02939f
C27802 _002_ _669_/a_2002_114# 0
C27803 net104 _690_/a_298_337# 0
C27804 net49 _442_/a_350_122# 0
C27805 _147_ _386_/a_496_118# 0.00142f
C27806 _081_ _650_/a_843_236# 0
C27807 _659_/a_681_505# net41 0
C27808 net67 hold58/a_438_182# 0
C27809 _248_ net49 0
C27810 _693_/a_843_236# _302_ 0
C27811 _170_ _447_/a_81_118# 0
C27812 net94 _086_ 0.00122f
C27813 net92 net40 0.02014f
C27814 fanout43/a_40_152# net49 0.0215f
C27815 _632_/a_38_114# _273_ 0.00132f
C27816 _632_/a_324_432# net64 0.00107f
C27817 _341_/a_500_118# tx_inst.data_reg\[0\] 0.00291f
C27818 net41 _120_ 0
C27819 _080_ hold122/a_326_118# 0
C27820 _100_ _687_/a_612_127# 0
C27821 _059_ _463_/a_22_110# 0
C27822 _238_ net24 0.03372f
C27823 net2 _409_/a_269_412# 0.00188f
C27824 _264_ FILLER_18_210/a_32_246# 0
C27825 _266_ _649_/a_2250_412# 0.02632f
C27826 net30 _649_/a_1785_429# 0
C27827 _414_/a_165_412# net28 0.0014f
C27828 _177_ _699_/a_612_127# 0.01673f
C27829 net94 _091_ 0.00255f
C27830 hold68/a_326_118# baud_inst.counter\[29\] 0.00496f
C27831 net100 _546_/a_155_160# 0
C27832 hold100/a_56_118# _026_ 0.05532f
C27833 net55 _658_/a_324_432# 0
C27834 clknet_4_0_0_clk _038_ 0.00107f
C27835 baud_inst.counter\[12\] baud_inst.counter\[15\] 0
C27836 tx_inst.data_reg\[6\] _341_/a_805_385# 0.00395f
C27837 _676_/a_1840_334# baud_inst.counter\[5\] 0
C27838 _659_/a_324_432# _147_ 0.02383f
C27839 _659_/a_741_93# _068_ 0.00312f
C27840 baud_inst.counter\[6\] _496_/a_170_412# 0
C27841 hold183/a_56_118# _216_ 0.02072f
C27842 _696_/a_38_114# baud_inst.counter\[15\] 0
C27843 _698_/a_132_114# VPWR 0
C27844 _392_/a_59_156# _664_/a_38_114# 0
C27845 _392_/a_382_118# _664_/a_298_337# 0
C27846 hold96/a_438_182# clknet_4_3_0_clk 0
C27847 baud_inst.counter\[17\] _522_/a_209_168# 0.00115f
C27848 hold158/a_56_118# net39 0
C27849 net37 _249_ 0.01982f
C27850 _178_ _699_/a_2250_412# 0.00645f
C27851 baud_inst.counter\[10\] net115 0
C27852 baud_inst.counter\[5\] _683_/a_1840_334# 0
C27853 _129_ VPWR 0.2527f
C27854 _045_ FILLER_29_198/a_40_246# 0.00355f
C27855 _154_ _649_/a_681_505# 0
C27856 _675_/a_1489_191# _030_ 0
C27857 _525_/a_46_156# baud_inst.counter\[16\] 0
C27858 net157 _524_/a_248_122# 0
C27859 baud_inst.counter\[12\] net108 0.0014f
C27860 _299_ _524_/a_146_122# 0
C27861 FILLER_25_198/a_32_246# clknet_0_clk 0.00135f
C27862 baud_inst.counter\[20\] _692_/a_298_337# 0.00334f
C27863 _670_/a_1583_191# clknet_4_9_0_clk 0.00611f
C27864 baud_inst.counter\[15\] net88 0.6139f
C27865 _205_ _670_/a_2250_412# 0.00154f
C27866 net27 _664_/a_298_337# 0
C27867 _645_/a_324_432# _232_ 0
C27868 _661_/a_1583_191# input5/a_40_152# 0.00158f
C27869 hold136/a_56_118# net86 0.00175f
C27870 hold136/a_326_118# net181 0
C27871 hold98/a_56_118# net97 0
C27872 _089_ _652_/a_38_114# 0
C27873 _230_ _236_ 0.68671f
C27874 _140_ net139 0
C27875 _243_ _253_ 0
C27876 _656_/a_324_432# FILLER_0_161/a_40_246# 0
C27877 _658_/a_324_432# _067_ 0
C27878 _658_/a_298_337# clknet_4_4_0_clk 0.00114f
C27879 FILLER_16_154/a_32_246# net26 0
C27880 _055_ VPWR 0.19604f
C27881 net49 _245_ 0.69183f
C27882 hold52/a_438_182# _236_ 0.00158f
C27883 hold175/a_438_182# clknet_0_clk 0.00197f
C27884 _198_ net168 0.13497f
C27885 _202_ VPWR 0.11021f
C27886 _467_/a_22_110# net64 0.00125f
C27887 _384_/a_59_156# _148_ 0.00227f
C27888 _384_/a_285_412# net171 0
C27889 net128 _685_/a_612_127# 0.00538f
C27890 _650_/a_741_93# _157_ 0
C27891 hold78/a_56_118# _158_ 0
C27892 _690_/a_2002_114# _296_ 0
C27893 FILLER_16_154/a_32_246# net32 0
C27894 _341_/a_886_118# VPWR 0.00427f
C27895 _676_/a_38_114# clknet_0_clk 0.02519f
C27896 _224_ _169_ 0.0069f
C27897 _155_ _463_/a_22_110# 0.00984f
C27898 _679_/a_298_337# clkbuf_4_0_0_clk/a_27_118# 0
C27899 tx_inst.state\[4\] net27 0.00139f
C27900 FILLER_12_117/a_40_246# _670_/a_324_432# 0
C27901 _311_ _309_ 0.04729f
C27902 tx_inst.bit_index\[1\] clk 0.67157f
C27903 _141_ _142_ 0.05855f
C27904 output23/a_40_152# _705_/a_1489_191# 0
C27905 _113_ hold105/a_326_118# 0
C27906 rx_data[1] net77 0
C27907 net13 _272_ 0
C27908 _100_ _308_ 0
C27909 net42 _141_ 0
C27910 _064_ _222_ 0
C27911 _653_/a_843_236# _063_ 0
C27912 _080_ net49 0
C27913 _698_/a_298_337# FILLER_20_106/a_32_246# 0
C27914 FILLER_12_173/a_32_246# net29 0.00402f
C27915 _167_ _416_/a_146_122# 0
C27916 baud_inst.counter\[26\] _698_/a_2002_114# 0
C27917 _660_/a_612_127# net41 0
C27918 net55 _042_ 0
C27919 hold122/a_326_118# _041_ 0.00217f
C27920 net39 FILLER_12_42/a_32_246# 0.01843f
C27921 net27 _671_/a_741_93# 0
C27922 net50 clknet_0_clk 0.01457f
C27923 _411_/a_358_436# net2 0.01211f
C27924 net51 _668_/a_1840_334# 0.01249f
C27925 net44 net163 0.23581f
C27926 _138_ _649_/a_324_432# 0
C27927 _506_/a_155_412# _289_ 0.00163f
C27928 net57 _651_/a_1583_191# 0
C27929 _537_/a_192_429# _692_/a_843_236# 0
C27930 net47 _634_/a_324_432# 0.05126f
C27931 net55 _656_/a_843_236# 0.00259f
C27932 net39 net108 0.01016f
C27933 _246_ _435_/a_72_436# 0
C27934 _008_ _085_ 0.60073f
C27935 FILLER_11_32/a_32_246# clknet_4_2_0_clk 0.00433f
C27936 _232_ _649_/a_324_432# 0
C27937 FILLER_23_204/a_40_246# _649_/a_1583_191# 0
C27938 _689_/a_2250_412# clknet_4_2_0_clk 0.00634f
C27939 hold122/a_56_118# _169_ 0
C27940 net167 net46 0
C27941 _538_/a_175_118# VPWR 0
C27942 output22/a_40_152# _705_/a_324_432# 0
C27943 hold129/a_326_118# _189_ 0.00177f
C27944 hold129/a_56_118# _190_ 0
C27945 tx_inst.data_reg\[0\] _380_/a_59_156# 0
C27946 net26 FILLER_6_189/a_40_246# 0
C27947 hold161/a_438_182# _102_ 0
C27948 _360_/a_382_118# net184 0.00373f
C27949 rx_data[0] net30 0
C27950 tx_data[7] net38 0.002f
C27951 _292_ _289_ 0
C27952 hold74/a_438_182# _125_ 0
C27953 net36 net24 0.678f
C27954 net156 _017_ 0
C27955 FILLER_17_131/a_32_246# _669_/a_1583_191# 0
C27956 hold65/a_56_118# rx_data[6] 0
C27957 rx_inst.data_reg\[1\] clkbuf_4_14_0_clk/a_27_118# 0
C27958 hold123/a_326_118# _670_/a_324_432# 0
C27959 net112 _232_ 0
C27960 _205_ net63 0.05624f
C27961 net28 _234_ 0.07119f
C27962 _479_/a_22_110# FILLER_5_207/a_32_246# 0
C27963 net20 _705_/a_1583_191# 0.00234f
C27964 baud_inst.counter\[22\] FILLER_25_36/a_32_246# 0.00423f
C27965 _310_ FILLER_23_83/a_32_246# 0
C27966 _517_/a_209_168# _012_ 0
C27967 _643_/a_843_236# _649_/a_843_236# 0
C27968 hold55/a_438_182# tx_start 0.00152f
C27969 net39 _689_/a_550_127# 0
C27970 _676_/a_38_114# _182_ 0
C27971 net13 _469_/a_22_110# 0
C27972 hold86/a_56_118# hold79/a_326_118# 0
C27973 _662_/a_843_236# tx_inst.data_reg\[0\] 0
C27974 _129_ _266_ 0.00714f
C27975 clknet_4_14_0_clk FILLER_24_133/a_32_246# 0
C27976 _656_/a_324_432# clknet_4_4_0_clk 0.03863f
C27977 _656_/a_843_236# _067_ 0.00161f
C27978 _656_/a_38_114# tx_inst.data_reg\[2\] 0
C27979 _500_/a_155_412# clknet_4_1_0_clk 0
C27980 _536_/a_155_160# _022_ 0
C27981 _088_ hold61/a_438_182# 0
C27982 tx_inst.data_reg\[7\] FILLER_3_141/a_40_246# 0.01105f
C27983 _073_ _664_/a_1785_429# 0
C27984 _663_/a_324_432# tx_inst.state\[1\] 0
C27985 _663_/a_741_93# clknet_4_7_0_clk 0.03585f
C27986 _169_ _235_ 0
C27987 _695_/a_132_114# _108_ 0
C27988 _643_/a_1489_191# net47 0.00186f
C27989 _643_/a_550_127# _054_ 0
C27990 baud_inst.counter\[6\] clknet_0_clk 0.25044f
C27991 _705_/a_612_127# net22 0.00606f
C27992 _447_/a_81_118# _237_ 0
C27993 _652_/a_1840_334# _063_ -0
C27994 _643_/a_132_114# net112 0
C27995 _293_ _281_ 0
C27996 _080_ _652_/a_2002_114# 0
C27997 hold127/a_56_118# _154_ 0.01264f
C27998 net54 _208_ 0.02482f
C27999 hold110/a_56_118# net135 0
C28000 tx_inst.bit_index\[1\] FILLER_5_156/a_32_246# 0.00356f
C28001 hold172/a_438_182# net11 0.0202f
C28002 _095_ FILLER_8_21/a_32_246# 0
C28003 baud_inst.counter\[8\] _512_/a_165_412# 0
C28004 net96 net115 0
C28005 _651_/a_324_432# _221_ 0
C28006 hold149/a_56_118# _107_ 0
C28007 _275_ _664_/a_2250_412# 0
C28008 hold140/a_56_118# _697_/a_843_236# 0
C28009 net58 _699_/a_1583_191# 0
C28010 hold140/a_438_182# _697_/a_324_432# 0
C28011 hold140/a_326_118# _697_/a_741_93# 0
C28012 net39 FILLER_10_14/a_40_246# 0.02353f
C28013 net50 _704_/a_298_337# 0.00489f
C28014 _177_ baud_inst.counter\[23\] 0
C28015 net151 _056_ 0.05471f
C28016 baud_inst.counter\[1\] _673_/a_38_114# 0
C28017 hold86/a_438_182# _673_/a_843_236# 0
C28018 net184 net9 0
C28019 hold124/a_56_118# VPWR 0.00532f
C28020 FILLER_19_139/a_40_246# net2 0
C28021 _707_/a_324_432# FILLER_13_228/a_40_246# 0
C28022 net87 _024_ 0.00116f
C28023 _064_ FILLER_7_121/a_40_246# 0.00259f
C28024 tx_inst.bit_index\[1\] _653_/a_1840_334# 0.03668f
C28025 net35 _232_ 0.48412f
C28026 FILLER_15_89/a_32_246# net91 0.01248f
C28027 baud_inst.counter\[21\] baud_inst.counter\[19\] 0
C28028 _023_ FILLER_22_22/a_32_246# 0
C28029 _639_/a_741_93# hold81/a_56_118# 0
C28030 _047_ net80 0.00152f
C28031 _548_/a_76_160# baud_inst.counter\[25\] 0.00247f
C28032 _694_/a_38_114# VPWR 0.04129f
C28033 _178_ baud_inst.counter\[21\] 0.00463f
C28034 _049_ _649_/a_1840_334# 0
C28035 _662_/a_2002_114# net54 0
C28036 net44 hold167/a_438_182# 0
C28037 _082_ hold167/a_326_118# 0
C28038 net34 clknet_0_clk 0.01424f
C28039 _251_ _161_ 0.35379f
C28040 _699_/a_612_127# VPWR 0.00157f
C28041 _431_/a_175_118# _241_ 0
C28042 _695_/a_741_93# net46 0
C28043 hold110/a_326_118# baud_inst.counter\[8\] 0.00657f
C28044 _102_ _689_/a_298_337# 0.01364f
C28045 hold171/a_326_118# net165 0.00702f
C28046 _674_/a_681_505# VPWR 0
C28047 FILLER_11_123/a_40_246# baud_inst.counter\[4\] 0.02592f
C28048 hold177/a_326_118# clknet_4_8_0_clk 0
C28049 net44 _696_/a_1489_191# 0.00265f
C28050 _662_/a_298_337# VPWR 0.00411f
C28051 FILLER_19_132/a_40_246# net24 0.03249f
C28052 hold52/a_326_118# _224_ 0.06557f
C28053 _302_ _701_/a_38_114# 0
C28054 net76 _303_ 0
C28055 _663_/a_132_114# _166_ 0
C28056 hold53/a_438_182# _640_/a_324_432# 0
C28057 hold53/a_326_118# _640_/a_741_93# 0.00291f
C28058 hold53/a_56_118# _640_/a_843_236# 0.00276f
C28059 clknet_4_1_0_clk net38 1.78271f
C28060 _655_/a_1840_334# net40 0
C28061 clknet_4_7_0_clk input2/a_40_152# 0.00135f
C28062 baud_inst.counter\[6\] _182_ 0.0022f
C28063 hold108/a_438_182# FILLER_13_68/a_40_246# 0
C28064 _215_ net146 0.00825f
C28065 _677_/a_741_93# clknet_0_clk 0.00996f
C28066 _087_ hold61/a_56_118# 0
C28067 hold167/a_326_118# clknet_0_clk 0.00187f
C28068 hold114/a_438_182# hold105/a_56_118# 0
C28069 net45 FILLER_24_4/a_40_246# 0
C28070 net27 FILLER_7_210/a_40_246# 0.00529f
C28071 output21/a_40_152# clknet_4_7_0_clk 0
C28072 _639_/a_843_236# hold51/a_438_182# 0.00191f
C28073 net44 hold140/a_438_182# 0.00251f
C28074 _200_ _666_/a_1840_334# 0
C28075 fanout27/a_40_152# _651_/a_1583_191# 0.00127f
C28076 _098_ _685_/a_324_432# 0.04539f
C28077 hold104/a_438_182# _018_ 0.01358f
C28078 _678_/a_843_236# VPWR 0.00375f
C28079 _115_ _700_/a_741_93# 0.03633f
C28080 net68 _700_/a_324_432# 0.00119f
C28081 net3 FILLER_0_174/a_32_246# 0
C28082 net96 clknet_4_3_0_clk 0
C28083 hold146/a_56_118# net50 0.00838f
C28084 hold146/a_326_118# net146 0.0416f
C28085 net26 net43 0.02302f
C28086 net49 _255_ 0.04228f
C28087 net145 VPWR 0.01108f
C28088 clkbuf_4_5_0_clk/a_27_118# net172 0.00809f
C28089 hold108/a_438_182# _683_/a_324_432# 0
C28090 baud_inst.counter\[13\] _684_/a_38_114# 0.01794f
C28091 _187_ _684_/a_324_432# 0
C28092 _269_ FILLER_18_210/a_32_246# 0
C28093 net131 _245_ 0.00318f
C28094 _058_ hold139/a_326_118# 0.01561f
C28095 _036_ hold92/a_438_182# 0.00186f
C28096 net16 VPWR 0.32037f
C28097 hold150/a_438_182# rx_inst.data_reg\[1\] 0
C28098 net35 _442_/a_248_122# 0
C28099 hold96/a_56_118# baud_inst.counter\[8\] 0
C28100 net163 _302_ 0.04514f
C28101 hold124/a_56_118# _127_ 0
C28102 _233_ net28 0.00371f
C28103 hold176/a_56_118# _131_ 0.06261f
C28104 hold176/a_438_182# _261_ 0
C28105 hold176/a_326_118# _262_ 0.00228f
C28106 _646_/a_2250_412# net84 0
C28107 baud_inst.counter\[28\] net67 0.18417f
C28108 _252_ _437_/a_154_118# 0
C28109 _424_/a_244_412# _154_ 0.00484f
C28110 _444_/a_142_412# net24 0.003f
C28111 baud_inst.counter\[20\] hold120/a_56_118# 0.01122f
C28112 _431_/a_277_118# net49 0
C28113 _636_/a_612_127# hold84/a_438_182# 0
C28114 _060_ _054_ 0.00259f
C28115 _671_/a_843_236# clkbuf_4_6_0_clk/a_27_118# 0.00301f
C28116 _636_/a_741_93# _264_ 0.05423f
C28117 _449_/a_27_156# net180 0
C28118 rx_inst.state\[2\] fanout25/a_40_152# 0
C28119 net128 _514_/a_257_140# 0.00404f
C28120 _655_/a_741_93# tx_data[7] 0
C28121 _276_ _664_/a_38_114# 0
C28122 _659_/a_1583_191# tx_inst.data_reg\[3\] 0.01401f
C28123 _171_ _664_/a_741_93# 0
C28124 _696_/a_1583_191# baud_inst.counter\[14\] 0
C28125 net48 _456_/a_155_412# 0.00108f
C28126 _698_/a_1489_191# VPWR 0
C28127 hold140/a_326_118# clknet_0_clk 0.01153f
C28128 clkbuf_4_4_0_clk/a_27_118# _220_ 0
C28129 hold178/a_438_182# net40 0.0129f
C28130 hold102/a_56_118# _017_ 0.04556f
C28131 net37 net51 0.2493f
C28132 _382_/a_285_412# _209_ 0
C28133 baud_inst.counter\[17\] _296_ 0.11604f
C28134 _045_ rx_inst.data_reg\[5\] 0.01377f
C28135 rx_inst.data_reg\[2\] hold150/a_326_118# 0.0064f
C28136 rx_inst.bit_index\[1\] VPWR 0.4041f
C28137 _154_ _649_/a_550_127# 0
C28138 _661_/a_843_236# _210_ 0.0054f
C28139 FILLER_16_176/a_40_246# net25 0
C28140 _223_ _247_ 0.02673f
C28141 _012_ hold108/a_56_118# 0
C28142 _688_/a_298_337# net160 0
C28143 net15 rx_data[3] 0.24757f
C28144 rx_data[7] _639_/a_843_236# 0
C28145 tx _665_/a_741_93# 0
C28146 baud_inst.counter\[20\] _692_/a_1583_191# 0.00916f
C28147 hold124/a_326_118# net30 0
C28148 hold124/a_56_118# _266_ 0
C28149 _360_/a_71_118# _341_/a_382_118# 0
C28150 _360_/a_382_118# _341_/a_71_118# 0
C28151 _677_/a_741_93# _182_ 0.02642f
C28152 _670_/a_2002_114# clknet_4_9_0_clk 0
C28153 _204_ _667_/a_1840_334# 0
C28154 VPWR _503_/a_165_412# 0
C28155 net27 _664_/a_1583_191# 0.00243f
C28156 _099_ _669_/a_298_337# 0
C28157 net46 _669_/a_38_114# 0
C28158 _555_/a_380_412# clknet_4_11_0_clk 0
C28159 hold157/a_438_182# net161 0
C28160 hold76/a_438_182# _302_ 0.00335f
C28161 net49 FILLER_17_22/a_40_246# 0
C28162 net70 net18 0
C28163 _699_/a_1583_191# _027_ 0.01032f
C28164 _021_ _693_/a_298_337# 0.03187f
C28165 net148 _693_/a_324_432# 0
C28166 _658_/a_1583_191# clknet_4_4_0_clk 0.01284f
C28167 _658_/a_2250_412# _067_ 0.06341f
C28168 clknet_4_12_0_clk net37 0.02326f
C28169 _257_ FILLER_21_147/a_40_246# 0.0035f
C28170 net37 net123 0
C28171 net51 _650_/a_298_337# 0
C28172 baud_inst.counter\[20\] hold148/a_438_182# 0
C28173 net128 net130 0.00401f
C28174 _240_ _247_ 0
C28175 net145 _339_/a_1023_118# 0
C28176 FILLER_5_74/a_32_246# clknet_0_clk 0.01791f
C28177 _676_/a_1840_334# clknet_0_clk 0
C28178 _645_/a_843_236# net47 0
C28179 _391_/a_46_156# net41 0.0066f
C28180 _291_ clknet_4_2_0_clk 0.0017f
C28181 _679_/a_843_236# clknet_0_clk 0
C28182 clkbuf_4_9_0_clk/a_27_118# _099_ 0.01016f
C28183 output12/a_40_152# _638_/a_2250_412# 0
C28184 FILLER_2_110/a_32_246# clknet_4_1_0_clk 0
C28185 output23/a_40_152# net22 0.00364f
C28186 _465_/a_22_110# hold81/a_56_118# 0
C28187 _232_ _254_ 0.01801f
C28188 hold52/a_56_118# net49 0
C28189 clknet_0_clk _683_/a_1840_334# 0.00255f
C28190 _095_ _689_/a_1583_191# 0.00209f
C28191 _688_/a_2250_412# _288_ 0
C28192 _644_/a_324_432# _255_ 0
C28193 _264_ hold81/a_326_118# 0.00149f
C28194 _548_/a_170_160# net140 0
C28195 _548_/a_76_160# baud_inst.counter\[24\] 0
C28196 _699_/a_741_93# net45 0.01694f
C28197 _230_ net2 0.53881f
C28198 _260_ net25 0.23393f
C28199 hold57/a_326_118# clknet_4_6_0_clk 0
C28200 _305_ _692_/a_843_236# 0.00141f
C28201 _644_/a_132_114# net49 0
C28202 hold52/a_438_182# net2 0.05535f
C28203 _023_ _692_/a_741_93# 0
C28204 _706_/a_681_505# net43 0
C28205 _706_/a_843_236# _120_ 0
C28206 net174 _480_/a_120_432# 0.00289f
C28207 _671_/a_38_114# rx_inst.state\[4\] 0.02135f
C28208 VPWR FILLER_22_152/a_32_246# 0.08592f
C28209 _170_ hold112/a_56_118# 0.05941f
C28210 hold163/a_438_182# clknet_4_8_0_clk 0
C28211 baud_inst.counter\[23\] VPWR 0.55574f
C28212 input5/a_40_152# FILLER_0_130/a_32_246# 0.00624f
C28213 _377_/a_46_156# net6 0.00124f
C28214 _144_ net170 0
C28215 net16 _266_ 0.26478f
C28216 rx_data[4] net30 0.01303f
C28217 _474_/a_22_110# clknet_0_clk 0.00373f
C28218 _360_/a_1377_160# _193_ 0
C28219 clkbuf_4_4_0_clk/a_27_118# FILLER_6_151/a_40_246# 0.01094f
C28220 VPWR _100_ 0.14157f
C28221 _158_ _633_/a_298_337# 0.00189f
C28222 _660_/a_38_114# _175_ 0
C28223 clknet_4_1_0_clk _655_/a_741_93# 0.04609f
C28224 _660_/a_324_432# _174_ 0
C28225 hold57/a_438_182# _217_ 0
C28226 hold57/a_326_118# _218_ 0
C28227 net48 _639_/a_324_432# 0
C28228 rx_inst.state\[2\] FILLER_17_162/a_32_246# 0
C28229 _696_/a_324_432# clknet_4_8_0_clk 0.0164f
C28230 _180_ net46 3.5681f
C28231 hold120/a_56_118# _701_/a_298_337# 0
C28232 hold68/a_56_118# _031_ 0.03207f
C28233 _645_/a_681_505# net49 0.00108f
C28234 _232_ _420_/a_248_122# 0
C28235 net75 hold148/a_56_118# 0
C28236 hold137/a_438_182# VPWR 0.00284f
C28237 net97 _683_/a_741_93# 0
C28238 net108 _683_/a_843_236# 0.04278f
C28239 _679_/a_298_337# net181 0
C28240 hold174/a_56_118# hold169/a_56_118# 0
C28241 net173 hold183/a_438_182# 0
C28242 net123 _670_/a_843_236# 0.03976f
C28243 VPWR _472_/a_120_432# 0.00872f
C28244 net47 _649_/a_843_236# 0
C28245 _054_ _649_/a_741_93# 0
C28246 FILLER_0_174/a_32_246# _150_ 0.01733f
C28247 _292_ net135 0
C28248 net109 _509_/a_155_412# 0.00415f
C28249 _191_ _670_/a_681_505# 0
C28250 net39 clknet_4_9_0_clk 0
C28251 hold77/a_438_182# _633_/a_1840_334# 0
C28252 net49 _051_ 0.01647f
C28253 _643_/a_1583_191# _649_/a_1840_334# 0
C28254 _643_/a_1840_334# _649_/a_1583_191# 0
C28255 rx_inst.bit_index\[1\] _641_/a_741_93# 0
C28256 _013_ _294_ 0.531f
C28257 hold78/a_438_182# net78 0
C28258 FILLER_22_118/a_32_246# VPWR 0.09791f
C28259 hold157/a_56_118# VPWR 0.01166f
C28260 _307_ _695_/a_1583_191# 0
C28261 clknet_4_8_0_clk _014_ 0
C28262 _307_ _542_/a_257_140# 0.00132f
C28263 VPWR _632_/a_681_505# 0
C28264 _662_/a_612_127# tx_inst.data_reg\[0\] 0
C28265 _073_ _654_/a_1489_191# 0
C28266 _679_/a_843_236# _182_ 0
C28267 net142 _696_/a_843_236# 0.00152f
C28268 _656_/a_612_127# _067_ 0.00483f
C28269 _656_/a_1840_334# tx_inst.data_reg\[2\] 0.00866f
C28270 _341_/a_382_118# _172_ 0
C28271 rx_inst.data_reg\[7\] _457_/a_120_432# 0
C28272 baud_inst.counter\[8\] _506_/a_257_140# 0.0021f
C28273 _294_ baud_inst.counter\[14\] 0.19801f
C28274 _226_ fanout25/a_40_152# 0.00361f
C28275 _411_/a_115_308# _230_ 0.00696f
C28276 _663_/a_2250_412# tx_inst.state\[1\] 0.00531f
C28277 _182_ _683_/a_1840_334# 0.00204f
C28278 _706_/a_741_93# net21 0
C28279 _116_ net105 0
C28280 _123_ FILLER_29_179/a_40_246# 0.00123f
C28281 baud_inst.counter\[12\] _358_/a_166_436# 0
C28282 _004_ _404_/a_268_412# 0
C28283 VPWR _668_/a_741_93# 0.01834f
C28284 clknet_0_clk hold180/a_438_182# 0
C28285 _644_/a_2250_412# _245_ 0
C28286 hold171/a_326_118# _658_/a_741_93# 0
C28287 hold171/a_56_118# _658_/a_843_236# 0
C28288 hold171/a_438_182# _658_/a_324_432# 0
C28289 _041_ _651_/a_298_337# 0.00181f
C28290 net128 _686_/a_1840_334# 0
C28291 FILLER_21_165/a_40_246# clknet_0_clk 0.00132f
C28292 hold105/a_56_118# _700_/a_741_93# 0
C28293 hold105/a_326_118# _700_/a_324_432# 0
C28294 _214_ FILLER_2_183/a_32_246# 0.0011f
C28295 _111_ _698_/a_843_236# 0.00171f
C28296 net45 _698_/a_681_505# 0
C28297 rx_inst.bit_index\[1\] _225_ 0.16307f
C28298 baud_inst.counter\[8\] _010_ 0
C28299 _696_/a_324_432# _686_/a_1840_334# 0
C28300 _696_/a_741_93# _686_/a_1583_191# 0
C28301 _696_/a_1583_191# _686_/a_741_93# 0
C28302 baud_inst.counter\[30\] _702_/a_741_93# 0.04592f
C28303 baud_inst.counter\[28\] _702_/a_681_505# 0
C28304 hold66/a_326_118# VPWR 0.00694f
C28305 hold136/a_56_118# net38 0
C28306 _316_ _699_/a_1489_191# 0
C28307 net73 output19/a_40_152# 0
C28308 baud_inst.counter\[1\] _673_/a_1840_334# 0.00401f
C28309 rx_inst.state\[3\] net167 0
C28310 VPWR _648_/a_324_432# 0.02924f
C28311 VPWR _380_/a_559_412# 0
C28312 net18 _634_/a_1583_191# 0.00455f
C28313 _635_/a_681_505# net64 0
C28314 hold116/a_438_182# clknet_4_0_0_clk 0
C28315 clkbuf_4_12_0_clk/a_27_118# _249_ 0
C28316 _264_ hold72/a_438_182# 0
C28317 net50 net43 0.12503f
C28318 hold79/a_56_118# VPWR 0.04835f
C28319 hold165/a_438_182# net41 0.01123f
C28320 _020_ _692_/a_843_236# 0
C28321 net163 _692_/a_132_114# 0
C28322 _312_ baud_inst.counter\[25\] 0.09391f
C28323 net105 _701_/a_741_93# 0
C28324 _694_/a_1840_334# VPWR 0.00128f
C28325 _509_/a_257_140# _096_ 0
C28326 net136 hold117/a_56_118# 0
C28327 _639_/a_741_93# _707_/a_1840_334# 0
C28328 net114 VPWR 0.1821f
C28329 net140 net46 0.0194f
C28330 _382_/a_559_412# _149_ 0
C28331 _382_/a_496_118# net137 0.00298f
C28332 clk FILLER_1_212/a_32_246# 0.00208f
C28333 _674_/a_550_127# VPWR 0
C28334 FILLER_5_213/a_32_246# _275_ 0
C28335 _102_ _689_/a_1583_191# 0
C28336 clknet_4_8_0_clk _529_/a_139_160# 0
C28337 _554_/a_350_122# baud_inst.counter\[29\] 0.00227f
C28338 _662_/a_1583_191# VPWR 0.01961f
C28339 clknet_4_0_0_clk net86 0.37879f
C28340 FILLER_21_33/a_32_246# VPWR 0.06856f
C28341 _638_/a_324_432# rx_inst.data_reg\[6\] 0
C28342 net70 _649_/a_843_236# 0
C28343 clknet_4_11_0_clk _702_/a_38_114# 0.00558f
C28344 tx_inst.bit_index\[2\] hold57/a_56_118# 0
C28345 _663_/a_1489_191# _166_ 0.00134f
C28346 net7 _384_/a_285_412# 0
C28347 net53 _640_/a_681_505# 0
C28348 baud_inst.counter\[20\] hold164/a_56_118# 0
C28349 _645_/a_843_236# _644_/a_741_93# 0.00188f
C28350 _673_/a_681_505# VPWR 0
C28351 _305_ _534_/a_46_156# 0
C28352 _537_/a_341_118# net148 0
C28353 _097_ net178 0.28467f
C28354 FILLER_18_160/a_32_246# _435_/a_72_436# 0
C28355 hold64/a_326_118# _046_ 0.00297f
C28356 hold170/a_56_118# net3 0
C28357 VPWR _667_/a_38_114# 0.00141f
C28358 _234_ _422_/a_146_122# 0
C28359 _398_/a_115_308# clknet_4_4_0_clk 0
C28360 _098_ _685_/a_2250_412# 0
C28361 _692_/a_1840_334# _104_ 0
C28362 _115_ _700_/a_1785_429# 0.00138f
C28363 _674_/a_741_93# _181_ 0.00413f
C28364 _118_ _366_/a_170_412# 0
C28365 _357_/a_150_412# clknet_0_clk 0
C28366 _081_ rx_inst.state\[4\] 0.01345f
C28367 net161 net40 0
C28368 hold104/a_326_118# clknet_4_8_0_clk 0.00565f
C28369 baud_inst.counter\[19\] _301_ 0.31008f
C28370 net30 _472_/a_22_110# 0
C28371 _266_ _472_/a_120_432# 0.00212f
C28372 baud_inst.counter\[6\] net43 0
C28373 baud_inst.counter\[13\] _684_/a_1840_334# 0.00635f
C28374 net111 hold111/a_438_182# 0.00119f
C28375 net43 _367_/a_170_412# 0
C28376 input1/a_40_152# VPWR 0.00422f
C28377 net149 _302_ 0
C28378 clknet_4_10_0_clk _296_ 0
C28379 _060_ _649_/a_741_93# 0
C28380 clknet_0_clk _137_ 0
C28381 hold171/a_56_118# _656_/a_132_114# 0
C28382 tx_inst.data_reg\[4\] _656_/a_38_114# 0.01406f
C28383 net73 _636_/a_843_236# 0
C28384 _269_ _636_/a_741_93# 0.00159f
C28385 net13 _648_/a_1583_191# 0.00196f
C28386 rx_inst.data_reg\[4\] _240_ 0
C28387 hold155/a_56_118# FILLER_3_123/a_32_246# 0
C28388 _678_/a_132_114# _036_ 0
C28389 baud_inst.counter\[4\] clknet_4_2_0_clk 0
C28390 _687_/a_843_236# _296_ 0.02889f
C28391 _657_/a_38_114# tx_inst.data_reg\[1\] 0.00328f
C28392 net48 _465_/a_120_432# 0
C28393 FILLER_26_88/a_40_246# clknet_4_11_0_clk 0.00297f
C28394 _159_ net24 0
C28395 _180_ _313_ 0.02818f
C28396 FILLER_23_186/a_40_246# clknet_4_15_0_clk 0.01082f
C28397 net27 FILLER_5_207/a_32_246# 0.01784f
C28398 hold184/a_326_118# _396_/a_155_412# 0
C28399 hold168/a_438_182# _206_ 0.00163f
C28400 _665_/a_324_432# _665_/a_741_93# -0
C28401 net48 _264_ 1.90375f
C28402 hold181/a_56_118# hold60/a_326_118# 0
C28403 _266_ _668_/a_741_93# 0.00704f
C28404 net137 _209_ 0.08612f
C28405 _166_ _665_/a_38_114# 0
C28406 net156 _689_/a_741_93# 0
C28407 hold156/a_56_118# _689_/a_2250_412# 0.00115f
C28408 _431_/a_175_118# net35 0.00209f
C28409 _055_ _232_ 0
C28410 _680_/a_298_337# net116 0
C28411 baud_inst.counter\[1\] _086_ 0.00728f
C28412 _353_/a_248_122# net29 0.00117f
C28413 _083_ _191_ 0.0286f
C28414 _126_ output16/a_40_152# 0
C28415 hold74/a_326_118# rx_data[4] 0.00647f
C28416 hold74/a_438_182# net16 0.00165f
C28417 net126 rx_inst.data_reg\[6\] 0.15694f
C28418 _154_ _632_/a_38_114# 0
C28419 _661_/a_612_127# _210_ 0.00125f
C28420 _072_ _383_/a_46_156# 0.00137f
C28421 _093_ _038_ 0
C28422 tx FILLER_8_236/a_40_246# 0.00454f
C28423 _170_ _136_ 0.91429f
C28424 _143_ clknet_4_3_0_clk 0
C28425 _477_/a_22_110# _166_ 0.02245f
C28426 clkbuf_4_2_0_clk/a_27_118# _683_/a_741_93# 0.00103f
C28427 _688_/a_1583_191# net160 0
C28428 net44 _542_/a_155_412# 0.00106f
C28429 net32 _249_ 0.02974f
C28430 _413_/a_170_412# _224_ 0
C28431 hold53/a_326_118# net100 0
C28432 net120 net147 0.03061f
C28433 tx_data[0] VPWR 0.01465f
C28434 hold173/a_326_118# net34 0.01365f
C28435 hold114/a_326_118# baud_inst.counter\[29\] 0.02178f
C28436 net120 net46 0.10828f
C28437 hold66/a_438_182# net30 0.06158f
C28438 hold66/a_326_118# _266_ 0.00119f
C28439 net34 net43 0.0011f
C28440 hold130/a_56_118# net129 0.00449f
C28441 _004_ _168_ 0.12176f
C28442 _448_/a_244_412# _258_ 0.00114f
C28443 _160_ _446_/a_248_122# 0
C28444 _636_/a_324_432# _156_ 0.01053f
C28445 baud_inst.counter\[20\] _692_/a_2002_114# 0
C28446 _703_/a_324_432# _702_/a_1583_191# 0
C28447 _677_/a_1785_429# _182_ 0
C28448 net30 _648_/a_741_93# 0.0026f
C28449 _266_ _648_/a_324_432# 0.00204f
C28450 _253_ _418_/a_46_156# 0
C28451 _206_ clkbuf_4_1_0_clk/a_27_118# 0.00897f
C28452 hold146/a_438_182# _200_ 0.00547f
C28453 _676_/a_298_337# baud_inst.counter\[4\] 0.00727f
C28454 _440_/a_244_412# _158_ 0.0019f
C28455 hold64/a_438_182# _049_ 0
C28456 hold181/a_56_118# hold135/a_326_118# 0.00191f
C28457 _192_ _664_/a_550_127# 0
C28458 VPWR _037_ 0.17505f
C28459 _397_/a_165_412# _172_ 0
C28460 _103_ _104_ 0.02896f
C28461 hold174/a_326_118# _477_/a_22_110# 0
C28462 _699_/a_2002_114# _027_ 0
C28463 _662_/a_132_114# net179 0
C28464 net20 net23 0.19407f
C28465 hold88/a_326_118# _687_/a_1583_191# 0
C28466 _634_/a_741_93# _634_/a_1489_191# -0
C28467 _634_/a_1583_191# _634_/a_2250_412# 0
C28468 net55 net10 0.01468f
C28469 _658_/a_2002_114# clknet_4_4_0_clk 0
C28470 _357_/a_150_412# _182_ 0.00409f
C28471 VPWR _220_ 0.14492f
C28472 output19/a_40_152# net118 0
C28473 _392_/a_382_118# net54 0.01017f
C28474 _674_/a_741_93# _088_ 0
C28475 _175_ _664_/a_298_337# 0
C28476 _061_ _157_ 0.00132f
C28477 _534_/a_46_156# _020_ 0
C28478 net49 hold127/a_56_118# 0.00354f
C28479 _696_/a_1840_334# clknet_4_9_0_clk 0
C28480 net12 _638_/a_843_236# 0.00209f
C28481 hold64/a_56_118# _638_/a_2250_412# 0
C28482 hold64/a_326_118# _638_/a_1840_334# 0
C28483 hold64/a_438_182# _638_/a_1583_191# 0
C28484 hold101/a_438_182# net49 0
C28485 rx_inst.state\[2\] net166 0.00102f
C28486 _645_/a_612_127# net47 0
C28487 _697_/a_843_236# baud_inst.counter\[25\] 0.00717f
C28488 _214_ _071_ 0.01188f
C28489 net105 hold105/a_438_182# 0.01156f
C28490 hold106/a_56_118# _701_/a_1840_334# 0
C28491 _635_/a_38_114# VPWR 0.00115f
C28492 net73 hold81/a_438_182# 0
C28493 hold64/a_326_118# _043_ 0.00142f
C28494 baud_inst.counter\[27\] _165_ 0
C28495 _356_/a_248_122# baud_inst.counter\[13\] 0.0041f
C28496 baud_inst.counter\[12\] _162_ 0
C28497 _672_/a_550_127# net38 0
C28498 _485_/a_120_432# VPWR 0
C28499 _687_/a_324_432# _014_ 0
C28500 _687_/a_741_93# net88 0
C28501 net62 _669_/a_1840_334# 0
C28502 _179_ _112_ 0
C28503 hold161/a_56_118# _017_ 0.00445f
C28504 _695_/a_1785_429# _313_ 0
C28505 net45 _694_/a_298_337# 0.00174f
C28506 net27 net54 0
C28507 hold158/a_438_182# _102_ 0.00362f
C28508 _312_ baud_inst.counter\[24\] 0.03671f
C28509 _313_ net140 0.01261f
C28510 _699_/a_1785_429# net45 0.0012f
C28511 _071_ FILLER_3_177/a_32_246# 0
C28512 _257_ _054_ 0.03171f
C28513 net49 _105_ 0.02655f
C28514 hold153/a_326_118# net40 0.03396f
C28515 _410_/a_155_412# _205_ 0
C28516 _706_/a_550_127# net43 0
C28517 _706_/a_612_127# _120_ 0
C28518 _671_/a_1840_334# rx_inst.state\[4\] 0.01169f
C28519 _292_ _685_/a_843_236# 0
C28520 _160_ _632_/a_38_114# 0
C28521 _705_/a_843_236# _704_/a_843_236# 0
C28522 _671_/a_2250_412# _061_ 0
C28523 _671_/a_1840_334# net119 0
C28524 baud_inst.counter\[26\] hold100/a_56_118# 0.07109f
C28525 baud_inst.counter\[27\] hold100/a_326_118# 0
C28526 _289_ net135 0
C28527 _113_ FILLER_28_53/a_32_246# 0.00153f
C28528 _657_/a_843_236# VPWR 0.00765f
C28529 output20/a_40_152# net20 0.02744f
C28530 net81 _636_/a_38_114# 0
C28531 _696_/a_2250_412# clknet_4_8_0_clk 0
C28532 _158_ _633_/a_1583_191# 0.01332f
C28533 clknet_4_1_0_clk _655_/a_1785_429# 0
C28534 _688_/a_324_432# clknet_4_2_0_clk 0.01429f
C28535 _046_ _632_/a_741_93# 0.00273f
C28536 _705_/a_38_114# net43 0.05256f
C28537 _157_ _433_/a_142_412# 0.00955f
C28538 _645_/a_550_127# net49 0
C28539 hold170/a_438_182# net170 0.02876f
C28540 net108 _683_/a_612_127# 0.02368f
C28541 _679_/a_1583_191# net181 0
C28542 _679_/a_132_114# net86 0
C28543 net174 hold169/a_326_118# 0
C28544 net123 _670_/a_612_127# 0.00486f
C28545 _646_/a_2250_412# net85 0.0017f
C28546 VPWR _123_ 0.21194f
C28547 baud_inst.counter\[6\] net152 0.02304f
C28548 FILLER_15_17/a_40_246# hold157/a_438_182# 0
C28549 net47 _649_/a_612_127# 0
C28550 rx_done net22 0.00893f
C28551 net109 _290_ 0
C28552 net44 _669_/a_843_236# 0.00227f
C28553 _082_ _669_/a_741_93# 0.00147f
C28554 hold139/a_438_182# _136_ 0.02108f
C28555 rx_data[4] _647_/a_2250_412# 0
C28556 hold125/a_56_118# _648_/a_298_337# 0
C28557 net55 _371_/a_170_412# 0
C28558 _388_/a_559_412# _212_ 0.00155f
C28559 _674_/a_38_114# _087_ 0.06149f
C28560 VPWR _632_/a_550_127# 0
C28561 _073_ tx_inst.data_reg\[0\] 0.01593f
C28562 _679_/a_612_127# _182_ 0.01087f
C28563 net39 _162_ 0.0791f
C28564 _075_ clknet_4_7_0_clk 0.021f
C28565 VPWR FILLER_6_151/a_40_246# 0.13339f
C28566 _315_ _701_/a_1489_191# 0
C28567 _508_/a_474_130# _288_ 0.00109f
C28568 fanout28/a_40_152# VPWR 0.01101f
C28569 hold52/a_326_118# _230_ 0.01693f
C28570 hold168/a_438_182# _202_ 0
C28571 hold168/a_56_118# _203_ 0.00251f
C28572 hold168/a_326_118# _201_ 0
C28573 net8 _381_/a_46_156# 0.02419f
C28574 net55 _389_/a_268_412# 0.00257f
C28575 FILLER_17_160/a_40_246# _435_/a_72_436# 0
C28576 net111 clknet_0_clk 0.075f
C28577 _675_/a_681_505# clknet_4_0_0_clk 0
C28578 baud_inst.counter\[3\] _672_/a_843_236# 0
C28579 _283_ net39 0.00187f
C28580 net92 _090_ 0.00443f
C28581 net35 _445_/a_279_412# 0
C28582 net121 fanout45/a_40_152# 0
C28583 hold164/a_326_118# _104_ 0.0066f
C28584 _533_/a_146_122# _304_ 0
C28585 hold68/a_56_118# _313_ 0.02307f
C28586 net45 FILLER_25_7/a_40_246# 0.00186f
C28587 _533_/a_248_122# net147 0.00375f
C28588 FILLER_0_40/a_40_246# net38 0.01283f
C28589 FILLER_7_40/a_32_246# _183_ 0
C28590 _116_ hold58/a_438_182# 0
C28591 _111_ _698_/a_612_127# 0.00483f
C28592 _311_ clknet_0_clk 0.01598f
C28593 _533_/a_248_122# net46 0
C28594 hold137/a_56_118# _653_/a_38_114# 0
C28595 net55 input11/a_40_152# 0
C28596 net110 _290_ 0.01396f
C28597 baud_inst.counter\[30\] _702_/a_1785_429# 0
C28598 baud_inst.counter\[28\] _702_/a_550_127# 0
C28599 net54 _706_/a_298_337# 0.00331f
C28600 clknet_4_4_0_clk net137 0
C28601 clknet_0_clk _669_/a_741_93# 0
C28602 hold140/a_326_118# _110_ 0
C28603 hold140/a_56_118# net142 0.00138f
C28604 tx_inst.state\[4\] _705_/a_741_93# 0
C28605 _642_/a_324_432# rx_inst.state\[2\] 0.00127f
C28606 net159 net40 0
C28607 hold96/a_438_182# _182_ 0.01469f
C28608 VPWR _648_/a_2250_412# 0.00401f
C28609 hold76/a_438_182# FILLER_22_32/a_40_246# 0.00941f
C28610 VPWR _208_ 0.18802f
C28611 net18 _634_/a_2002_114# 0
C28612 _635_/a_550_127# net64 0
C28613 _693_/a_681_505# clknet_4_10_0_clk 0
C28614 clknet_4_5_0_clk _706_/a_741_93# 0.06987f
C28615 _508_/a_209_168# _682_/a_1840_334# 0
C28616 tx_busy hold80/a_438_182# 0
C28617 _046_ FILLER_21_229/a_32_246# 0
C28618 _633_/a_324_432# net78 0.02005f
C28619 _635_/a_324_432# net30 0.02447f
C28620 _635_/a_38_114# _266_ 0.00494f
C28621 _217_ net183 1.61985f
C28622 _050_ hold81/a_56_118# 0
C28623 _020_ _692_/a_612_127# 0.00231f
C28624 net163 _692_/a_1489_191# 0
C28625 _314_ _701_/a_1583_191# 0.00127f
C28626 _632_/a_843_236# _049_ 0
C28627 net104 baud_inst.counter\[17\] 0
C28628 net79 _680_/a_2002_114# 0
C28629 _663_/a_38_114# clknet_4_6_0_clk 0.04731f
C28630 _234_ _223_ 0.15494f
C28631 hold135/a_56_118# baud_inst.counter\[8\] 0.03665f
C28632 clknet_4_13_0_clk net19 0.03683f
C28633 FILLER_18_65/a_40_246# _309_ 0
C28634 FILLER_24_218/a_40_246# _638_/a_612_127# 0
C28635 _363_/a_120_432# net184 0.00148f
C28636 _095_ hold117/a_56_118# 0
C28637 hold115/a_56_118# clknet_4_0_0_clk 0.02394f
C28638 _677_/a_741_93# net152 0.00132f
C28639 _102_ _689_/a_2002_114# 0
C28640 VPWR _682_/a_38_114# 0.03055f
C28641 _079_ net28 0
C28642 _662_/a_2002_114# VPWR 0
C28643 net118 hold81/a_438_182# 0
C28644 _638_/a_1583_191# _632_/a_843_236# 0
C28645 _638_/a_843_236# _632_/a_1583_191# 0
C28646 net79 _680_/a_1583_191# 0
C28647 hold97/a_326_118# net29 0.00483f
C28648 clknet_4_11_0_clk _702_/a_1840_334# 0.01034f
C28649 tx_inst.state\[1\] _166_ 0
C28650 input9/a_40_152# _380_/a_382_118# 0
C28651 net92 FILLER_5_59/a_40_246# 0
C28652 _663_/a_324_432# _217_ 0
C28653 net7 net171 0
C28654 clkbuf_4_12_0_clk/a_27_118# clknet_4_12_0_clk 0.03116f
C28655 net53 _640_/a_550_127# 0
C28656 VPWR hold90/a_326_118# 0.00669f
C28657 _697_/a_324_432# _309_ 0
C28658 _697_/a_843_236# baud_inst.counter\[24\] 0.00799f
C28659 _043_ _632_/a_741_93# 0
C28660 hold66/a_56_118# _049_ 0
C28661 _661_/a_324_432# VPWR 0.0081f
C28662 net124 VPWR 0.04539f
C28663 _645_/a_741_93# _644_/a_612_127# 0
C28664 _645_/a_1583_191# _644_/a_1583_191# 0
C28665 _700_/a_324_432# baud_inst.counter\[29\] 0
C28666 _427_/a_248_122# net24 0
C28667 FILLER_0_161/a_40_246# FILLER_0_163/a_32_246# 0.0524f
C28668 _673_/a_550_127# VPWR 0
C28669 hold138/a_56_118# _636_/a_843_236# 0
C28670 hold138/a_438_182# _636_/a_324_432# 0
C28671 hold138/a_326_118# _636_/a_741_93# 0.00768f
C28672 _023_ _021_ 0
C28673 FILLER_19_132/a_40_246# _641_/a_2250_412# 0
C28674 _510_/a_146_122# _183_ 0
C28675 net36 FILLER_21_147/a_40_246# 0.00196f
C28676 hold118/a_326_118# rx_inst.state\[1\] 0
C28677 clknet_4_13_0_clk hold51/a_326_118# 0
C28678 _640_/a_741_93# VPWR 0.04149f
C28679 VPWR _667_/a_1840_334# 0.00186f
C28680 _234_ _240_ 0.15232f
C28681 _216_ clknet_4_4_0_clk 0
C28682 _699_/a_1583_191# net49 0
C28683 _674_/a_1785_429# _181_ 0
C28684 net93 VPWR 0.00477f
C28685 _101_ net160 0
C28686 _650_/a_38_114# _459_/a_27_156# 0
C28687 _691_/a_2250_412# net103 0
C28688 _409_/a_73_118# net25 0
C28689 tx_data[2] _388_/a_285_118# 0
C28690 _691_/a_324_432# net101 0
C28691 net66 _638_/a_38_114# 0
C28692 hold108/a_326_118# _096_ 0
C28693 _266_ _123_ 0.0101f
C28694 _248_ net25 0.07676f
C28695 net13 _648_/a_2002_114# 0
C28696 _269_ _636_/a_1785_429# 0
C28697 net92 _352_/a_268_412# 0.00158f
C28698 _283_ _352_/a_46_156# 0.04794f
C28699 _687_/a_612_127# _296_ 0.00167f
C28700 _632_/a_550_127# _266_ 0
C28701 _673_/a_741_93# _181_ 0
C28702 _673_/a_843_236# net60 0.02648f
C28703 _657_/a_1840_334# tx_inst.data_reg\[1\] 0.03452f
C28704 net48 _269_ 0.05075f
C28705 _307_ _548_/a_76_160# 0.02177f
C28706 clknet_4_14_0_clk _426_/a_154_118# 0.00129f
C28707 _389_/a_46_156# _389_/a_268_412# -0
C28708 hold181/a_438_182# net135 0.03928f
C28709 hold181/a_326_118# _287_ 0.00719f
C28710 _500_/a_155_412# clknet_4_0_0_clk 0
C28711 _377_/a_46_156# net8 0
C28712 _392_/a_59_156# _144_ 0.00756f
C28713 _392_/a_382_118# _065_ 0
C28714 _671_/a_741_93# _153_ 0
C28715 net93 hold93/a_326_118# 0
C28716 net26 net51 0.15337f
C28717 _059_ net30 0.02445f
C28718 baud_inst.counter\[23\] FILLER_22_43/a_40_246# 0.00296f
C28719 tx_inst.data_reg\[0\] net41 0.824f
C28720 hold109/a_438_182# _684_/a_324_432# 0
C28721 _000_ _668_/a_550_127# 0
C28722 net83 hold83/a_438_182# 0
C28723 net168 _664_/a_681_505# 0
C28724 _401_/a_120_432# _221_ 0.00212f
C28725 _142_ _400_/a_435_412# 0
C28726 net14 clknet_4_15_0_clk 0.00414f
C28727 FILLER_0_40/a_40_246# FILLER_0_42/a_32_246# 0.0524f
C28728 _680_/a_1840_334# _288_ 0
C28729 FILLER_11_142/a_40_246# _667_/a_612_127# 0
C28730 net32 net51 0
C28731 clknet_4_13_0_clk _457_/a_22_110# 0
C28732 baud_inst.counter\[21\] hold103/a_56_118# 0
C28733 _159_ net30 0
C28734 hold129/a_326_118# clknet_0_clk 0
C28735 _688_/a_1489_191# _296_ 0
C28736 net44 _309_ 0
C28737 rx_data[7] net81 0.0139f
C28738 net31 fanout25/a_40_152# 0.03677f
C28739 _636_/a_2250_412# _156_ 0
C28740 _518_/a_139_160# net87 0.00424f
C28741 _414_/a_279_412# clknet_0_clk 0
C28742 _703_/a_741_93# _702_/a_1489_191# 0
C28743 net58 _555_/a_177_436# 0
C28744 net143 _264_ 0.0032f
C28745 _483_/a_120_432# _671_/a_38_114# 0
C28746 tx_inst.bit_index\[1\] _341_/a_295_385# 0.00741f
C28747 _266_ _648_/a_2250_412# 0.02155f
C28748 net30 _648_/a_1785_429# 0.00168f
C28749 hold65/a_56_118# net69 0.03864f
C28750 net21 _200_ 0
C28751 _676_/a_1583_191# baud_inst.counter\[4\] 0.04636f
C28752 _510_/a_146_122# net115 0.00155f
C28753 hold116/a_326_118# net109 0
C28754 _679_/a_324_432# _282_ 0
C28755 _679_/a_741_93# baud_inst.counter\[4\] 0
C28756 _679_/a_843_236# net152 0
C28757 _219_ _172_ 0
C28758 net124 _127_ 0
C28759 FILLER_26_229/a_32_246# _637_/a_843_236# 0
C28760 _445_/a_165_412# _257_ 0
C28761 _213_ _209_ 0
C28762 hold174/a_438_182# _007_ 0
C28763 clkload0/Y _494_/a_165_412# 0
C28764 tx_done _121_ 0
C28765 clknet_4_12_0_clk net26 0
C28766 hold87/a_438_182# net46 0.00118f
C28767 _662_/a_1489_191# net179 0
C28768 net51 hold62/a_326_118# 0.00956f
C28769 _443_/a_354_412# _256_ 0.00157f
C28770 net152 _683_/a_1840_334# 0
C28771 baud_inst.counter\[4\] _683_/a_1583_191# 0
C28772 net123 net26 0
C28773 _446_/a_146_122# net47 0
C28774 _637_/a_741_93# clknet_4_15_0_clk 0.06731f
C28775 FILLER_26_227/a_40_246# VPWR 0.12311f
C28776 _546_/a_192_429# net99 0.01193f
C28777 _227_ _132_ 0.02507f
C28778 _170_ rx_inst.bit_index\[2\] 0.00199f
C28779 tx_data[3] tx_data[5] 0.74388f
C28780 baud_inst.counter\[12\] hold91/a_56_118# 0
C28781 clknet_4_12_0_clk net32 0.02075f
C28782 net49 _439_/a_252_412# 0
C28783 net109 net108 0
C28784 hold184/a_56_118# _222_ 0
C28785 _232_ FILLER_22_152/a_32_246# 0.00129f
C28786 _233_ _223_ 0.79265f
C28787 hold144/a_438_182# _258_ 0
C28788 _697_/a_612_127# baud_inst.counter\[25\] 0.0018f
C28789 hold174/a_56_118# net174 0
C28790 hold130/a_438_182# _098_ 0
C28791 _635_/a_1840_334# VPWR 0.00104f
C28792 net92 _677_/a_298_337# 0
C28793 _642_/a_38_114# _669_/a_298_337# 0
C28794 _171_ _196_ 0
C28795 _481_/a_22_110# _197_ 0.00806f
C28796 clknet_4_0_0_clk net38 0.57237f
C28797 _094_ net116 0
C28798 _003_ VPWR 0.04485f
C28799 _308_ _296_ 0.01647f
C28800 hold153/a_56_118# _281_ 0
C28801 net14 _637_/a_324_432# 0.00209f
C28802 net124 _266_ 0.19056f
C28803 _155_ net30 0.04922f
C28804 net45 _694_/a_1583_191# 0.00265f
C28805 _036_ net40 0.05786f
C28806 clkbuf_4_7_0_clk/a_27_118# _666_/a_1583_191# 0
C28807 _133_ _139_ 0.0014f
C28808 _478_/a_27_156# net172 0
C28809 net25 net139 0
C28810 _658_/a_741_93# _387_/a_46_156# 0.00105f
C28811 _686_/a_298_337# _669_/a_38_114# 0
C28812 _686_/a_38_114# _669_/a_298_337# 0
C28813 rx_inst.state\[2\] clknet_4_9_0_clk 0
C28814 rx_inst.data_reg\[1\] net49 0
C28815 _009_ _688_/a_1840_334# 0
C28816 net75 clknet_4_10_0_clk 0.32861f
C28817 _119_ _120_ 0.07229f
C28818 net110 net108 0.1158f
C28819 hold129/a_326_118# _182_ 0.00414f
C28820 _694_/a_1840_334# FILLER_22_43/a_40_246# 0
C28821 net16 hold73/a_326_118# 0.00856f
C28822 rx_data[4] hold73/a_56_118# 0.00439f
C28823 _233_ _240_ 0.02792f
C28824 _705_/a_1840_334# _704_/a_1583_191# 0
C28825 _705_/a_1583_191# _704_/a_1840_334# 0
C28826 _657_/a_612_127# VPWR 0.00119f
C28827 _678_/a_843_236# clkbuf_4_1_0_clk/a_27_118# 0
C28828 hold178/a_56_118# _295_ 0
C28829 clknet_4_13_0_clk _636_/a_1583_191# 0.01171f
C28830 hold142/a_56_118# _310_ 0.00375f
C28831 _170_ _243_ 0.00336f
C28832 clk _380_/a_382_118# 0.0027f
C28833 net145 clkbuf_4_1_0_clk/a_27_118# 0
C28834 _398_/a_358_436# clknet_0_clk 0
C28835 _158_ _633_/a_2002_114# 0
C28836 net96 _510_/a_248_122# 0
C28837 _688_/a_2250_412# clknet_4_2_0_clk 0
C28838 VPWR _522_/a_209_168# 0.00655f
C28839 rx_inst.state\[3\] _669_/a_1840_334# 0
C28840 clkbuf_4_9_0_clk/a_27_118# _686_/a_38_114# 0.001f
C28841 VPWR _650_/a_324_432# 0.00683f
C28842 _705_/a_1840_334# net43 0
C28843 _436_/a_550_140# _137_ 0
C28844 _157_ _156_ 0.91325f
C28845 _136_ _433_/a_550_140# 0
C28846 _549_/a_257_140# _165_ 0.0022f
C28847 tx_data[7] VPWR 0.14073f
C28848 net97 _096_ 0.60482f
C28849 rx_inst.data_reg\[3\] _635_/a_132_114# 0
C28850 hold117/a_56_118# _350_/a_165_412# 0
C28851 net57 _667_/a_1583_191# 0
C28852 net67 net59 0.00657f
C28853 _427_/a_146_122# VPWR 0
C28854 _138_ _648_/a_324_432# 0.03233f
C28855 net125 _648_/a_38_114# 0.01421f
C28856 rx_inst.bit_index\[1\] _052_ 0
C28857 FILLER_15_173/a_40_246# _671_/a_324_432# 0
C28858 _634_/a_298_337# _271_ 0
C28859 net31 FILLER_17_162/a_32_246# 0.00235f
C28860 _127_ FILLER_26_227/a_40_246# 0.03231f
C28861 hold148/a_56_118# _303_ 0.02651f
C28862 net79 _491_/a_192_429# 0.0476f
C28863 _146_ net5 0
C28864 net96 _182_ 0.05092f
C28865 hold55/a_326_118# _478_/a_27_156# 0.00279f
C28866 _432_/a_248_122# rx_inst.state\[2\] 0
C28867 rx_inst.state\[2\] _157_ 0
C28868 _638_/a_324_432# hold70/a_56_118# 0
C28869 tx_inst.bit_index\[2\] _172_ 0.01371f
C28870 _376_/a_272_160# net172 0.0021f
C28871 _376_/a_76_160# _200_ 0.03443f
C28872 net44 FILLER_20_0/a_40_246# 0.02546f
C28873 _031_ hold114/a_56_118# 0
C28874 _378_/a_285_412# net7 0
C28875 hold108/a_326_118# _190_ 0
C28876 hold108/a_438_182# _189_ 0
C28877 output18/a_40_152# VPWR 0.00174f
C28878 clknet_4_10_0_clk _701_/a_324_432# 0.00786f
C28879 hold178/a_56_118# clknet_4_2_0_clk 0.06537f
C28880 _231_ _204_ 0
C28881 _046_ net66 0.00229f
C28882 _035_ baud_inst.counter\[6\] 0
C28883 hold96/a_326_118# _291_ 0
C28884 _158_ FILLER_26_141/a_40_246# 0
C28885 _207_ _213_ 0.14919f
C28886 clk _219_ 0
C28887 net90 _297_ 0
C28888 baud_inst.counter\[3\] _672_/a_612_127# 0.00126f
C28889 baud_inst.counter\[8\] _287_ 0.74168f
C28890 hold154/a_326_118# _089_ 0.00257f
C28891 _676_/a_324_432# _280_ 0
C28892 net49 hold107/a_438_182# 0
C28893 hold171/a_326_118# _069_ 0
C28894 tx_inst.data_reg\[4\] _658_/a_1489_191# 0.00227f
C28895 hold159/a_326_118# _151_ 0
C28896 hold122/a_56_118# clknet_4_6_0_clk 0.01548f
C28897 net48 hold78/a_326_118# 0.00481f
C28898 hold124/a_438_182# net47 0.04599f
C28899 _107_ _106_ 0
C28900 clkbuf_0_clk/a_116_82# _667_/a_324_432# 0
C28901 _528_/a_379_118# baud_inst.counter\[16\] 0.00216f
C28902 baud_inst.counter\[30\] _115_ 0.02317f
C28903 net54 _706_/a_1583_191# 0.04703f
C28904 _280_ _683_/a_324_432# 0
C28905 hold126/a_56_118# rx_inst.data_reg\[6\] 0.03212f
C28906 _378_/a_559_412# _206_ 0.00133f
C28907 _378_/a_59_156# _151_ 0
C28908 net92 _679_/a_38_114# 0
C28909 net94 _679_/a_324_432# 0.05057f
C28910 _652_/a_324_432# _142_ 0.02263f
C28911 _642_/a_2250_412# rx_inst.state\[2\] 0.00366f
C28912 VPWR FILLER_14_164/a_32_246# 0.07986f
C28913 FILLER_5_164/a_40_246# tx_inst.data_reg\[2\] 0
C28914 _240_ FILLER_17_199/a_40_246# 0.0029f
C28915 baud_inst.counter\[28\] _116_ 0.00308f
C28916 hold143/a_326_118# _474_/a_22_110# 0
C28917 _698_/a_1489_191# FILLER_20_95/a_40_246# 0
C28918 _064_ _652_/a_38_114# 0.00258f
C28919 net42 _652_/a_324_432# 0.04865f
C28920 net47 _271_ 0.25896f
C28921 hold179/a_326_118# net41 0
C28922 hold172/a_56_118# net172 0.00128f
C28923 _062_ hold57/a_438_182# 0.00769f
C28924 output15/a_40_152# rx_data[4] 0
C28925 clknet_4_5_0_clk _706_/a_1785_429# 0
C28926 _294_ _687_/a_843_236# 0
C28927 net2 net180 0.16977f
C28928 _068_ _339_/a_886_118# 0
C28929 fanout37/a_40_152# _459_/a_27_156# 0
C28930 baud_inst.counter\[12\] _515_/a_170_160# 0
C28931 net128 _515_/a_76_160# 0.0319f
C28932 _020_ net164 0.11869f
C28933 baud_inst.counter\[28\] hold67/a_438_182# 0.00245f
C28934 baud_inst.counter\[30\] hold67/a_56_118# 0.03219f
C28935 _314_ _701_/a_2002_114# 0
C28936 _639_/a_1583_191# net51 0
C28937 net81 _707_/a_1583_191# 0
C28938 _050_ _707_/a_1840_334# 0
C28939 _697_/a_298_337# net46 0.00249f
C28940 _663_/a_1840_334# clknet_4_6_0_clk 0
C28941 FILLER_2_208/a_40_246# _200_ 0
C28942 _216_ _666_/a_1583_191# 0
C28943 _118_ _487_/a_146_122# 0
C28944 hold152/a_438_182# _676_/a_1840_334# 0
C28945 net183 _667_/a_843_236# 0
C28946 net44 _539_/a_139_160# 0
C28947 _644_/a_324_432# rx_inst.data_reg\[1\] 0
C28948 FILLER_24_218/a_40_246# net70 0
C28949 _224_ _253_ 0
C28950 rx_inst.bit_index\[2\] _263_ 0
C28951 rx_inst.bit_index\[1\] _406_/a_154_118# 0.00402f
C28952 _093_ hold116/a_438_182# 0
C28953 _677_/a_1785_429# net152 0.00154f
C28954 net39 clkbuf_4_3_0_clk/a_27_118# 0.01248f
C28955 net58 _702_/a_298_337# 0
C28956 VPWR _682_/a_1840_334# 0.00241f
C28957 _483_/a_22_110# _205_ 0
C28958 hold142/a_326_118# _698_/a_1583_191# 0
C28959 hold102/a_438_182# _164_ 0
C28960 _638_/a_2250_412# _632_/a_2250_412# 0.00235f
C28961 _022_ _692_/a_298_337# 0
C28962 net120 _692_/a_324_432# 0
C28963 _102_ _688_/a_298_337# 0
C28964 rx_inst.bit_index\[2\] hold175/a_326_118# 0
C28965 clknet_4_12_0_clk hold175/a_438_182# 0
C28966 tx_data[6] _380_/a_496_118# 0
C28967 _186_ hold95/a_326_118# 0
C28968 net50 net51 0.00708f
C28969 _017_ _690_/a_132_114# 0
C28970 hold102/a_56_118# _690_/a_612_127# 0
C28971 baud_inst.counter\[28\] _701_/a_741_93# 0.02924f
C28972 _267_ net65 0.00408f
C28973 hold147/a_56_118# VPWR 0.03353f
C28974 net2 _668_/a_38_114# 0.00151f
C28975 rx_inst.bit_index\[2\] _237_ 0.00754f
C28976 _554_/a_248_122# net46 0.00116f
C28977 _178_ _112_ 0.05796f
C28978 _697_/a_612_127# baud_inst.counter\[24\] 0
C28979 _661_/a_2250_412# VPWR 0.0057f
C28980 _224_ net29 0.01813f
C28981 VPWR _702_/a_843_236# 0.0024f
C28982 _645_/a_843_236# _055_ 0.03883f
C28983 _645_/a_741_93# net132 0
C28984 _245_ _139_ 0.1105f
C28985 clknet_4_1_0_clk VPWR 1.06266f
C28986 _413_/a_170_412# _230_ 0
C28987 _677_/a_741_93# _035_ 0
C28988 hold56/a_326_118# net56 0.00502f
C28989 FILLER_12_46/a_32_246# hold109/a_438_182# 0
C28990 _640_/a_1785_429# VPWR 0
C28991 FILLER_7_82/a_32_246# clknet_4_3_0_clk 0.00141f
C28992 FILLER_17_81/a_32_246# _025_ 0
C28993 net48 hold138/a_326_118# 0
C28994 net49 _694_/a_843_236# 0
C28995 tx_inst.data_reg\[1\] net41 0.9822f
C28996 net55 clknet_0_clk 0.02597f
C28997 baud_inst.counter\[18\] _187_ 0
C28998 _676_/a_324_432# _191_ 0.00881f
C28999 _650_/a_741_93# net30 0.01837f
C29000 _650_/a_324_432# _266_ 0.02371f
C29001 tx_data[2] _146_ 0
C29002 _411_/a_115_308# net180 0.02476f
C29003 _230_ _424_/a_244_140# 0
C29004 hold53/a_438_182# _242_ 0
C29005 _345_/a_354_412# baud_inst.counter\[20\] 0
C29006 hold124/a_438_182# net70 0
C29007 _679_/a_132_114# net38 0
C29008 FILLER_5_156/a_32_246# _219_ 0
C29009 net50 FILLER_5_213/a_32_246# 0
C29010 net66 _043_ 0.20782f
C29011 hold171/a_326_118# clknet_4_4_0_clk 0.00176f
C29012 FILLER_2_237/a_40_246# FILLER_1_237/a_40_246# 0.00269f
C29013 _013_ _190_ 0.01031f
C29014 net48 FILLER_20_177/a_32_246# 0
C29015 _285_ _185_ 0.01098f
C29016 tx_inst.bit_index\[2\] clk 0.14847f
C29017 _307_ _312_ 0.05389f
C29018 net133 _702_/a_324_432# 0
C29019 rx_inst.data_reg\[2\] FILLER_29_165/a_40_246# 0.00144f
C29020 FILLER_8_236/a_40_246# _665_/a_2250_412# 0
C29021 _285_ clknet_4_0_0_clk 0
C29022 _286_ baud_inst.counter\[6\] 0
C29023 hold87/a_326_118# VPWR 0.00396f
C29024 _431_/a_277_118# net25 0.00219f
C29025 hold133/a_326_118# _702_/a_298_337# 0
C29026 _392_/a_496_118# tx_inst.data_reg\[0\] 0.00115f
C29027 net55 _077_ 0.20754f
C29028 _190_ baud_inst.counter\[14\] 0
C29029 hold65/a_326_118# net65 0
C29030 _060_ _238_ 0
C29031 _485_/a_22_110# clkbuf_0_clk/a_116_82# 0
C29032 rx_inst.state\[3\] FILLER_11_134/a_32_246# 0.00337f
C29033 _243_ _237_ 0
C29034 net172 _664_/a_1489_191# 0
C29035 _142_ _221_ 0.01988f
C29036 _246_ _241_ 0.07204f
C29037 hold170/a_326_118# _392_/a_382_118# 0
C29038 _385_/a_46_156# _382_/a_59_156# 0
C29039 hold161/a_438_182# _690_/a_324_432# 0
C29040 _680_/a_741_93# hold136/a_438_182# 0.00404f
C29041 _363_/a_22_110# _194_ 0.06463f
C29042 hold116/a_56_118# _289_ 0.01334f
C29043 output23/a_40_152# _704_/a_843_236# 0
C29044 _636_/a_681_505# _047_ 0.00126f
C29045 FILLER_19_77/a_32_246# net99 0
C29046 _194_ _007_ 0.02118f
C29047 clkbuf_4_2_0_clk/a_27_118# _096_ 0.03847f
C29048 net145 _653_/a_1489_191# 0
C29049 hold110/a_438_182# baud_inst.counter\[4\] 0
C29050 rx_inst.data_reg\[1\] net131 0.17598f
C29051 hold86/a_56_118# _672_/a_1489_191# 0
C29052 _032_ net67 0.00121f
C29053 _004_ _671_/a_38_114# 0.01197f
C29054 net28 _671_/a_741_93# 0.004f
C29055 _277_ _671_/a_324_432# 0.0357f
C29056 clknet_4_8_0_clk net99 0.04421f
C29057 net100 VPWR 0.09868f
C29058 _676_/a_2002_114# baud_inst.counter\[4\] 0.00105f
C29059 hold114/a_56_118# net46 0.0064f
C29060 _116_ _703_/a_843_236# 0.03097f
C29061 _679_/a_2250_412# _282_ 0
C29062 net29 _235_ 0.01705f
C29063 _345_/a_150_412# net75 0
C29064 hold184/a_438_182# _196_ 0
C29065 _040_ net179 0
C29066 _514_/a_257_140# _292_ 0.00269f
C29067 _046_ _635_/a_132_114# 0
C29068 _302_ FILLER_20_0/a_40_246# 0
C29069 _046_ hold85/a_438_182# 0.02909f
C29070 _282_ _683_/a_1489_191# 0
C29071 _017_ hold158/a_56_118# 0
C29072 _258_ net47 0
C29073 hold172/a_56_118# _705_/a_843_236# 0
C29074 hold172/a_326_118# _705_/a_741_93# 0
C29075 _226_ _642_/a_2250_412# 0.00431f
C29076 _637_/a_1785_429# clknet_4_15_0_clk 0
C29077 _076_ clknet_0_clk 0
C29078 _681_/a_843_236# net117 0.00373f
C29079 _681_/a_324_432# baud_inst.counter\[9\] 0.0016f
C29080 _677_/a_843_236# _280_ 0.00525f
C29081 net128 net91 0
C29082 net49 _251_ 0.01012f
C29083 net173 FILLER_9_169/a_32_246# 0
C29084 net12 net70 0
C29085 net142 baud_inst.counter\[25\] 0.21222f
C29086 net3 net9 0.00713f
C29087 hold162/a_56_118# net141 0.06375f
C29088 _170_ _429_/a_244_412# 0
C29089 net179 _006_ 0.02131f
C29090 FILLER_17_81/a_32_246# FILLER_17_79/a_40_246# 0.0524f
C29091 _481_/a_120_432# VPWR 0.0038f
C29092 clknet_4_5_0_clk _200_ 0.02592f
C29093 _674_/a_843_236# hold61/a_56_118# 0
C29094 hold103/a_56_118# _301_ 0.06569f
C29095 hold103/a_438_182# net103 0
C29096 clknet_0_clk clknet_4_15_0_clk 0.16409f
C29097 _392_/a_382_118# VPWR 0.02213f
C29098 net153 _683_/a_2250_412# 0
C29099 hold175/a_56_118# net175 0.01162f
C29100 _138_ _123_ 0
C29101 tx_inst.bit_index\[0\] _475_/a_170_412# 0
C29102 _031_ _700_/a_38_114# 0
C29103 _672_/a_681_505# VPWR 0
C29104 hold96/a_56_118# _282_ 0.00153f
C29105 _098_ _686_/a_1489_191# 0
C29106 _536_/a_192_429# net148 0.00167f
C29107 hold97/a_326_118# _288_ 0.05584f
C29108 clkbuf_4_7_0_clk/a_27_118# _704_/a_38_114# 0
C29109 output22/a_40_152# _121_ 0
C29110 net31 net166 0
C29111 tx_inst.bit_index\[2\] FILLER_5_156/a_32_246# 0
C29112 FILLER_26_35/a_32_246# _302_ 0
C29113 _658_/a_843_236# _212_ 0
C29114 _425_/a_268_412# net24 0
C29115 _653_/a_681_505# _142_ 0
C29116 _292_ net130 0.04518f
C29117 net37 _236_ 0.03826f
C29118 hold85/a_56_118# net74 0.00251f
C29119 _175_ net54 0.0032f
C29120 _064_ _653_/a_843_236# 0.00172f
C29121 net42 _653_/a_681_505# 0
C29122 _217_ hold169/a_438_182# 0.00517f
C29123 _080_ _667_/a_298_337# 0.02094f
C29124 _295_ _520_/a_257_140# 0
C29125 hold88/a_438_182# _297_ 0.01331f
C29126 _257_ fanout24/a_40_152# 0
C29127 net22 _704_/a_324_432# 0
C29128 net27 VPWR 1.33666f
C29129 net33 _120_ 0
C29130 _147_ VPWR 0.25318f
C29131 _386_/a_382_118# net137 0.00518f
C29132 hold55/a_56_118# net54 0.00442f
C29133 _143_ clknet_0_clk 0.00537f
C29134 _672_/a_741_93# _491_/a_192_429# 0
C29135 _039_ FILLER_8_19/a_40_246# 0.00248f
C29136 VPWR _296_ 1.44721f
C29137 VPWR _650_/a_2250_412# 0.00533f
C29138 _249_ _137_ 0
C29139 _136_ _247_ 0.10196f
C29140 _109_ _696_/a_38_114# 0.05638f
C29141 _194_ _341_/a_1453_124# 0
C29142 net34 FILLER_3_177/a_32_246# 0.00121f
C29143 _175_ _364_/a_257_140# 0
C29144 hold117/a_56_118# _183_ 0.00408f
C29145 _640_/a_324_432# net45 0.02441f
C29146 _640_/a_38_114# _111_ 0.00139f
C29147 net111 clkbuf_4_13_0_clk/a_27_118# 0
C29148 baud_inst.counter\[31\] net113 0
C29149 net112 net127 0
C29150 rx_data[3] _467_/a_22_110# 0
C29151 _634_/a_132_114# _124_ 0
C29152 hold101/a_438_182# baud_inst.counter\[18\] 0.00221f
C29153 _230_ _439_/a_354_412# 0
C29154 _008_ net60 0
C29155 hold155/a_56_118# _209_ 0
C29156 _489_/a_358_436# _674_/a_1583_191# 0
C29157 net79 _181_ 0.16976f
C29158 net54 net165 0
C29159 _670_/a_1489_191# VPWR 0
C29160 hold167/a_438_182# _191_ 0
C29161 net155 net7 0.0166f
C29162 _644_/a_1583_191# _272_ 0
C29163 net108 _351_/a_46_156# 0
C29164 _097_ _011_ 0
C29165 _097_ _684_/a_298_337# 0.02717f
C29166 hold130/a_56_118# _189_ 0
C29167 VPWR _456_/a_155_412# 0.00349f
C29168 hold175/a_56_118# _161_ 0
C29169 _660_/a_741_93# net55 0
C29170 net94 hold110/a_326_118# 0
C29171 net92 hold110/a_56_118# 0
C29172 hold163/a_56_118# VPWR 0.07204f
C29173 baud_inst.counter\[17\] _096_ 0
C29174 rx_data[0] hold71/a_56_118# 0
C29175 _009_ _508_/a_380_412# 0.0098f
C29176 _180_ _686_/a_1583_191# 0.00603f
C29177 _301_ baud_inst.counter\[16\] 0.02922f
C29178 _684_/a_1840_334# net29 0
C29179 _526_/a_248_122# baud_inst.counter\[16\] 0.00212f
C29180 _696_/a_298_337# VPWR 0.00154f
C29181 net54 _706_/a_2002_114# 0
C29182 _280_ _683_/a_2250_412# 0
C29183 net48 net28 0
C29184 net179 _392_/a_59_156# 0.00154f
C29185 net94 _679_/a_2250_412# 0.01412f
C29186 net92 _679_/a_1840_334# 0.03201f
C29187 _283_ _679_/a_1583_191# 0.02118f
C29188 _652_/a_2250_412# _142_ 0.01306f
C29189 hold136/a_56_118# VPWR 0.00803f
C29190 net124 _138_ 0.01526f
C29191 _064_ _652_/a_1840_334# 0
C29192 net42 _652_/a_2250_412# 0.00105f
C29193 net2 hold119/a_326_118# 0
C29194 hold120/a_438_182# net120 0
C29195 hold98/a_56_118# VPWR 0.04358f
C29196 _508_/a_474_130# clknet_4_2_0_clk 0.00115f
C29197 _134_ _236_ 0.0171f
C29198 hold114/a_56_118# _313_ 0.05304f
C29199 hold147/a_438_182# _106_ 0
C29200 _706_/a_298_337# VPWR 0.00502f
C29201 tx_inst.data_reg\[3\] _339_/a_500_118# 0.00123f
C29202 hold122/a_438_182# _667_/a_741_93# 0
C29203 hold122/a_326_118# _667_/a_843_236# 0
C29204 net26 _459_/a_229_118# 0
C29205 _639_/a_2002_114# net51 0
C29206 hold118/a_56_118# rx_inst.data_reg\[7\] 0.02178f
C29207 _695_/a_2250_412# clknet_4_8_0_clk 0
C29208 clkbuf_4_11_0_clk/a_27_118# _703_/a_1489_191# 0
C29209 _684_/a_741_93# net40 0.00522f
C29210 tx_inst.bit_index\[1\] _218_ 0
C29211 _118_ _152_ 0.02942f
C29212 hold130/a_326_118# hold129/a_326_118# 0.0041f
C29213 _294_ hold91/a_326_118# 0
C29214 _644_/a_2250_412# rx_inst.data_reg\[1\] 0.00632f
C29215 hold117/a_56_118# net115 0
C29216 net58 _702_/a_1583_191# 0.00459f
C29217 hold155/a_56_118# _069_ 0.00203f
C29218 _660_/a_298_337# tx_inst.data_reg\[2\] 0
C29219 _292_ _686_/a_1840_334# 0
C29220 net49 net103 0.06943f
C29221 hold181/a_326_118# net181 0.00236f
C29222 hold181/a_56_118# net86 0
C29223 _398_/a_358_436# net43 0
C29224 net49 _444_/a_244_140# 0
C29225 net94 hold96/a_56_118# 0.00218f
C29226 clknet_4_3_0_clk FILLER_6_98/a_40_246# 0
C29227 _047_ clkbuf_4_13_0_clk/a_27_118# 0
C29228 _022_ _692_/a_1583_191# 0
C29229 _675_/a_298_337# FILLER_3_21/a_40_246# 0.00151f
C29230 net9 _150_ 0
C29231 net102 _690_/a_550_127# 0
C29232 hold160/a_56_118# baud_inst.counter\[17\] 0.00382f
C29233 hold102/a_326_118# _103_ 0.00939f
C29234 clknet_4_14_0_clk _429_/a_550_140# 0
C29235 baud_inst.counter\[28\] _701_/a_1785_429# 0.00106f
C29236 net2 _668_/a_1840_334# 0.00159f
C29237 rx _668_/a_2250_412# 0
C29238 _449_/a_27_156# net26 0
C29239 net48 _633_/a_38_114# 0.03568f
C29240 _254_ _439_/a_150_412# 0.0024f
C29241 rx_inst.bit_index\[1\] _445_/a_279_412# 0.00488f
C29242 net36 _445_/a_165_412# 0.00672f
C29243 net80 hold81/a_438_182# 0.00201f
C29244 net142 baud_inst.counter\[24\] 0.08299f
C29245 _699_/a_741_93# _699_/a_1583_191# -0
C29246 _645_/a_612_127# _055_ 0.02414f
C29247 rx_inst.data_reg\[2\] _644_/a_1840_334# 0
C29248 net111 hold143/a_326_118# 0
C29249 hold115/a_326_118# _183_ 0
C29250 _707_/a_1583_191# hold80/a_438_182# 0
C29251 net138 _636_/a_550_127# 0
C29252 tx_inst.bit_index\[0\] _141_ 0
C29253 _449_/a_27_156# net32 0
C29254 _453_/a_170_412# _261_ 0
C29255 _464_/a_120_432# _264_ 0
C29256 net49 _694_/a_612_127# 0.00193f
C29257 _022_ hold148/a_438_182# 0.00475f
C29258 _660_/a_741_93# _076_ 0
C29259 _676_/a_2250_412# _191_ 0.00885f
C29260 _650_/a_612_127# _000_ 0
C29261 clknet_0_clk _685_/a_298_337# 0.00258f
C29262 _650_/a_1785_429# net30 0
C29263 _691_/a_741_93# hold163/a_438_182# 0.00164f
C29264 _691_/a_843_236# hold163/a_326_118# 0.00243f
C29265 _031_ net105 0.33966f
C29266 hold68/a_438_182# _314_ 0
C29267 VPWR FILLER_13_228/a_40_246# 0.1334f
C29268 _178_ baud_inst.counter\[20\] 0.03367f
C29269 hold141/a_56_118# net46 0.05911f
C29270 hold177/a_326_118# clkbuf_4_8_0_clk/a_27_118# 0
C29271 hold111/a_326_118# clknet_0_clk 0.00265f
C29272 hold155/a_438_182# net55 0.00116f
C29273 _216_ _215_ 0.23682f
C29274 _645_/a_1583_191# rx_inst.data_reg\[2\] 0
C29275 _305_ FILLER_25_36/a_32_246# 0
C29276 _674_/a_741_93# _279_ 0.0036f
C29277 hold157/a_56_118# net157 0.00243f
C29278 _669_/a_132_114# clknet_4_9_0_clk 0
C29279 _640_/a_1840_334# _236_ 0
C29280 _010_ _282_ 0
C29281 _425_/a_46_156# VPWR 0.00953f
C29282 _639_/a_324_432# VPWR 0
C29283 rx_inst.bit_index\[2\] hold176/a_438_182# 0
C29284 net132 _256_ 0
C29285 _069_ FILLER_0_128/a_40_246# 0
C29286 _062_ net183 0.02578f
C29287 net122 _224_ 0.00108f
C29288 hold75/a_56_118# clknet_4_10_0_clk 0.041f
C29289 input10/a_40_152# _066_ 0
C29290 hold153/a_438_182# net39 0
C29291 net79 _488_/a_380_412# 0.00941f
C29292 _680_/a_1489_191# net136 0
C29293 _228_ _204_ 0
C29294 _293_ _180_ 0.06667f
C29295 net37 clk 0.0352f
C29296 _642_/a_1840_334# FILLER_17_131/a_32_246# 0
C29297 net30 _456_/a_257_140# 0
C29298 net172 tx_inst.state\[2\] 0.05269f
C29299 net49 _667_/a_843_236# 0
C29300 _076_ FILLER_6_189/a_40_246# 0
C29301 _693_/a_298_337# _106_ 0.0209f
C29302 _211_ _382_/a_382_118# 0.03278f
C29303 _527_/a_192_429# _299_ 0.02429f
C29304 _167_ _456_/a_155_412# 0
C29305 net44 _697_/a_741_93# 0.00704f
C29306 _680_/a_132_114# net136 0
C29307 _217_ _166_ 0.02907f
C29308 net23 _704_/a_1840_334# 0
C29309 tx_done _704_/a_1583_191# 0.00648f
C29310 _636_/a_550_127# _047_ 0
C29311 net156 _688_/a_741_93# 0.04398f
C29312 hold156/a_438_182# _688_/a_1583_191# 0
C29313 _060_ _648_/a_741_93# 0.0021f
C29314 _186_ _281_ 0
C29315 _456_/a_155_412# _647_/a_741_93# 0
C29316 _407_/a_248_122# clknet_0_clk 0
C29317 clknet_4_15_0_clk hold82/a_438_182# 0.00239f
C29318 hold86/a_326_118# clknet_4_0_0_clk 0.00111f
C29319 hold155/a_56_118# clknet_4_4_0_clk 0
C29320 _097_ baud_inst.counter\[16\] 0
C29321 net122 hold122/a_56_118# 0.01487f
C29322 net34 _274_ 0
C29323 _661_/a_843_236# _384_/a_382_118# 0
C29324 clk _657_/a_2250_412# 0
C29325 baud_inst.counter\[26\] _116_ 0
C29326 _349_/a_248_122# _182_ -0
C29327 tx_inst.data_reg\[7\] _339_/a_1377_160# 0.00195f
C29328 hold115/a_326_118# net115 0.00256f
C29329 _116_ _703_/a_612_127# 0.021f
C29330 hold174/a_326_118# _217_ 0
C29331 _117_ rx 0.00765f
C29332 net42 _663_/a_612_127# 0
C29333 _693_/a_681_505# VPWR 0
C29334 hold165/a_438_182# _656_/a_324_432# 0
C29335 hold165/a_326_118# _656_/a_741_93# 0.00231f
C29336 hold165/a_56_118# _656_/a_843_236# 0.0028f
C29337 _024_ _687_/a_1583_191# 0
C29338 _531_/a_209_168# VPWR 0.00792f
C29339 _048_ clknet_4_15_0_clk 0.06368f
C29340 _681_/a_612_127# net117 0.0039f
C29341 _681_/a_2250_412# baud_inst.counter\[9\] 0.02675f
C29342 hold157/a_56_118# _298_ 0.06979f
C29343 rx_inst.bit_index\[2\] hold180/a_326_118# 0
C29344 _697_/a_324_432# clknet_0_clk 0.01809f
C29345 rx_data[2] hold82/a_56_118# 0
C29346 net14 hold82/a_326_118# 0.02807f
C29347 net126 rx_inst.data_reg\[5\] 0
C29348 _360_/a_1453_124# net41 0.00423f
C29349 _206_ _203_ 0.00988f
C29350 _677_/a_612_127# _280_ 0.00308f
C29351 hold63/a_326_118# _079_ 0.00172f
C29352 net112 _258_ 0.01846f
C29353 baud_inst.counter\[15\] net46 0.00183f
C29354 _113_ _315_ 0
C29355 tx_done _707_/a_843_236# 0
C29356 net55 net43 1.72547f
C29357 _012_ _515_/a_170_160# 0
C29358 _294_ _515_/a_272_160# 0
C29359 _642_/a_1840_334# _669_/a_1583_191# 0
C29360 baud_inst.counter\[8\] hold116/a_326_118# 0.0163f
C29361 clkbuf_0_clk/a_116_82# _670_/a_1583_191# 0.0084f
C29362 net32 FILLER_23_143/a_32_246# 0
C29363 FILLER_1_90/a_32_246# net38 0
C29364 _158_ _048_ 0
C29365 _672_/a_550_127# VPWR 0
C29366 _231_ VPWR 0.03676f
C29367 net44 _082_ 0.21446f
C29368 clknet_4_10_0_clk baud_inst.counter\[29\] 0.00139f
C29369 _232_ _427_/a_146_122# 0.00179f
C29370 VPWR hold94/a_438_182# 0.00464f
C29371 net147 _692_/a_843_236# 0
C29372 FILLER_6_23/a_32_246# _094_ 0.00138f
C29373 _093_ net38 0.09883f
C29374 baud_inst.counter\[8\] net108 0.03174f
C29375 _499_/a_380_412# _352_/a_46_156# 0
C29376 net35 _246_ 0.54691f
C29377 _471_/a_120_432# net77 0.00692f
C29378 _257_ _238_ 0
C29379 _653_/a_550_127# _142_ 0
C29380 _637_/a_741_93# hold82/a_326_118# 0
C29381 _178_ _701_/a_298_337# 0
C29382 _555_/a_177_436# net49 0
C29383 hold171/a_56_118# tx_inst.data_reg\[4\] 0.02524f
C29384 baud_inst.counter\[8\] net181 0.01413f
C29385 _064_ _653_/a_612_127# 0.00146f
C29386 hold159/a_56_118# _657_/a_38_114# 0
C29387 net22 _704_/a_2250_412# 0
C29388 _659_/a_324_432# clknet_4_4_0_clk 0.01742f
C29389 FILLER_4_183/a_40_246# _192_ 0.02514f
C29390 FILLER_17_94/a_40_246# clknet_0_clk 0.00424f
C29391 _649_/a_1583_191# rx_inst.data_reg\[6\] 0
C29392 tx_inst.data_reg\[7\] tx_inst.data_reg\[1\] 0.04151f
C29393 _215_ _666_/a_843_236# 0.00104f
C29394 _691_/a_741_93# hold104/a_326_118# 0.0075f
C29395 _691_/a_324_432# hold104/a_438_182# 0.00155f
C29396 _303_ clknet_4_10_0_clk 0.10395f
C29397 _672_/a_741_93# _181_ 0.02544f
C29398 _672_/a_843_236# net60 0.01581f
C29399 _639_/a_324_432# _266_ 0
C29400 net166 net62 0.09917f
C29401 _639_/a_741_93# net30 0.00123f
C29402 rx_inst.state\[2\] _450_/a_398_96# 0
C29403 fanout30/a_40_152# hold139/a_326_118# 0
C29404 _313_ _700_/a_38_114# 0.00451f
C29405 _637_/a_324_432# _048_ 0.03479f
C29406 _637_/a_38_114# net72 0.02908f
C29407 _695_/a_1583_191# clknet_4_10_0_clk 0.00649f
C29408 net44 clknet_0_clk 0.13682f
C29409 net87 baud_inst.counter\[14\] 0.20258f
C29410 _158_ FILLER_26_172/a_40_246# 0.01035f
C29411 net92 _292_ 0
C29412 _194_ _341_/a_1377_160# 0
C29413 net94 _010_ 0
C29414 _199_ _200_ 0.37261f
C29415 FILLER_8_63/a_40_246# _683_/a_741_93# 0
C29416 net41 _653_/a_324_432# 0
C29417 _046_ hold84/a_326_118# 0.00142f
C29418 baud_inst.counter\[21\] _699_/a_38_114# 0
C29419 net71 net65 0
C29420 _230_ _253_ 0.01231f
C29421 _465_/a_120_432# VPWR 0
C29422 hold131/a_326_118# _159_ 0
C29423 net37 net2 0.78937f
C29424 input9/a_40_152# FILLER_0_154/a_40_246# 0.00536f
C29425 clknet_4_4_0_clk _664_/a_298_337# 0.00555f
C29426 FILLER_18_160/a_32_246# _241_ 0
C29427 _420_/a_350_122# _238_ 0.00183f
C29428 clknet_4_7_0_clk _668_/a_741_93# 0
C29429 _474_/a_120_432# net64 0
C29430 hold124/a_438_182# _649_/a_2250_412# 0
C29431 net128 clkbuf_4_8_0_clk/a_27_118# 0
C29432 _649_/a_741_93# _648_/a_741_93# 0
C29433 _649_/a_324_432# _648_/a_843_236# 0
C29434 VPWR _264_ 1.10943f
C29435 baud_inst.counter\[31\] baud_inst.counter\[29\] 0.63601f
C29436 _640_/a_1583_191# _224_ 0
C29437 _358_/a_268_436# _190_ 0.00568f
C29438 clknet_4_12_0_clk _137_ 0.00137f
C29439 _661_/a_1583_191# clk 0
C29440 _164_ _690_/a_38_114# 0
C29441 _302_ _690_/a_324_432# 0
C29442 _034_ _162_ 0
C29443 _230_ net29 0
C29444 net31 _157_ 0
C29445 _690_/a_741_93# _690_/a_1583_191# 0
C29446 _180_ _686_/a_2002_114# 0
C29447 _102_ _101_ 0.54145f
C29448 VPWR hold50/a_326_118# 0.00505f
C29449 _696_/a_1583_191# VPWR 0.01055f
C29450 FILLER_18_158/a_40_246# clknet_0_clk 0.00181f
C29451 net102 net158 0
C29452 net22 net21 0.00331f
C29453 VPWR FILLER_0_40/a_40_246# 0.12399f
C29454 _283_ _679_/a_2002_114# 0.00118f
C29455 _285_ _679_/a_1489_191# 0.01347f
C29456 hold153/a_56_118# _677_/a_38_114# 0
C29457 _691_/a_38_114# _104_ 0.03008f
C29458 _076_ _664_/a_324_432# 0.03431f
C29459 fanout33/a_40_152# net54 0.00182f
C29460 clkbuf_4_8_0_clk/a_27_118# _014_ 0.00789f
C29461 net44 _692_/a_298_337# 0
C29462 FILLER_13_102/a_32_246# baud_inst.counter\[12\] 0
C29463 net2 _650_/a_298_337# 0
C29464 _657_/a_741_93# _148_ 0
C29465 VPWR _547_/a_175_118# 0
C29466 _706_/a_1583_191# VPWR 0.02165f
C29467 _680_/a_681_505# clknet_4_0_0_clk 0
C29468 _041_ _667_/a_1583_191# 0.02526f
C29469 _684_/a_1785_429# net40 0
C29470 _642_/a_324_432# net46 0
C29471 net122 _652_/a_1489_191# 0
C29472 hold131/a_326_118# _155_ 0
C29473 net58 _702_/a_2002_114# 0
C29474 _556_/a_341_118# _115_ 0
C29475 hold152/a_326_118# clknet_4_3_0_clk 0.00208f
C29476 net49 net101 0.02076f
C29477 _202_ _203_ 0.50948f
C29478 _143_ net43 0.10457f
C29479 hold173/a_438_182# _216_ 0.00184f
C29480 hold166/a_326_118# clknet_0_clk 0
C29481 hold158/a_326_118# _689_/a_324_432# 0
C29482 _662_/a_324_432# _206_ 0
C29483 hold96/a_438_182# _286_ 0.00977f
C29484 _099_ _686_/a_38_114# 0.00909f
C29485 net46 _686_/a_324_432# 0.02147f
C29486 _534_/a_46_156# net147 0.00386f
C29487 net48 _633_/a_1840_334# 0
C29488 net36 _257_ 0.09501f
C29489 net36 _256_ 0
C29490 net75 VPWR 0.08934f
C29491 VPWR net68 0.08976f
C29492 net154 net153 0.0341f
C29493 hold160/a_438_182# _688_/a_843_236# 0
C29494 _227_ _260_ 0.06848f
C29495 _000_ rx_inst.state\[4\] 0.10979f
C29496 hold127/a_56_118# _139_ 0.03758f
C29497 _191_ FILLER_11_125/a_32_246# 0.01766f
C29498 _127_ _264_ 0.11692f
C29499 rx_data[5] hold71/a_56_118# 0.00119f
C29500 _180_ _703_/a_324_432# 0.00118f
C29501 _662_/a_38_114# _074_ 0
C29502 _671_/a_38_114# _168_ 0.01424f
C29503 _671_/a_324_432# net62 0.03052f
C29504 clknet_0_clk _685_/a_1583_191# 0.02154f
C29505 net119 _000_ 0.04273f
C29506 _061_ net30 0.14875f
C29507 _691_/a_1583_191# baud_inst.counter\[20\] 0.00152f
C29508 net55 input5/a_40_152# 0.00815f
C29509 hold171/a_326_118# FILLER_3_141/a_40_246# 0
C29510 _163_ _296_ 0.01871f
C29511 hold67/a_326_118# VPWR 0.00126f
C29512 _669_/a_1489_191# clknet_4_9_0_clk 0.0052f
C29513 net44 _164_ 0.00918f
C29514 _676_/a_741_93# VPWR 0.01826f
C29515 _090_ _036_ 0
C29516 _062_ hold122/a_326_118# 0
C29517 hold101/a_326_118# hold157/a_56_118# 0.00191f
C29518 net44 _690_/a_2250_412# 0
C29519 _177_ net113 0
C29520 FILLER_13_102/a_32_246# net39 0.0183f
C29521 _639_/a_2250_412# VPWR 0.00463f
C29522 _226_ _450_/a_398_96# 0
C29523 net119 _647_/a_38_114# 0
C29524 _465_/a_22_110# net30 0.02635f
C29525 _061_ _647_/a_324_432# 0
C29526 output15/a_40_152# _635_/a_2250_412# 0
C29527 _217_ _651_/a_1583_191# 0
C29528 VPWR _683_/a_741_93# 0.02712f
C29529 net6 _211_ 0
C29530 baud_inst.counter\[14\] _685_/a_324_432# 0
C29531 net4 tx_data[4] 0.042f
C29532 tx_data[1] net7 0
C29533 _665_/a_1489_191# tx_inst.state\[3\] 0.00293f
C29534 net49 _702_/a_298_337# 0
C29535 _460_/a_22_110# _668_/a_843_236# 0
C29536 _030_ FILLER_5_32/a_40_246# 0.00184f
C29537 net34 hold57/a_56_118# 0.06509f
C29538 _266_ _264_ 1.8338f
C29539 _640_/a_132_114# net49 0
C29540 VPWR _701_/a_324_432# 0
C29541 baud_inst.counter\[18\] _528_/a_175_118# 0.00108f
C29542 clk _071_ 0.0436f
C29543 _510_/a_146_122# _182_ 0
C29544 _183_ _280_ 0.00348f
C29545 net36 fanout24/a_40_152# 0.01222f
C29546 _693_/a_1583_191# _106_ 0
C29547 _675_/a_2250_412# hold60/a_56_118# 0
C29548 hold161/a_326_118# _103_ 0
C29549 _167_ _264_ 0.00439f
C29550 net44 _697_/a_1785_429# 0.00212f
C29551 rx_data[7] _168_ 0
C29552 _194_ _195_ 0.08605f
C29553 tx_done _704_/a_2002_114# 0
C29554 net105 _313_ 0.83685f
C29555 net156 _688_/a_1785_429# 0
C29556 net179 _706_/a_132_114# 0
C29557 _519_/a_379_118# _011_ 0
C29558 hold63/a_438_182# net166 0
C29559 _519_/a_81_118# _684_/a_741_93# 0
C29560 _264_ _647_/a_741_93# 0
C29561 net104 VPWR 0.02212f
C29562 _179_ _311_ 0
C29563 _206_ net4 0
C29564 clk FILLER_0_154/a_40_246# 0.00124f
C29565 _193_ tx_inst.bit_index\[2\] 0
C29566 net30 _433_/a_142_412# 0
C29567 _229_ net175 0
C29568 rx_inst.state\[2\] net24 0.14613f
C29569 clkbuf_4_10_0_clk/a_27_118# clknet_0_clk 0.02099f
C29570 _661_/a_741_93# net171 0.00116f
C29571 _661_/a_38_114# _148_ 0.0012f
C29572 clknet_4_1_0_clk _384_/a_559_412# 0.00124f
C29573 _294_ VPWR 0.24687f
C29574 _116_ net59 0
C29575 net38 _209_ 0.0267f
C29576 rx_inst.data_reg\[1\] _044_ 0.00379f
C29577 _550_/a_380_412# _701_/a_843_236# 0
C29578 tx _275_ 0.0045f
C29579 _118_ hold55/a_438_182# 0
C29580 FILLER_10_78/a_32_246# _280_ 0
C29581 tx_inst.bit_index\[1\] net122 0
C29582 fanout27/a_40_152# clkbuf_4_6_0_clk/a_27_118# 0
C29583 _644_/a_843_236# _159_ 0.01582f
C29584 _644_/a_298_337# _134_ 0
C29585 net37 _169_ 0.19997f
C29586 _360_/a_1377_160# net41 0.00603f
C29587 FILLER_9_70/a_40_246# net29 0.01112f
C29588 _223_ _436_/a_244_412# 0.00237f
C29589 _697_/a_2250_412# clknet_0_clk 0.00786f
C29590 hold145/a_326_118# net145 0
C29591 net154 _280_ 0.18124f
C29592 tx_busy _704_/a_741_93# 0.03154f
C29593 net89 _100_ 0.15296f
C29594 net111 clknet_4_12_0_clk 0.36408f
C29595 _663_/a_298_337# net26 0.00168f
C29596 hold108/a_438_182# clknet_0_clk 0.02848f
C29597 hold69/a_438_182# VPWR 0.00422f
C29598 hold140/a_326_118# hold99/a_326_118# 0.00159f
C29599 clknet_4_3_0_clk net153 0
C29600 hold118/a_326_118# clknet_4_13_0_clk 0.01292f
C29601 _674_/a_550_127# net61 0
C29602 hold181/a_56_118# net38 0.03013f
C29603 _241_ FILLER_17_160/a_40_246# 0.00346f
C29604 _053_ _669_/a_681_505# 0
C29605 clknet_4_12_0_clk _669_/a_741_93# 0
C29606 _132_ _669_/a_843_236# 0.00243f
C29607 _060_ _155_ 0
C29608 _645_/a_741_93# _159_ 0.0179f
C29609 _185_ VPWR 0.10672f
C29610 _424_/a_244_412# _139_ 0.00134f
C29611 clknet_4_11_0_clk baud_inst.counter\[25\] 0
C29612 FILLER_24_229/a_32_246# net30 0
C29613 _170_ hold144/a_56_118# 0.02775f
C29614 tx_inst.bit_index\[1\] _657_/a_1840_334# 0
C29615 clknet_4_0_0_clk VPWR 1.05418f
C29616 _704_/a_132_114# _121_ 0
C29617 _302_ _692_/a_298_337# 0.00522f
C29618 _399_/a_154_118# _216_ 0
C29619 _135_ _440_/a_244_412# 0.01869f
C29620 net55 _654_/a_681_505# 0
C29621 _653_/a_1583_191# FILLER_10_145/a_40_246# 0
C29622 _651_/a_324_432# _142_ 0.00135f
C29623 _651_/a_741_93# _220_ 0
C29624 hold156/a_326_118# _508_/a_380_412# 0
C29625 net42 _651_/a_324_432# 0
C29626 net77 _272_ 0.1754f
C29627 _139_ _649_/a_550_127# 0
C29628 clknet_4_1_0_clk clkbuf_4_1_0_clk/a_27_118# 0.04756f
C29629 _231_ _486_/a_358_436# 0.03084f
C29630 net55 _664_/a_2250_412# 0
C29631 _662_/a_298_337# _203_ 0
C29632 net92 _289_ 0
C29633 FILLER_10_14/a_40_246# _689_/a_741_93# 0
C29634 output22/a_40_152# _707_/a_843_236# 0
C29635 net32 _236_ 0.08412f
C29636 _444_/a_244_412# _254_ 0
C29637 _444_/a_142_412# _256_ 0
C29638 fanout41/a_40_152# _211_ 0
C29639 _659_/a_2250_412# clknet_4_4_0_clk 0.02343f
C29640 clknet_4_13_0_clk _273_ 0
C29641 hold141/a_438_182# clknet_0_clk 0
C29642 _220_ _007_ 0
C29643 _383_/a_268_412# _209_ 0
C29644 net46 clknet_4_9_0_clk 0.24814f
C29645 _672_/a_1785_429# _181_ 0.00107f
C29646 _672_/a_612_127# net60 0.02644f
C29647 net42 net169 0.00546f
C29648 _677_/a_1489_191# clkbuf_4_3_0_clk/a_27_118# 0
C29649 _639_/a_2250_412# _266_ 0
C29650 _229_ _161_ 0
C29651 net28 _204_ 0.01072f
C29652 _081_ _168_ 0.00163f
C29653 _175_ VPWR 0.17103f
C29654 _695_/a_2002_114# clknet_4_10_0_clk 0
C29655 _707_/a_741_93# _121_ 0.00164f
C29656 net98 FILLER_8_19/a_40_246# 0
C29657 net20 _707_/a_2250_412# 0.02459f
C29658 rx_done _707_/a_1840_334# 0
C29659 FILLER_26_227/a_40_246# net18 0.00277f
C29660 hold55/a_56_118# VPWR 0.00974f
C29661 net57 fanout34/a_40_152# 0
C29662 tx_inst.state\[4\] _666_/a_1583_191# 0.00151f
C29663 baud_inst.counter\[24\] _687_/a_1583_191# 0
C29664 net140 _687_/a_1840_334# 0
C29665 _118_ _705_/a_681_505# 0
C29666 baud_inst.counter\[22\] _699_/a_681_505# 0
C29667 _656_/a_324_432# tx_inst.data_reg\[0\] 0
C29668 _040_ hold54/a_326_118# 0.02784f
C29669 FILLER_7_82/a_32_246# _182_ 0
C29670 _691_/a_132_114# net163 0
C29671 _691_/a_843_236# _020_ 0
C29672 hold108/a_438_182# _182_ 0
C29673 _671_/a_741_93# _240_ 0
C29674 _269_ VPWR 0.20469f
C29675 net154 _191_ 0
C29676 clknet_4_4_0_clk _664_/a_1583_191# 0.00163f
C29677 net174 tx_inst.bit_index\[2\] 0
C29678 net65 _273_ 0.24772f
C29679 _122_ net64 0.0985f
C29680 net37 _084_ 0
C29681 hold105/a_326_118# VPWR 0.00609f
C29682 _302_ _164_ 1.00172f
C29683 _052_ net100 0.0085f
C29684 _207_ net38 0.02138f
C29685 _191_ _189_ 0
C29686 net166 rx_inst.state\[3\] 0.01526f
C29687 _645_/a_298_337# fanout47/a_40_152# 0
C29688 clkload2/Y _180_ 0.00168f
C29689 _640_/a_324_432# _051_ 0.01268f
C29690 FILLER_2_110/a_32_246# _209_ 0
C29691 _414_/a_279_412# net51 0
C29692 baud_inst.counter\[27\] net99 1.26262f
C29693 VPWR net165 0.2537f
C29694 _217_ _394_/a_22_110# 0
C29695 _686_/a_38_114# _685_/a_843_236# 0
C29696 _686_/a_741_93# _685_/a_324_432# 0
C29697 _686_/a_324_432# _685_/a_741_93# 0
C29698 _690_/a_298_337# _103_ 0.03332f
C29699 clknet_4_3_0_clk _280_ 0.11944f
C29700 _045_ _637_/a_38_114# 0.00231f
C29701 _242_ _252_ 0.00561f
C29702 VPWR FILLER_3_123/a_32_246# 0.08559f
C29703 hold179/a_438_182# _200_ 0
C29704 _285_ baud_inst.counter\[7\] 0
C29705 _226_ net24 0.00186f
C29706 _284_ _677_/a_741_93# 0
C29707 _286_ net96 0.0491f
C29708 hold74/a_438_182# _264_ 0.00599f
C29709 _198_ _664_/a_681_505# 0
C29710 net2 _650_/a_1583_191# 0
C29711 rx_inst.state\[3\] _373_/a_170_412# 0
C29712 hold69/a_438_182# _266_ 0
C29713 VPWR net113 0.09734f
C29714 hold144/a_56_118# hold139/a_438_182# 0
C29715 _706_/a_2002_114# VPWR 0
C29716 _041_ _667_/a_2002_114# 0.00118f
C29717 _023_ _106_ 0
C29718 _351_/a_46_156# _162_ 0.04714f
C29719 _155_ _649_/a_741_93# 0
C29720 net124 _649_/a_843_236# 0
C29721 _228_ VPWR 0.33181f
C29722 _251_ _437_/a_154_118# 0
C29723 net45 _693_/a_843_236# 0.00104f
C29724 hold168/a_56_118# _192_ 0
C29725 hold168/a_438_182# net27 0
C29726 _143_ _659_/a_612_127# 0
C29727 net100 FILLER_20_95/a_40_246# 0
C29728 _309_ _540_/a_45_160# 0
C29729 _542_/a_257_140# _308_ 0.00259f
C29730 _705_/a_741_93# VPWR 0.01322f
C29731 _169_ _667_/a_1489_191# 0.00138f
C29732 _116_ _032_ 0.02582f
C29733 _034_ clkbuf_4_3_0_clk/a_27_118# 0.00275f
C29734 hold111/a_326_118# clkbuf_4_13_0_clk/a_27_118# 0
C29735 _099_ _686_/a_1840_334# 0
C29736 net46 _686_/a_2250_412# 0
C29737 _697_/a_324_432# _110_ 0.01817f
C29738 _697_/a_38_114# net142 0.01864f
C29739 output18/a_40_152# net18 0.0223f
C29740 _021_ _304_ 0.05531f
C29741 hold87/a_56_118# net90 0.0013f
C29742 _699_/a_132_114# net114 0
C29743 net35 FILLER_18_160/a_32_246# 0.01645f
C29744 hold67/a_438_182# _032_ 0
C29745 _461_/a_22_110# _264_ 0.00382f
C29746 net157 _522_/a_209_168# 0.0021f
C29747 _515_/a_76_160# _292_ 0.02f
C29748 _449_/a_27_156# hold180/a_438_182# 0.00217f
C29749 _117_ tx_inst.state\[1\] 0.2215f
C29750 _008_ hold61/a_56_118# 0.01539f
C29751 net48 _223_ 0.16469f
C29752 hold152/a_326_118# baud_inst.counter\[5\] 0.04812f
C29753 clknet_0_clk _685_/a_2002_114# 0
C29754 _029_ net49 0.00106f
C29755 hold142/a_326_118# hold100/a_56_118# 0.00145f
C29756 _147_ clkbuf_4_1_0_clk/a_27_118# 0.00498f
C29757 _671_/a_1840_334# _168_ 0
C29758 _532_/a_155_412# VPWR 0.00121f
C29759 hold55/a_56_118# FILLER_7_234/a_32_246# 0
C29760 _184_ _683_/a_324_432# 0
C29761 hold183/a_56_118# VPWR 0.05997f
C29762 _508_/a_209_168# _096_ 0.01448f
C29763 _651_/a_1489_191# clknet_4_6_0_clk 0.0013f
C29764 _097_ baud_inst.counter\[13\] 0.00352f
C29765 _659_/a_741_93# clknet_0_clk 0
C29766 _282_ _287_ 0.06703f
C29767 clknet_4_3_0_clk _191_ 0.05512f
C29768 hold161/a_438_182# _688_/a_38_114# 0
C29769 _695_/a_298_337# VPWR 0.00542f
C29770 hold85/a_56_118# _270_ 0.00789f
C29771 _270_ _635_/a_843_236# 0
C29772 _125_ _635_/a_741_93# 0
C29773 FILLER_9_70/a_40_246# hold95/a_438_182# 0
C29774 _024_ _541_/a_209_168# 0.02251f
C29775 _269_ _266_ 0.36839f
C29776 net15 _635_/a_1489_191# 0
C29777 _170_ _224_ 0.64203f
C29778 _073_ _665_/a_741_93# 0.00217f
C29779 hold165/a_326_118# net55 0
C29780 _658_/a_298_337# tx_inst.data_reg\[1\] 0
C29781 clk net26 0.02293f
C29782 _314_ hold114/a_438_182# 0
C29783 _348_/a_248_122# net86 0
C29784 hold184/a_326_118# net183 0
C29785 net49 _702_/a_1583_191# 0
C29786 baud_inst.counter\[28\] _031_ 0
C29787 _675_/a_2250_412# _287_ 0
C29788 _679_/a_2250_412# _499_/a_209_168# 0
C29789 _300_ _299_ 0.01656f
C29790 clkbuf_4_9_0_clk/a_27_118# net91 0.00462f
C29791 net48 _240_ 0.06978f
C29792 _110_ FILLER_17_94/a_40_246# 0
C29793 _640_/a_1489_191# net49 0
C29794 VPWR _701_/a_2250_412# 0.00507f
C29795 _386_/a_382_118# _386_/a_496_118# 0
C29796 baud_inst.counter\[18\] net103 0.07558f
C29797 clkbuf_4_11_0_clk/a_27_118# net45 0.04415f
C29798 _177_ baud_inst.counter\[29\] 0.00424f
C29799 _153_ VPWR 0.86013f
C29800 net44 _110_ 0.02736f
C29801 _006_ _665_/a_38_114# 0.04866f
C29802 _275_ _665_/a_324_432# 0.0023f
C29803 _397_/a_279_412# _217_ 0.00114f
C29804 net44 _642_/a_681_505# 0
C29805 _645_/a_132_114# _056_ 0
C29806 net179 _706_/a_1489_191# 0
C29807 net97 FILLER_11_32/a_32_246# 0
C29808 baud_inst.counter\[12\] _684_/a_843_236# 0.00178f
C29809 net128 _684_/a_741_93# 0
C29810 hold88/a_56_118# _684_/a_2250_412# 0
C29811 hold88/a_438_182# _684_/a_1583_191# 0
C29812 hold88/a_326_118# _684_/a_1840_334# 0
C29813 _236_ FILLER_25_150/a_32_246# 0.00394f
C29814 clknet_0_clk FILLER_6_98/a_40_246# 0.03397f
C29815 _523_/a_257_140# net160 0
C29816 _523_/a_155_412# _296_ 0.02817f
C29817 net30 _156_ 0.037f
C29818 _661_/a_1840_334# _148_ 0.01111f
C29819 clknet_4_5_0_clk _369_/a_146_122# 0
C29820 hold113/a_438_182# _180_ 0.0376f
C29821 _307_ _687_/a_298_337# 0
C29822 _538_/a_379_118# baud_inst.counter\[23\] 0.00138f
C29823 _538_/a_175_118# _306_ 0
C29824 hold78/a_326_118# VPWR 0.03626f
C29825 _659_/a_324_432# _386_/a_382_118# 0
C29826 _659_/a_741_93# _386_/a_59_156# 0
C29827 _678_/a_1489_191# hold92/a_56_118# 0
C29828 net44 _686_/a_681_505# 0
C29829 net133 _701_/a_1583_191# 0
C29830 _550_/a_209_168# _701_/a_1489_191# 0
C29831 hold154/a_326_118# net40 0.00219f
C29832 _546_/a_341_118# clknet_0_clk 0.00235f
C29833 hold140/a_56_118# _641_/a_132_114# 0
C29834 net10 _655_/a_843_236# 0
C29835 net55 _655_/a_681_505# 0
C29836 hold165/a_326_118# _067_ 0
C29837 _644_/a_612_127# _159_ 0.01265f
C29838 _055_ _444_/a_244_412# 0
C29839 net132 _444_/a_142_412# 0
C29840 hold59/a_56_118# _702_/a_324_432# 0
C29841 rx_inst.state\[2\] _641_/a_324_432# 0
C29842 baud_inst.counter\[26\] _695_/a_1840_334# 0
C29843 baud_inst.counter\[27\] _695_/a_2250_412# 0
C29844 hold120/a_56_118# _302_ 0.00205f
C29845 baud_inst.counter\[22\] hold107/a_56_118# 0
C29846 tx_inst.bit_index\[1\] net41 0.02761f
C29847 _216_ net56 0.01301f
C29848 _374_/a_244_140# net62 0
C29849 _685_/a_741_93# clknet_4_9_0_clk 0.03826f
C29850 net177 _296_ 0.14714f
C29851 _223_ _250_ 0.02914f
C29852 _156_ _647_/a_324_432# 0.00571f
C29853 _064_ _206_ 0
C29854 tx_busy _704_/a_1785_429# 0.00192f
C29855 _684_/a_843_236# net88 0
C29856 rx _639_/a_38_114# 0.00131f
C29857 net2 _639_/a_298_337# 0.00212f
C29858 _642_/a_843_236# clknet_0_clk 0.00468f
C29859 FILLER_18_148/a_40_246# hold180/a_56_118# 0.0034f
C29860 rx_inst.data_reg\[1\] _648_/a_38_114# 0
C29861 _062_ _651_/a_298_337# 0.01252f
C29862 _671_/a_843_236# clknet_0_clk 0.0063f
C29863 _228_ _167_ 0
C29864 _684_/a_38_114# clknet_4_2_0_clk 0.00236f
C29865 _132_ _669_/a_612_127# 0
C29866 baud_inst.counter\[20\] hold103/a_56_118# 0
C29867 _645_/a_1785_429# _159_ 0
C29868 FILLER_1_30/a_32_246# FILLER_1_28/a_40_246# 0.0524f
C29869 hold159/a_56_118# net41 0.00492f
C29870 FILLER_4_183/a_40_246# net168 0.01581f
C29871 _484_/a_154_118# baud_inst.counter\[4\] 0
C29872 rx_data[3] hold84/a_56_118# 0.01942f
C29873 net15 hold84/a_326_118# 0.03544f
C29874 clknet_0_clk _686_/a_843_236# 0.00802f
C29875 _228_ _225_ 0
C29876 _170_ _235_ 0.01119f
C29877 net55 _654_/a_550_127# 0
C29878 output18/a_40_152# _634_/a_2250_412# 0.00152f
C29879 _230_ _640_/a_1583_191# 0.00196f
C29880 net49 _693_/a_38_114# 0
C29881 _646_/a_741_93# FILLER_21_192/a_40_246# 0
C29882 _062_ _166_ 0
C29883 net147 net164 0.00461f
C29884 _360_/a_71_118# net34 0
C29885 net42 _651_/a_2250_412# 0
C29886 _240_ _250_ 0
C29887 net164 net46 0
C29888 baud_inst.counter\[13\] _670_/a_843_236# 0
C29889 _048_ hold82/a_326_118# 0
C29890 hold52/a_56_118# _640_/a_2250_412# 0.00115f
C29891 _707_/a_324_432# _704_/a_38_114# 0
C29892 _707_/a_38_114# _704_/a_324_432# 0
C29893 _551_/a_76_160# _314_ 0.0033f
C29894 _244_ FILLER_25_163/a_32_246# 0
C29895 net153 baud_inst.counter\[5\] 0.03752f
C29896 tx_busy _707_/a_1583_191# 0.0087f
C29897 net39 _684_/a_843_236# 0
C29898 net6 _655_/a_1583_191# 0.02033f
C29899 VPWR _350_/a_279_412# 0
C29900 _528_/a_81_118# _100_ 0
C29901 _159_ _256_ 0.06161f
C29902 _138_ _264_ 0
C29903 hold148/a_438_182# _302_ 0.0086f
C29904 clkbuf_4_5_0_clk/a_27_118# _664_/a_843_236# 0
C29905 net11 _665_/a_1840_334# 0
C29906 _170_ _409_/a_269_412# 0
C29907 _227_ _409_/a_73_118# 0
C29908 hold138/a_326_118# VPWR 0.00373f
C29909 net49 FILLER_25_9/a_32_246# 0.00122f
C29910 _632_/a_741_93# rx_inst.data_reg\[6\] 0
C29911 _235_ hold62/a_56_118# 0
C29912 _691_/a_550_127# net104 0
C29913 _232_ _264_ 0
C29914 _658_/a_741_93# VPWR 0.01779f
C29915 net92 net135 0.2297f
C29916 net94 _287_ 0.19154f
C29917 FILLER_13_102/a_32_246# FILLER_13_100/a_40_246# 0.0524f
C29918 _690_/a_741_93# baud_inst.counter\[17\] 0.00755f
C29919 _050_ net30 0.00656f
C29920 _288_ _681_/a_1840_334# 0
C29921 net116 _681_/a_1583_191# 0.00443f
C29922 _501_/a_154_118# _287_ 0
C29923 net173 _396_/a_257_140# 0
C29924 net45 _115_ 0.01022f
C29925 hold69/a_326_118# _049_ 0.00142f
C29926 _248_ _227_ 0
C29927 hold75/a_56_118# VPWR 0.02104f
C29928 hold113/a_438_182# net140 0
C29929 FILLER_8_63/a_40_246# _096_ 0
C29930 _095_ FILLER_8_19/a_40_246# 0
C29931 _011_ _683_/a_38_114# 0
C29932 _163_ _683_/a_741_93# 0
C29933 _633_/a_38_114# FILLER_29_179/a_40_246# 0
C29934 net75 FILLER_22_43/a_40_246# 0.02486f
C29935 _118_ _705_/a_550_127# 0
C29936 baud_inst.counter\[24\] _687_/a_2002_114# 0
C29937 baud_inst.counter\[22\] _694_/a_324_432# 0.04501f
C29938 hold53/a_438_182# net52 0
C29939 hold53/a_56_118# _130_ 0.06979f
C29940 _641_/a_1840_334# hold176/a_56_118# 0
C29941 net55 FILLER_5_213/a_32_246# 0
C29942 _656_/a_2250_412# tx_inst.data_reg\[0\] 0
C29943 _691_/a_612_127# _020_ 0
C29944 _691_/a_1489_191# net163 0.00359f
C29945 FILLER_20_177/a_32_246# VPWR 0.08201f
C29946 hold92/a_56_118# net40 0
C29947 _153_ _266_ 0.37207f
C29948 net26 net2 0.72756f
C29949 hold69/a_326_118# _638_/a_1583_191# 0.00358f
C29950 _646_/a_1489_191# net111 0
C29951 net55 _214_ 0.01034f
C29952 hold130/a_56_118# _182_ 0
C29953 _535_/a_146_122# net49 0.00103f
C29954 hold69/a_438_182# _461_/a_22_110# 0
C29955 _224_ _263_ 0
C29956 hold81/a_56_118# net19 0
C29957 _126_ rx_inst.data_reg\[7\] 0
C29958 net32 net2 0
C29959 _643_/a_132_114# _264_ 0
C29960 tx_inst.data_reg\[6\] _656_/a_38_114# 0
C29961 net79 _279_ 0.07009f
C29962 _707_/a_38_114# net19 0
C29963 _153_ _167_ 0.08581f
C29964 net35 FILLER_17_160/a_40_246# 0
C29965 _649_/a_1489_191# _648_/a_1583_191# 0
C29966 rx_inst.bit_index\[1\] _246_ 0.05281f
C29967 _530_/a_257_140# clknet_4_8_0_clk 0
C29968 hold175/a_326_118# _224_ 0
C29969 _286_ hold135/a_438_182# 0
C29970 _407_/a_248_122# _249_ 0
C29971 fanout38/a_40_152# net38 0
C29972 _690_/a_681_505# clknet_4_8_0_clk 0
C29973 baud_inst.counter\[28\] net46 0.03452f
C29974 net27 _477_/a_120_432# 0.0086f
C29975 _357_/a_354_412# VPWR 0
C29976 net87 _687_/a_843_236# 0.02116f
C29977 hold139/a_56_118# _241_ 0
C29978 net71 _637_/a_298_337# 0
C29979 net45 _701_/a_38_114# 0.01948f
C29980 _294_ _163_ 0
C29981 hold74/a_438_182# _269_ 0
C29982 fanout44/a_40_152# FILLER_20_0/a_40_246# 0
C29983 output13/a_40_152# _633_/a_324_432# 0
C29984 baud_inst.counter\[13\] net90 0
C29985 net2 hold62/a_326_118# 0.00613f
C29986 VPWR _434_/a_150_412# 0
C29987 _178_ _311_ 0
C29988 hold81/a_326_118# hold51/a_56_118# 0
C29989 hold81/a_56_118# hold51/a_326_118# 0
C29990 _229_ FILLER_18_148/a_40_246# 0.01382f
C29991 _632_/a_324_432# FILLER_21_229/a_32_246# 0
C29992 hold155/a_326_118# hold155/a_438_182# 0
C29993 tx_inst.state\[4\] _215_ 0.03713f
C29994 _646_/a_550_127# _057_ 0
C29995 _707_/a_324_432# hold51/a_56_118# 0
C29996 rx_inst.state\[3\] clknet_4_9_0_clk 0.00328f
C29997 hold174/a_326_118# _359_/a_22_110# 0
C29998 net54 clknet_4_4_0_clk 0.0186f
C29999 _009_ baud_inst.counter\[16\] 0.00114f
C30000 clknet_4_6_0_clk _668_/a_38_114# 0.02188f
C30001 _411_/a_115_308# net26 0.0021f
C30002 hold146/a_326_118# tx_inst.state\[4\] 0.00143f
C30003 hold149/a_326_118# net46 0.0671f
C30004 baud_inst.counter\[5\] _280_ 2.44865f
C30005 fanout33/a_40_152# VPWR 0.0915f
C30006 net34 _172_ 0.01412f
C30007 _314_ _700_/a_741_93# 0
C30008 _135_ FILLER_26_141/a_40_246# 0.01498f
C30009 net105 _700_/a_132_114# 0
C30010 hold183/a_438_182# _400_/a_192_429# 0
C30011 _470_/a_22_110# _648_/a_1583_191# 0
C30012 _656_/a_681_505# VPWR 0
C30013 hold74/a_326_118# _156_ 0
C30014 hold131/a_56_118# clknet_4_14_0_clk 0.00376f
C30015 clknet_4_14_0_clk FILLER_25_163/a_32_246# 0.00536f
C30016 clknet_4_4_0_clk _364_/a_257_140# 0
C30017 hold169/a_326_118# _171_ 0
C30018 VPWR baud_inst.counter\[29\] 0.18756f
C30019 rx_inst.state\[2\] _486_/a_115_308# 0
C30020 _216_ _476_/a_248_122# 0
C30021 _697_/a_2250_412# _110_ 0
C30022 clknet_4_14_0_clk net47 0.00214f
C30023 hold99/a_438_182# baud_inst.counter\[25\] 0
C30024 fanout41/a_40_152# tx_inst.data_reg\[5\] 0
C30025 hold64/a_438_182# _632_/a_1840_334# 0.00197f
C30026 _214_ _076_ 0.00223f
C30027 _642_/a_1840_334# _131_ 0
C30028 net36 FILLER_19_132/a_40_246# 0.00347f
C30029 _642_/a_2250_412# _262_ 0
C30030 _644_/a_38_114# _170_ 0.00208f
C30031 hold143/a_56_118# clknet_0_clk 0.02108f
C30032 _661_/a_843_236# _206_ 0
C30033 _661_/a_38_114# _151_ 0.05127f
C30034 _661_/a_741_93# net155 0.00318f
C30035 net157 _296_ 0.22092f
C30036 _299_ net160 0.022f
C30037 rx_data[0] _632_/a_1489_191# 0
C30038 hold121/a_438_182# hold147/a_326_118# 0
C30039 hold121/a_326_118# hold147/a_438_182# 0.0021f
C30040 _067_ FILLER_3_150/a_40_246# 0.00629f
C30041 FILLER_19_118/a_32_246# clknet_0_clk 0
C30042 _254_ _441_/a_154_118# 0
C30043 _376_/a_76_160# clkbuf_4_5_0_clk/a_27_118# 0
C30044 clknet_4_12_0_clk clknet_4_15_0_clk 0.00161f
C30045 _303_ VPWR 0.07093f
C30046 _184_ _683_/a_2250_412# 0.00482f
C30047 clknet_4_10_0_clk _312_ 0.00156f
C30048 _314_ hold106/a_56_118# 0.01089f
C30049 _455_/a_155_412# net24 0.02626f
C30050 FILLER_6_189/a_40_246# _664_/a_38_114# 0
C30051 _674_/a_38_114# _030_ 0.02491f
C30052 _695_/a_1583_191# VPWR 0.0086f
C30053 net97 _291_ 0.12065f
C30054 _270_ _635_/a_612_127# 0
C30055 net173 _402_/a_154_118# 0
C30056 baud_inst.counter\[12\] FILLER_12_82/a_32_246# 0
C30057 net85 _125_ 0
C30058 _645_/a_298_337# _170_ 0
C30059 hold64/a_56_118# net66 0
C30060 net180 net29 0
C30061 _679_/a_1489_191# VPWR 0
C30062 net31 _421_/a_252_412# 0
C30063 _040_ _665_/a_1840_334# 0.00246f
C30064 VPWR _096_ 0.32343f
C30065 _264_ hold73/a_326_118# 0.04135f
C30066 _500_/a_257_140# clknet_0_clk 0
C30067 net94 clkbuf_4_0_0_clk/a_27_118# 0.02156f
C30068 FILLER_7_176/a_32_246# _166_ 0
C30069 _663_/a_1840_334# net146 0.00149f
C30070 _663_/a_1583_191# net50 0
C30071 FILLER_15_173/a_40_246# net30 0
C30072 _058_ _436_/a_142_412# 0
C30073 hold141/a_326_118# net142 0
C30074 _265_ _668_/a_1489_191# 0
C30075 rx_inst.bit_index\[0\] net49 0
C30076 baud_inst.counter\[18\] net101 0
C30077 hold164/a_56_118# _302_ 0
C30078 FILLER_21_175/a_32_246# _133_ 0.00978f
C30079 _191_ baud_inst.counter\[5\] 0
C30080 hold175/a_56_118# net49 0
C30081 _218_ _219_ 0.28912f
C30082 _082_ _642_/a_612_127# 0
C30083 net44 _642_/a_550_127# 0
C30084 hold74/a_326_118# _050_ 0
C30085 FILLER_26_151/a_32_246# net24 0
C30086 net179 _042_ 0
C30087 _703_/a_843_236# net46 0
C30088 VPWR hold80/a_56_118# 0.0095f
C30089 hold154/a_56_118# _281_ 0.10957f
C30090 net166 _205_ 0.26518f
C30091 clkbuf_4_11_0_clk/a_27_118# FILLER_21_96/a_40_246# 0
C30092 _699_/a_843_236# _165_ 0.00189f
C30093 tx_inst.data_reg\[4\] _212_ 0
C30094 net143 _240_ 0.03232f
C30095 _001_ _666_/a_741_93# 0.00385f
C30096 _298_ _296_ 0.04416f
C30097 FILLER_18_158/a_40_246# _249_ 0
C30098 FILLER_7_82/a_32_246# net152 0
C30099 net48 _447_/a_81_118# 0
C30100 _072_ net171 0
C30101 _680_/a_324_432# _504_/a_209_168# 0
C30102 _307_ _687_/a_1583_191# 0
C30103 baud_inst.counter\[23\] _306_ 0.01491f
C30104 net45 hold105/a_56_118# 0
C30105 hold175/a_438_182# net2 0.00524f
C30106 net44 _686_/a_550_127# 0
C30107 net26 _169_ 0.37091f
C30108 net28 VPWR 0.30998f
C30109 baud_inst.counter\[28\] _313_ 0.52245f
C30110 net132 _159_ 0.19099f
C30111 rx_inst.state\[2\] _641_/a_2250_412# 0.00127f
C30112 net34 clk 0
C30113 _306_ _100_ 0
C30114 _170_ _649_/a_298_337# 0
C30115 net99 FILLER_23_83/a_32_246# 0
C30116 baud_inst.counter\[12\] hold128/a_438_182# 0
C30117 net128 hold128/a_326_118# 0.00452f
C30118 hold160/a_56_118# VPWR 0.05566f
C30119 _685_/a_1785_429# clknet_4_9_0_clk 0
C30120 hold182/a_326_118# net29 0
C30121 _156_ _647_/a_2250_412# 0.00611f
C30122 net31 net24 0.33061f
C30123 net2 _639_/a_1583_191# 0.01458f
C30124 net32 _169_ 0.00913f
C30125 _642_/a_612_127# clknet_0_clk 0.00122f
C30126 net39 FILLER_12_82/a_32_246# 0
C30127 _373_/a_170_412# _205_ 0.00167f
C30128 _225_ _434_/a_150_412# 0.00255f
C30129 _390_/a_382_118# net6 0.01669f
C30130 FILLER_11_32/a_32_246# baud_inst.counter\[17\] 0
C30131 _689_/a_612_127# net158 0
C30132 _689_/a_2250_412# baud_inst.counter\[17\] 0.01027f
C30133 _548_/a_76_160# _308_ 0.00643f
C30134 clknet_4_13_0_clk _638_/a_741_93# 0
C30135 _663_/a_324_432# _200_ 0
C30136 _062_ _651_/a_1583_191# 0
C30137 _663_/a_741_93# net168 0
C30138 _671_/a_612_127# clknet_0_clk 0.00141f
C30139 _188_ _296_ 0.37203f
C30140 _684_/a_1840_334# clknet_4_2_0_clk 0
C30141 _704_/a_132_114# net43 0
C30142 _041_ hold62/a_438_182# 0
C30143 baud_inst.counter\[24\] _541_/a_209_168# 0.02693f
C30144 _645_/a_1489_191# _134_ 0
C30145 _536_/a_341_118# VPWR 0.00125f
C30146 _341_/a_1377_160# _208_ 0
C30147 _659_/a_741_93# net43 0
C30148 clknet_0_clk _686_/a_612_127# 0.0024f
C30149 hold130/a_438_182# _013_ 0
C30150 FILLER_1_90/a_32_246# VPWR 0.09321f
C30151 _646_/a_1583_191# FILLER_17_199/a_40_246# 0
C30152 _692_/a_741_93# clknet_4_8_0_clk 0
C30153 baud_inst.counter\[28\] _552_/a_257_140# 0.00131f
C30154 _230_ _640_/a_2002_114# 0
C30155 net49 _693_/a_1840_334# 0.00731f
C30156 hold140/a_326_118# _111_ 0
C30157 tx net50 0
C30158 _169_ hold62/a_326_118# 0.0663f
C30159 _360_/a_886_118# _174_ 0
C30160 _180_ fanout29/a_40_152# 0.00912f
C30161 baud_inst.counter\[13\] _670_/a_612_127# 0.00165f
C30162 hold130/a_438_182# baud_inst.counter\[14\] 0
C30163 net72 hold72/a_438_182# 0.00401f
C30164 _245_ _242_ 0
C30165 hold68/a_56_118# _550_/a_177_436# 0
C30166 _093_ VPWR 0.28584f
C30167 hold146/a_326_118# FILLER_7_210/a_40_246# 0.00188f
C30168 VPWR _633_/a_38_114# 0.03662f
C30169 hold132/a_326_118# net49 0
C30170 _641_/a_298_337# net140 0
C30171 hold182/a_326_118# net182 0.00781f
C30172 _707_/a_1583_191# _704_/a_741_93# 0
C30173 _707_/a_741_93# _704_/a_1583_191# 0
C30174 _673_/a_324_432# net95 0
C30175 _673_/a_741_93# net29 0.00441f
C30176 tx_busy _707_/a_2002_114# 0
C30177 hold150/a_56_118# net150 0.02343f
C30178 net6 _655_/a_2002_114# 0
C30179 _638_/a_741_93# net65 0.0022f
C30180 _638_/a_324_432# _122_ 0
C30181 _195_ _220_ 0
C30182 baud_inst.counter\[14\] _686_/a_132_114# 0
C30183 baud_inst.counter\[15\] _686_/a_1583_191# 0
C30184 _462_/a_22_110# _267_ 0.00241f
C30185 _462_/a_120_432# _128_ -0
C30186 net155 _657_/a_550_127# 0
C30187 clkbuf_4_6_0_clk/a_27_118# FILLER_14_185/a_32_246# 0
C30188 _690_/a_1785_429# baud_inst.counter\[17\] 0
C30189 _658_/a_1785_429# VPWR 0
C30190 hold54/a_56_118# _706_/a_1583_191# 0
C30191 _707_/a_741_93# net43 0
C30192 _644_/a_741_93# clknet_4_14_0_clk 0.05547f
C30193 _043_ _474_/a_22_110# 0.00439f
C30194 _507_/a_170_412# net117 0
C30195 net116 _681_/a_2002_114# 0
C30196 _143_ _339_/a_71_118# 0
C30197 _398_/a_115_308# _339_/a_1377_160# 0.00176f
C30198 tx_inst.data_reg\[1\] _382_/a_285_412# 0
C30199 _171_ _665_/a_741_93# 0
C30200 tx_inst.bit_index\[2\] _218_ 0.05078f
C30201 hold88/a_438_182# baud_inst.counter\[13\] 0
C30202 net39 hold128/a_438_182# 0
C30203 rx_inst.state\[2\] clkbuf_0_clk/a_116_82# 0
C30204 baud_inst.counter\[22\] _694_/a_2250_412# 0.00383f
C30205 _064_ net145 0
C30206 hold98/a_326_118# _681_/a_843_236# 0
C30207 FILLER_21_192/a_40_246# net24 0
C30208 _360_/a_589_385# net165 0
C30209 _183_ hold93/a_438_182# 0
C30210 _431_/a_379_118# net32 0
C30211 rx_inst.data_reg\[3\] net111 0.00447f
C30212 _045_ hold82/a_56_118# 0
C30213 FILLER_23_158/a_40_246# _237_ 0.00242f
C30214 _678_/a_843_236# net40 0.00115f
C30215 _166_ FILLER_8_191/a_32_246# 0
C30216 net27 _651_/a_741_93# 0.00694f
C30217 _645_/a_324_432# clknet_4_14_0_clk 0.04021f
C30218 net66 _632_/a_324_432# 0.00669f
C30219 _358_/a_411_436# _182_ 0
C30220 net26 _084_ 0.02083f
C30221 _643_/a_1489_191# _264_ 0.00159f
C30222 net100 _698_/a_38_114# 0.02256f
C30223 hold100/a_56_118# _698_/a_1583_191# 0.00364f
C30224 _021_ _692_/a_741_93# 0
C30225 tx_inst.data_reg\[6\] _656_/a_1840_334# 0.00989f
C30226 _707_/a_1840_334# net19 0.00131f
C30227 net49 FILLER_24_19/a_40_246# 0.00816f
C30228 rx_inst.state\[2\] FILLER_21_147/a_40_246# 0.00794f
C30229 _682_/a_324_432# net117 0
C30230 _291_ clkbuf_4_2_0_clk/a_27_118# 0
C30231 _205_ _671_/a_324_432# 0
C30232 _649_/a_1583_191# rx_inst.data_reg\[5\] 0
C30233 hold174/a_56_118# _171_ 0
C30234 _091_ _678_/a_741_93# 0.00219f
C30235 net32 _084_ 0
C30236 _241_ _433_/a_244_412# 0.00311f
C30237 _361_/a_248_122# _196_ 0
C30238 _078_ clknet_0_clk 0.00788f
C30239 rx_data[7] _636_/a_1840_334# 0
C30240 _390_/a_285_118# _209_ 0
C30241 net153 clknet_0_clk 0
C30242 _686_/a_298_337# clknet_4_9_0_clk 0.00446f
C30243 net37 output16/a_40_152# 0
C30244 _112_ _699_/a_38_114# 0.05708f
C30245 net27 _007_ 0.14876f
C30246 net87 _687_/a_612_127# 0
C30247 _190_ VPWR 0.32227f
C30248 _636_/a_843_236# clkbuf_4_13_0_clk/a_27_118# 0
C30249 net71 _637_/a_1583_191# 0.00119f
C30250 net45 _701_/a_1840_334# 0.00798f
C30251 clknet_4_4_0_clk clkbuf_4_4_0_clk/a_27_118# 0.01235f
C30252 clknet_4_5_0_clk clkbuf_4_5_0_clk/a_27_118# 0.05912f
C30253 _081_ rx_data[7] 0
C30254 net28 _266_ 0.0091f
C30255 net148 hold148/a_56_118# 0
C30256 net173 _222_ 0.00553f
C30257 _344_/a_354_412# _312_ 0.00104f
C30258 _344_/a_252_412# _313_ 0
C30259 hold168/a_56_118# net168 0.01347f
C30260 hold163/a_326_118# hold121/a_438_182# 0
C30261 _311_ net162 0
C30262 hold163/a_438_182# hold121/a_326_118# 0
C30263 _154_ net65 0.93566f
C30264 net126 _122_ 0
C30265 net97 baud_inst.counter\[4\] 0
C30266 net29 net95 1.79914f
C30267 net108 _282_ 0.00942f
C30268 _113_ clknet_4_11_0_clk 0.01654f
C30269 _360_/a_71_118# _656_/a_741_93# 0
C30270 net28 _167_ 0
C30271 net35 _244_ 0
C30272 hold62/a_326_118# _084_ 0.0089f
C30273 hold175/a_326_118# FILLER_19_139/a_40_246# 0.00262f
C30274 hold174/a_438_182# _192_ 0
C30275 VPWR FILLER_28_53/a_32_246# 0.09885f
C30276 net41 FILLER_1_212/a_32_246# 0.01772f
C30277 net44 _687_/a_132_114# 0
C30278 _292_ clkbuf_4_8_0_clk/a_27_118# 0
C30279 hold124/a_438_182# _648_/a_2250_412# 0.00887f
C30280 net28 _647_/a_741_93# 0.00113f
C30281 net45 fanout46/a_40_152# 0.01399f
C30282 _660_/a_1583_191# _654_/a_298_337# 0.00142f
C30283 clknet_4_6_0_clk _668_/a_1840_334# 0.00153f
C30284 tx_data[6] _146_ 0
C30285 tx_inst.data_reg\[7\] tx_inst.bit_index\[1\] 0.00558f
C30286 _401_/a_120_432# _142_ 0.00206f
C30287 _401_/a_22_110# _220_ 0.00243f
C30288 _170_ _230_ 0
C30289 net45 net149 0.23153f
C30290 _644_/a_741_93# hold132/a_56_118# 0
C30291 clknet_4_14_0_clk _649_/a_324_432# 0
C30292 _641_/a_132_114# baud_inst.counter\[25\] 0
C30293 output21/a_40_152# hold55/a_438_182# 0.00888f
C30294 _656_/a_550_127# VPWR 0
C30295 net40 _503_/a_165_412# 0
C30296 fanout35/a_40_152# clknet_0_clk 0.00184f
C30297 _646_/a_843_236# _240_ 0.00634f
C30298 hold66/a_326_118# net84 0
C30299 _672_/a_132_114# _033_ 0
C30300 _114_ baud_inst.counter\[23\] 0
C30301 _694_/a_38_114# _107_ 0.02406f
C30302 _633_/a_38_114# _266_ 0
C30303 _633_/a_324_432# net30 0.00109f
C30304 _170_ FILLER_22_175/a_32_246# 0.0011f
C30305 _659_/a_38_114# _211_ 0.00445f
C30306 hold172/a_438_182# _077_ 0.00254f
C30307 hold158/a_438_182# _688_/a_38_114# 0
C30308 _128_ hold72/a_56_118# 0
C30309 net18 _264_ 0.00437f
C30310 FILLER_7_9/a_32_246# net117 0
C30311 _053_ _261_ 0.00203f
C30312 _644_/a_1840_334# _170_ 0
C30313 _379_/a_46_156# _206_ 0
C30314 net153 _182_ 0.03042f
C30315 hold101/a_326_118# _296_ 0.00689f
C30316 _696_/a_741_93# FILLER_17_81/a_32_246# 0.00112f
C30317 _655_/a_843_236# clknet_0_clk 0
C30318 hold124/a_438_182# net124 0.00116f
C30319 hold121/a_438_182# _537_/a_192_429# 0.00962f
C30320 _186_ _683_/a_1489_191# 0.0081f
C30321 _353_/a_350_122# baud_inst.counter\[11\] 0
C30322 _410_/a_155_412# net49 0.00123f
C30323 net87 _308_ 0
C30324 _110_ _686_/a_843_236# 0
C30325 _130_ net24 0.00537f
C30326 _656_/a_741_93# input9/a_40_152# 0
C30327 net136 FILLER_5_32/a_40_246# 0.0274f
C30328 net48 _636_/a_132_114# 0
C30329 _341_/a_382_118# net41 0
C30330 clknet_4_7_0_clk _639_/a_324_432# 0
C30331 net177 _294_ 0
C30332 _695_/a_2002_114# VPWR 0
C30333 net73 hold73/a_438_182# 0.02725f
C30334 _280_ clknet_0_clk 0.15606f
C30335 _286_ FILLER_7_40/a_32_246# 0
C30336 baud_inst.counter\[14\] _687_/a_298_337# 0
C30337 baud_inst.counter\[15\] _687_/a_38_114# 0.00673f
C30338 baud_inst.counter\[19\] _108_ 0
C30339 baud_inst.counter\[7\] VPWR 0.23422f
C30340 _660_/a_298_337# clknet_4_5_0_clk 0
C30341 hold179/a_56_118# net55 0.00187f
C30342 _662_/a_1583_191# _662_/a_2250_412# 0
C30343 _415_/a_170_412# _224_ 0
C30344 _160_ net65 0.30889f
C30345 _057_ _647_/a_843_236# 0
C30346 _207_ _390_/a_285_118# 0
C30347 net44 _540_/a_139_160# 0
C30348 _058_ _157_ 0.02588f
C30349 _265_ rx_inst.state\[1\] 0.00133f
C30350 _064_ hold137/a_438_182# 0.00577f
C30351 _429_/a_142_412# _158_ 0.00289f
C30352 hold65/a_326_118# hold72/a_326_118# 0
C30353 hold97/a_56_118# baud_inst.counter\[10\] 0.08201f
C30354 _692_/a_324_432# net164 0.0048f
C30355 _692_/a_38_114# clknet_4_10_0_clk 0.00322f
C30356 _315_ clknet_4_10_0_clk 0.00309f
C30357 _180_ _027_ 0.00112f
C30358 _680_/a_1785_429# net135 0
C30359 FILLER_15_185/a_32_246# hold119/a_56_118# 0
C30360 _246_ fanout28/a_40_152# 0
C30361 net74 clknet_4_13_0_clk 0.04877f
C30362 _082_ _132_ 0.00263f
C30363 net44 clknet_4_12_0_clk 0.02181f
C30364 rx_inst.data_reg\[2\] _056_ 0
C30365 _255_ _242_ 0.02622f
C30366 net35 clknet_4_14_0_clk 0.24992f
C30367 hold111/a_56_118# net64 0.00719f
C30368 baud_inst.counter\[30\] clknet_0_clk 0
C30369 _655_/a_298_337# net181 0
C30370 _339_/a_589_385# clknet_4_4_0_clk 0.00309f
C30371 clknet_4_3_0_clk hold93/a_438_182# 0
C30372 baud_inst.counter\[26\] net46 0.01931f
C30373 _689_/a_38_114# _101_ 0.04548f
C30374 _513_/a_192_429# _189_ 0
C30375 _643_/a_741_93# net65 0
C30376 _179_ hold114/a_438_182# 0
C30377 clknet_4_1_0_clk hold92/a_438_182# 0
C30378 _680_/a_324_432# _287_ 0
C30379 _680_/a_741_93# net135 0
C30380 hold157/a_56_118# net40 0.00131f
C30381 FILLER_27_194/a_40_246# _272_ 0.00103f
C30382 _114_ _694_/a_1840_334# 0
C30383 hold70/a_326_118# rx_inst.data_reg\[6\] 0.00147f
C30384 _635_/a_843_236# _632_/a_843_236# 0
C30385 net100 _310_ 0
C30386 net3 _380_/a_285_118# 0.00128f
C30387 net10 _145_ 0
C30388 clk _658_/a_38_114# 0
C30389 FILLER_10_147/a_32_246# _667_/a_324_432# 0
C30390 clkbuf_4_11_0_clk/a_27_118# _051_ 0
C30391 net94 net108 0
C30392 _678_/a_132_114# net93 0
C30393 VPWR _209_ 0.36884f
C30394 hold153/a_438_182# _351_/a_46_156# 0.00218f
C30395 _685_/a_38_114# hold91/a_438_182# 0
C30396 _685_/a_324_432# hold91/a_326_118# 0
C30397 net94 net181 0
C30398 _205_ clknet_4_9_0_clk 0
C30399 net2 _639_/a_2002_114# 0
C30400 _132_ clknet_0_clk 0.0116f
C30401 _280_ _182_ 0.15126f
C30402 net89 _296_ 0.06642f
C30403 hold121/a_56_118# _693_/a_1840_334# 0
C30404 hold121/a_326_118# _693_/a_1583_191# 0
C30405 net121 _693_/a_324_432# 0.03709f
C30406 _486_/a_358_436# net28 0.00141f
C30407 _636_/a_1583_191# _157_ 0
C30408 _312_ _308_ 0.01687f
C30409 _244_ _254_ 0.00143f
C30410 clknet_4_12_0_clk FILLER_18_158/a_40_246# 0
C30411 hold66/a_56_118# _635_/a_843_236# 0
C30412 hold66/a_326_118# _635_/a_741_93# 0.00222f
C30413 _191_ clknet_0_clk 0.14005f
C30414 hold166/a_326_118# net51 0.00633f
C30415 hold181/a_56_118# VPWR 0.05925f
C30416 _206_ _392_/a_559_412# 0.0046f
C30417 _675_/a_38_114# net38 0.06098f
C30418 _680_/a_2250_412# hold135/a_56_118# 0.00161f
C30419 _680_/a_843_236# baud_inst.counter\[8\] 0
C30420 _184_ _183_ 0.12668f
C30421 _261_ _451_/a_155_412# 0.00334f
C30422 _046_ net138 0
C30423 FILLER_2_46/a_40_246# net38 0
C30424 hold68/a_438_182# net133 0.00218f
C30425 net13 _158_ 0.14799f
C30426 _230_ hold175/a_326_118# 0
C30427 _224_ _247_ 0
C30428 VPWR _633_/a_1840_334# 0.00144f
C30429 _232_ FILLER_20_177/a_32_246# 0.00132f
C30430 _707_/a_843_236# _704_/a_1489_191# 0
C30431 _707_/a_1489_191# _704_/a_843_236# 0
C30432 _230_ _237_ 0.6503f
C30433 _385_/a_268_412# _211_ 0
C30434 _075_ rx_inst.state\[4\] 0
C30435 FILLER_11_144/a_32_246# _667_/a_324_432# 0
C30436 _050_ hold73/a_56_118# 0.00147f
C30437 VPWR _548_/a_76_160# 0.04473f
C30438 _206_ _192_ 0
C30439 output15/a_40_152# _156_ 0.08569f
C30440 _495_/a_154_118# _282_ 0.00182f
C30441 baud_inst.counter\[14\] _686_/a_1489_191# 0.01091f
C30442 FILLER_0_161/a_40_246# VPWR 0.1236f
C30443 _059_ _472_/a_22_110# 0
C30444 _206_ tx_inst.data_reg\[3\] 0.00103f
C30445 _390_/a_59_156# _213_ 0
C30446 net95 hold95/a_438_182# 0
C30447 net37 clknet_4_6_0_clk 0
C30448 _103_ baud_inst.counter\[17\] 0.00568f
C30449 _099_ net91 0.20104f
C30450 FILLER_17_201/a_32_246# _240_ 0
C30451 _069_ VPWR 0.33079f
C30452 hold97/a_438_182# _010_ 0.00736f
C30453 _644_/a_1785_429# clknet_4_14_0_clk 0.00143f
C30454 _039_ baud_inst.counter\[9\] 0.02273f
C30455 _143_ _339_/a_1109_431# 0
C30456 _080_ _676_/a_2250_412# 0
C30457 hold134/a_438_182# _115_ 0
C30458 FILLER_1_28/a_40_246# net38 0.00198f
C30459 FILLER_10_78/a_32_246# _184_ 0.00671f
C30460 _310_ _296_ 0
C30461 _159_ _472_/a_22_110# 0.02678f
C30462 net30 clkbuf_4_15_0_clk/a_27_118# 0
C30463 tx_inst.data_reg\[1\] net137 0
C30464 hold184/a_438_182# hold174/a_56_118# 0.00113f
C30465 net42 _667_/a_324_432# 0.00129f
C30466 hold156/a_326_118# baud_inst.counter\[16\] 0.0026f
C30467 _081_ _671_/a_1840_334# 0
C30468 _163_ _096_ 0
C30469 net49 hold180/a_56_118# 0.00579f
C30470 _264_ _649_/a_843_236# 0.02426f
C30471 FILLER_10_147/a_32_246# _142_ 0
C30472 _673_/a_843_236# _086_ 0.01585f
C30473 _009_ _681_/a_1583_191# 0
C30474 net42 FILLER_10_147/a_32_246# 0.01908f
C30475 _183_ FILLER_9_72/a_32_246# 0.00159f
C30476 clk _656_/a_741_93# 0.01683f
C30477 hold69/a_438_182# net18 0.01808f
C30478 FILLER_20_65/a_32_246# _313_ 0.0118f
C30479 hold178/a_326_118# _290_ 0.00428f
C30480 baud_inst.counter\[16\] FILLER_15_0/a_40_246# 0
C30481 _678_/a_612_127# net40 0.00315f
C30482 _180_ _186_ 0.01684f
C30483 hold154/a_326_118# net128 0
C30484 net27 _651_/a_1785_429# 0.00328f
C30485 _126_ rx_inst.data_reg\[4\] 0
C30486 _645_/a_2250_412# clknet_4_14_0_clk 0.00299f
C30487 baud_inst.counter\[1\] _287_ 0.00528f
C30488 net79 _674_/a_2250_412# 0
C30489 _191_ _182_ 0.01662f
C30490 net100 _698_/a_1840_334# 0
C30491 FILLER_3_207/a_40_246# net43 0.02139f
C30492 net2 hold180/a_438_182# 0.00898f
C30493 FILLER_19_77/a_32_246# clknet_4_8_0_clk 0
C30494 net48 hold112/a_56_118# 0.00191f
C30495 net174 net26 0.29702f
C30496 _682_/a_1583_191# baud_inst.counter\[9\] 0
C30497 _358_/a_72_436# net130 0
C30498 _422_/a_146_122# VPWR 0
C30499 _436_/a_244_412# _136_ 0
C30500 _436_/a_244_140# _249_ 0
C30501 clknet_4_6_0_clk _650_/a_298_337# 0
C30502 net163 FILLER_17_22/a_40_246# 0
C30503 _207_ VPWR 0.06972f
C30504 tx_inst.state\[1\] hold50/a_56_118# 0.02843f
C30505 clknet_4_7_0_clk hold50/a_326_118# 0.00316f
C30506 hold182/a_438_182# _670_/a_324_432# 0
C30507 _686_/a_1583_191# clknet_4_9_0_clk 0.00432f
C30508 _444_/a_142_412# _159_ 0.00257f
C30509 hold65/a_438_182# _128_ 0.00101f
C30510 _194_ _192_ 0
C30511 _077_ _368_/a_257_140# 0.00384f
C30512 _097_ net29 0
C30513 _527_/a_192_429# net101 0.01797f
C30514 _059_ _648_/a_741_93# 0.00106f
C30515 net111 _043_ 0.01893f
C30516 net79 _673_/a_324_432# 0.02633f
C30517 VPWR _666_/a_298_337# 0.01791f
C30518 net163 _299_ 0.00101f
C30519 _696_/a_38_114# net141 0
C30520 net13 _633_/a_1489_191# 0.00319f
C30521 clknet_4_14_0_clk _254_ 0.02212f
C30522 _286_ FILLER_7_82/a_32_246# 0
C30523 _246_ _432_/a_146_122# 0.00209f
C30524 _109_ net46 0.06488f
C30525 baud_inst.counter\[26\] _313_ 0.00182f
C30526 _177_ _312_ 0.22777f
C30527 _360_/a_886_118# _656_/a_843_236# 0
C30528 hold160/a_56_118# _163_ 0
C30529 clknet_0_clk _451_/a_257_140# 0
C30530 _431_/a_81_118# FILLER_16_166/a_32_246# 0
C30531 FILLER_11_144/a_32_246# _142_ 0
C30532 net44 _687_/a_1489_191# 0.00671f
C30533 hold57/a_326_118# _216_ 0
C30534 _493_/a_139_160# net29 0.00195f
C30535 net42 FILLER_11_144/a_32_246# 0.00374f
C30536 net20 VPWR 0.11173f
C30537 hold151/a_56_118# net48 0
C30538 _170_ hold127/a_438_182# 0.00432f
C30539 _380_/a_496_118# _208_ 0
C30540 _206_ _706_/a_324_432# 0
C30541 FILLER_15_67/a_40_246# _189_ 0
C30542 _440_/a_244_412# _252_ 0
C30543 _118_ tx_start 0.00635f
C30544 hold106/a_438_182# clknet_4_10_0_clk 0.00163f
C30545 hold112/a_326_118# _259_ 0
C30546 _064_ _220_ 0
C30547 net42 _142_ 0.10989f
C30548 output16/a_40_152# _650_/a_1583_191# 0
C30549 clknet_4_4_0_clk VPWR 0.97955f
C30550 _646_/a_612_127# _240_ 0.00115f
C30551 _672_/a_550_127# net61 0
C30552 _074_ _706_/a_38_114# 0.00124f
C30553 net37 net29 0.63347f
C30554 hold154/a_326_118# _090_ 0.00174f
C30555 hold154/a_438_182# net39 0
C30556 _633_/a_1840_334# _266_ 0
C30557 _633_/a_2250_412# net30 0.00722f
C30558 clknet_4_12_0_clk _697_/a_2250_412# 0.00142f
C30559 _390_/a_382_118# net8 0
C30560 _113_ _550_/a_209_168# 0.00151f
C30561 _056_ _253_ 0
C30562 hold150/a_56_118# _158_ 0
C30563 _072_ net155 0.05775f
C30564 clkbuf_4_11_0_clk/a_27_118# _698_/a_324_432# 0
C30565 _655_/a_612_127# clknet_0_clk 0
C30566 _091_ FILLER_5_84/a_40_246# 0.00396f
C30567 _374_/a_244_140# _205_ 0
C30568 clknet_0_clk hold91/a_438_182# 0.00186f
C30569 net31 _486_/a_115_308# 0
C30570 hold121/a_326_118# _023_ 0
C30571 hold121/a_438_182# _305_ 0.00342f
C30572 net121 _537_/a_341_118# 0
C30573 net124 _648_/a_843_236# 0.00141f
C30574 _155_ _648_/a_741_93# 0.00436f
C30575 _186_ baud_inst.counter\[11\] 0.11592f
C30576 net156 _684_/a_324_432# 0.05868f
C30577 _229_ net49 0.03309f
C30578 hold147/a_326_118# _694_/a_324_432# 0
C30579 _660_/a_324_432# _214_ 0.01546f
C30580 _660_/a_843_236# net54 0
C30581 net79 net29 0
C30582 net21 _478_/a_27_156# 0
C30583 _671_/a_1583_191# _671_/a_2250_412# 0
C30584 net48 _636_/a_1489_191# 0
C30585 _307_ _541_/a_209_168# 0
C30586 hold120/a_326_118# clknet_4_10_0_clk 0
C30587 net4 tx_data[7] 0.02867f
C30588 _078_ net43 0
C30589 baud_inst.counter\[15\] _687_/a_1840_334# 0
C30590 _192_ _202_ 0
C30591 net27 _203_ 0.01042f
C30592 _660_/a_1583_191# clknet_4_5_0_clk 0.02865f
C30593 _089_ _676_/a_741_93# 0
C30594 _686_/a_1583_191# _686_/a_2250_412# 0
C30595 hold152/a_326_118# net152 0
C30596 hold56/a_56_118# _166_ 0.00137f
C30597 hold152/a_56_118# baud_inst.counter\[4\] 0.00723f
C30598 clknet_4_6_0_clk _667_/a_1489_191# 0.00169f
C30599 clknet_4_11_0_clk _700_/a_324_432# 0.01696f
C30600 net2 _705_/a_1840_334# 0
C30601 _670_/a_843_236# net29 0
C30602 _692_/a_1840_334# clknet_4_10_0_clk 0
C30603 hold172/a_438_182# net43 0.04939f
C30604 clknet_4_3_0_clk FILLER_9_72/a_32_246# 0
C30605 net87 VPWR 0.27048f
C30606 _280_ FILLER_10_110/a_40_246# 0
C30607 _673_/a_298_337# clknet_4_1_0_clk 0.00424f
C30608 tx _705_/a_1840_334# 0.00149f
C30609 net37 hold119/a_56_118# 0.01122f
C30610 rx_data[2] VPWR 0.01362f
C30611 net59 net46 0
C30612 _163_ _190_ 0
C30613 _689_/a_1840_334# _101_ 0
C30614 _643_/a_2250_412# _122_ 0
C30615 net156 hold103/a_438_182# 0
C30616 FILLER_18_169/a_40_246# _223_ 0.00205f
C30617 _170_ _424_/a_550_140# 0
C30618 net32 _424_/a_244_140# 0
C30619 net97 _688_/a_2250_412# 0
C30620 _680_/a_2250_412# _287_ 0
C30621 hold137/a_56_118# net41 0.00317f
C30622 clknet_4_3_0_clk _653_/a_298_337# 0
C30623 _635_/a_1840_334# _632_/a_1583_191# 0
C30624 _635_/a_1583_191# _632_/a_1840_334# 0
C30625 net3 _150_ 0.00872f
C30626 _090_ hold92/a_56_118# 0.00788f
C30627 _440_/a_142_412# _236_ 0
C30628 clk _658_/a_1840_334# 0.04944f
C30629 net116 net29 0
C30630 net125 _633_/a_298_337# 0
C30631 _685_/a_843_236# net91 0
C30632 _264_ hold71/a_326_118# 0.00434f
C30633 net49 _701_/a_550_127# 0
C30634 _654_/a_324_432# FILLER_2_208/a_40_246# 0
C30635 baud_inst.counter\[5\] hold93/a_438_182# 0
C30636 _637_/a_843_236# VPWR 0.0019f
C30637 net31 _428_/a_150_412# 0.00221f
C30638 tx_data[2] net5 0.04355f
C30639 _075_ net168 0
C30640 _292_ _684_/a_741_93# 0.02401f
C30641 hold126/a_326_118# net65 0
C30642 hold178/a_326_118# net108 0
C30643 net48 _136_ 0.30179f
C30644 hold172/a_56_118# net21 0.06046f
C30645 FILLER_11_32/a_32_246# _688_/a_1489_191# 0
C30646 _643_/a_1840_334# net111 0
C30647 _675_/a_1583_191# _085_ 0.00616f
C30648 _675_/a_1840_334# net38 0.00544f
C30649 _706_/a_38_114# _201_ 0
C30650 _689_/a_843_236# net161 0
C30651 _689_/a_2250_412# _688_/a_1489_191# 0
C30652 baud_inst.counter\[17\] _688_/a_324_432# 0.00658f
C30653 FILLER_14_202/a_40_246# net30 0
C30654 net179 _371_/a_170_412# 0
C30655 _556_/a_435_412# _313_ 0
C30656 _118_ tx_busy 0
C30657 _262_ net24 0.0996f
C30658 _092_ _679_/a_298_337# 0.01026f
C30659 _193_ net34 0.16511f
C30660 clknet_4_8_0_clk _687_/a_324_432# 0.01721f
C30661 net90 net29 0.161f
C30662 net41 _380_/a_382_118# 0.00335f
C30663 _468_/a_22_110# _156_ 0.00542f
C30664 _173_ hold184/a_326_118# 0
C30665 _194_ hold184/a_56_118# 0.00128f
C30666 _191_ FILLER_10_110/a_40_246# 0
C30667 _650_/a_843_236# _668_/a_741_93# 0
C30668 VPWR _312_ 0.22846f
C30669 net84 _635_/a_1840_334# 0
C30670 net62 net30 0
C30671 _168_ _000_ 0.11997f
C30672 _528_/a_81_118# _296_ 0.05845f
C30673 FILLER_28_176/a_32_246# net150 0.00203f
C30674 net49 FILLER_29_145/a_40_246# 0.00179f
C30675 net40 _682_/a_38_114# 0.00581f
C30676 _265_ _639_/a_681_505# 0
C30677 _129_ _639_/a_843_236# 0.00247f
C30678 hold99/a_326_118# _697_/a_324_432# 0
C30679 hold99/a_56_118# _697_/a_741_93# 0
C30680 hold54/a_326_118# _042_ 0
C30681 _223_ VPWR 0.4541f
C30682 _055_ clknet_4_14_0_clk 0.03865f
C30683 clknet_4_3_0_clk _652_/a_843_236# 0.0201f
C30684 _674_/a_2250_412# _672_/a_741_93# 0
C30685 _646_/a_741_93# _058_ 0
C30686 net42 _667_/a_2250_412# 0
C30687 net44 _691_/a_298_337# 0
C30688 baud_inst.counter\[30\] _314_ 0
C30689 _200_ _665_/a_843_236# 0.00182f
C30690 net44 baud_inst.counter\[19\] 0.25215f
C30691 _673_/a_612_127# _086_ 0.00843f
C30692 hold154/a_56_118# _677_/a_38_114# 0
C30693 net153 net152 0
C30694 clk _656_/a_1785_429# 0
C30695 net169 net172 0
C30696 _166_ _200_ 0.11842f
C30697 _230_ hold176/a_438_182# 0
C30698 _646_/a_550_127# clknet_0_clk 0
C30699 _376_/a_76_160# _376_/a_272_160# -0
C30700 _414_/a_165_412# _224_ 0
C30701 _550_/a_474_130# _313_ 0
C30702 net93 net40 0.09331f
C30703 _668_/a_324_432# rx_inst.state\[1\] 0
C30704 clknet_0_clk _435_/a_411_436# 0.00127f
C30705 net122 _667_/a_132_114# 0
C30706 net37 _667_/a_681_505# 0
C30707 _707_/a_741_93# net51 0.00263f
C30708 net71 hold72/a_326_118# 0.00969f
C30709 _127_ _637_/a_843_236# 0
C30710 _552_/a_155_412# VPWR 0.04041f
C30711 net148 clknet_4_10_0_clk 0.02662f
C30712 _059_ _159_ 0
C30713 FILLER_25_7/a_40_246# _693_/a_38_114# 0
C30714 _240_ VPWR 0.48796f
C30715 _239_ _223_ 0.00201f
C30716 _102_ _299_ 0
C30717 _526_/a_350_122# net101 0
C30718 _250_ _136_ 0.06449f
C30719 output12/a_40_152# hold69/a_56_118# 0
C30720 net54 _120_ 0.03119f
C30721 hold174/a_438_182# net168 0
C30722 net156 net49 0
C30723 VPWR _685_/a_324_432# 0
C30724 _686_/a_2002_114# clknet_4_9_0_clk 0
C30725 _444_/a_550_140# _134_ 0.00105f
C30726 _206_ _388_/a_285_118# 0
C30727 _678_/a_298_337# hold94/a_326_118# 0
C30728 _339_/a_886_118# clknet_0_clk 0.02071f
C30729 _195_ net27 0.57404f
C30730 hold152/a_326_118# hold152/a_438_182# 0
C30731 hold63/a_326_118# VPWR 0.00102f
C30732 net79 _673_/a_2250_412# 0
C30733 fanout38/a_40_152# VPWR 0.02824f
C30734 VPWR _666_/a_1583_191# 0.00768f
C30735 _191_ net43 0
C30736 VPWR _689_/a_324_432# 0.01004f
C30737 hold141/a_56_118# hold113/a_438_182# 0
C30738 hold141/a_438_182# hold113/a_56_118# 0
C30739 net144 _223_ 0.00204f
C30740 _696_/a_1840_334# net141 0
C30741 _696_/a_1583_191# _310_ 0
C30742 FILLER_25_7/a_40_246# FILLER_25_9/a_32_246# 0.0524f
C30743 net59 _313_ 0
C30744 _178_ hold114/a_438_182# 0
C30745 FILLER_3_207/a_40_246# _664_/a_2250_412# 0
C30746 net37 fanout42/a_40_152# 0
C30747 net44 hold99/a_326_118# 0.00241f
C30748 _360_/a_71_118# _067_ 0.00321f
C30749 tx_inst.bit_index\[1\] _656_/a_324_432# 0
C30750 _360_/a_1377_160# _656_/a_2250_412# 0
C30751 _175_ _007_ 0
C30752 hold55/a_56_118# _665_/a_1583_191# 0
C30753 net39 net117 0
C30754 _646_/a_298_337# net48 0.00509f
C30755 _637_/a_843_236# _266_ 0
C30756 net145 tx_inst.data_reg\[3\] 0.15793f
C30757 _304_ _106_ 0.00136f
C30758 _658_/a_843_236# net171 0
C30759 clknet_4_5_0_clk _654_/a_324_432# 0.00572f
C30760 _658_/a_324_432# _148_ 0.00373f
C30761 _660_/a_38_114# tx_inst.data_reg\[0\] 0.00199f
C30762 _660_/a_843_236# _065_ 0
C30763 _660_/a_741_93# _144_ 0.00157f
C30764 net51 _671_/a_843_236# 0
C30765 _292_ _511_/a_354_412# 0
C30766 net31 _423_/a_279_412# 0.00209f
C30767 _345_/a_252_412# hold120/a_56_118# 0
C30768 net55 input9/a_40_152# 0.0079f
C30769 net34 net174 0
C30770 tx_inst.state\[1\] _705_/a_324_432# 0.00442f
C30771 clknet_4_7_0_clk _705_/a_741_93# 0.03979f
C30772 _230_ hold180/a_326_118# 0
C30773 net163 _105_ 0.01747f
C30774 _055_ hold132/a_56_118# 0.00788f
C30775 net144 _240_ 0
C30776 hold164/a_438_182# net164 0
C30777 net49 _180_ 0.00303f
C30778 clknet_4_0_0_clk net61 0
C30779 _059_ _155_ 0.6893f
C30780 _074_ _706_/a_1840_334# 0
C30781 _699_/a_1583_191# _547_/a_81_118# 0
C30782 hold99/a_56_118# clknet_0_clk 0.00734f
C30783 _690_/a_741_93# VPWR 0.02081f
C30784 net136 _674_/a_38_114# 0
C30785 _029_ _694_/a_1583_191# 0
C30786 net39 hold109/a_56_118# 0.00612f
C30787 _132_ _110_ 0
C30788 _642_/a_681_505# _132_ 0
C30789 _642_/a_132_114# _053_ 0
C30790 _642_/a_741_93# rx_inst.bit_index\[2\] 0
C30791 _155_ _159_ 0
C30792 _642_/a_843_236# clknet_4_12_0_clk 0.0324f
C30793 _120_ _368_/a_155_412# 0
C30794 baud_inst.counter\[28\] _700_/a_1489_191# 0.00259f
C30795 FILLER_23_204/a_40_246# clknet_4_15_0_clk 0
C30796 _282_ _162_ 0
C30797 net152 _280_ 0.05256f
C30798 net156 _525_/a_268_412# 0
C30799 clkbuf_4_11_0_clk/a_27_118# _698_/a_2250_412# 0
C30800 input3/a_40_152# FILLER_0_154/a_40_246# 0.01f
C30801 _145_ clknet_0_clk 0
C30802 hold152/a_326_118# FILLER_8_116/a_40_246# 0
C30803 hold139/a_326_118# net25 0.00208f
C30804 hold69/a_438_182# hold71/a_326_118# 0
C30805 hold69/a_326_118# hold71/a_438_182# 0
C30806 net85 _635_/a_38_114# 0.02826f
C30807 hold178/a_56_118# clkbuf_4_2_0_clk/a_27_118# 0
C30808 net124 _648_/a_612_127# 0
C30809 _181_ hold60/a_438_182# 0.01216f
C30810 _645_/a_38_114# FILLER_29_145/a_40_246# 0
C30811 _285_ baud_inst.counter\[4\] 0
C30812 _283_ _282_ 0.0423f
C30813 _067_ input9/a_40_152# 0
C30814 _656_/a_1489_191# net9 0.00448f
C30815 _660_/a_612_127# net54 0.01092f
C30816 tx_inst.bit_index\[2\] net41 0
C30817 _697_/a_843_236# VPWR 0.00123f
C30818 hold111/a_326_118# _638_/a_38_114# 0
C30819 _223_ _167_ 0.12312f
C30820 hold56/a_56_118# _651_/a_1583_191# 0.00294f
C30821 baud_inst.counter\[21\] _693_/a_324_432# 0
C30822 net122 net37 0.14073f
C30823 _021_ hold149/a_56_118# 0.03614f
C30824 VPWR _261_ 0.02519f
C30825 net31 _442_/a_146_122# 0
C30826 _088_ FILLER_3_21/a_40_246# 0.00365f
C30827 _498_/a_165_412# _280_ 0
C30828 _643_/a_38_114# clknet_4_15_0_clk 0.00113f
C30829 _660_/a_2002_114# clknet_4_5_0_clk 0
C30830 _225_ _223_ 0
C30831 _184_ baud_inst.counter\[5\] 0
C30832 FILLER_13_137/a_32_246# _667_/a_38_114# 0
C30833 _057_ net139 0
C30834 _486_/a_115_308# net62 0.05143f
C30835 _646_/a_38_114# _157_ 0
C30836 hold58/a_326_118# _703_/a_741_93# 0.0011f
C30837 hold58/a_438_182# _703_/a_324_432# 0
C30838 hold58/a_56_118# _703_/a_843_236# 0.00232f
C30839 _134_ FILLER_24_156/a_32_246# 0
C30840 _234_ _224_ 0.07419f
C30841 clknet_4_11_0_clk _700_/a_2250_412# 0.04101f
C30842 _178_ _551_/a_76_160# 0
C30843 _240_ _266_ 0.25782f
C30844 FILLER_9_70/a_40_246# _683_/a_1583_191# 0
C30845 hold102/a_438_182# baud_inst.counter\[16\] 0.00261f
C30846 fanout39/a_40_152# _689_/a_324_432# 0
C30847 hold175/a_56_118# net25 0.00104f
C30848 _293_ _162_ 0.01148f
C30849 _240_ _167_ 0.526f
C30850 _344_/a_150_412# clknet_4_8_0_clk 0
C30851 _673_/a_1583_191# clknet_4_1_0_clk 0
C30852 tx_data[7] net40 0
C30853 FILLER_4_102/a_32_246# net6 0.01869f
C30854 clkbuf_0_clk/a_116_82# _669_/a_1489_191# 0
C30855 _657_/a_324_432# net41 0.04299f
C30856 _691_/a_298_337# _302_ 0
C30857 hold77/a_56_118# net47 0
C30858 hold142/a_56_118# net99 0
C30859 _302_ baud_inst.counter\[19\] 0.18682f
C30860 _240_ _647_/a_741_93# 0.00572f
C30861 _268_ _128_ 0.0172f
C30862 net42 _670_/a_1583_191# 0
C30863 _691_/a_843_236# _690_/a_843_236# 0
C30864 _178_ _302_ 0
C30865 hold143/a_438_182# net143 0.01304f
C30866 _667_/a_298_337# net63 0.00796f
C30867 hold150/a_438_182# net78 0
C30868 baud_inst.counter\[21\] _535_/a_248_122# 0
C30869 rx_data[3] rx_inst.data_reg\[4\] 0
C30870 net15 net138 0.01298f
C30871 _462_/a_22_110# _273_ 0.00106f
C30872 hold140/a_326_118# _698_/a_741_93# 0
C30873 baud_inst.counter\[27\] _546_/a_192_429# 0.02874f
C30874 hold140/a_438_182# _698_/a_324_432# 0
C30875 hold88/a_438_182# net29 0
C30876 _158_ _236_ 0
C30877 FILLER_26_35/a_32_246# net45 0
C30878 net5 _210_ 0
C30879 baud_inst.counter\[14\] _520_/a_257_140# 0.00482f
C30880 _678_/a_843_236# _090_ 0
C30881 _191_ net152 0
C30882 _403_/a_22_110# net56 0.00169f
C30883 FILLER_26_141/a_40_246# _252_ 0
C30884 _178_ clkbuf_4_10_0_clk/a_27_118# 0
C30885 _657_/a_298_337# _068_ 0.03269f
C30886 _286_ hold115/a_326_118# 0
C30887 net37 _670_/a_741_93# 0
C30888 hold102/a_56_118# net49 0
C30889 net44 FILLER_17_24/a_32_246# 0
C30890 _306_ _296_ 0.01273f
C30891 FILLER_17_94/a_40_246# FILLER_17_96/a_32_246# 0.0524f
C30892 net26 _668_/a_298_337# 0
C30893 _126_ FILLER_17_199/a_40_246# 0
C30894 _292_ _684_/a_1785_429# 0
C30895 net44 FILLER_17_96/a_32_246# 0.00176f
C30896 _697_/a_324_432# net162 0
C30897 _638_/a_1840_334# clknet_4_15_0_clk 0
C30898 _694_/a_38_114# _693_/a_1583_191# 0
C30899 _694_/a_298_337# _693_/a_1840_334# 0
C30900 fanout35/a_40_152# _249_ 0
C30901 _689_/a_612_127# net161 0
C30902 baud_inst.counter\[17\] _688_/a_2250_412# 0.00581f
C30903 fanout40/a_40_152# _690_/a_1840_334# 0
C30904 rx_data[4] _639_/a_741_93# 0
C30905 _448_/a_550_140# _223_ 0
C30906 _206_ net168 1.06405f
C30907 net29 _682_/a_1489_191# 0
C30908 _118_ _704_/a_741_93# 0
C30909 _032_ _313_ 0.00306f
C30910 _043_ clknet_4_15_0_clk 0
C30911 _143_ _653_/a_38_114# 0.02227f
C30912 rx_inst.bit_index\[1\] clknet_4_14_0_clk 0
C30913 hold157/a_326_118# _015_ 0
C30914 hold157/a_438_182# _296_ 0.00753f
C30915 hold103/a_56_118# _108_ 0
C30916 net47 _633_/a_741_93# 0.00411f
C30917 clk net55 0.4205f
C30918 _234_ _235_ 0.00663f
C30919 _092_ _679_/a_1583_191# 0
C30920 rx net80 0.02455f
C30921 _677_/a_38_114# FILLER_8_92/a_32_246# 0
C30922 clknet_4_8_0_clk _687_/a_2250_412# 0.04975f
C30923 _062_ _667_/a_1583_191# 0
C30924 net15 _047_ 0.00222f
C30925 net27 FILLER_6_191/a_32_246# 0.00288f
C30926 _641_/a_324_432# _262_ 0.00215f
C30927 hold79/a_56_118# _672_/a_1583_191# 0.0024f
C30928 _657_/a_681_505# _070_ 0
C30929 net177 _190_ 0
C30930 _650_/a_1583_191# _668_/a_1583_191# 0
C30931 hold68/a_56_118# net49 0
C30932 net36 _425_/a_268_412# 0
C30933 hold172/a_56_118# clknet_4_5_0_clk 0.00287f
C30934 hold97/a_438_182# _509_/a_155_412# 0
C30935 net26 clknet_4_6_0_clk 1.0586f
C30936 FILLER_24_218/a_40_246# _264_ 0
C30937 hold113/a_56_118# _546_/a_341_118# 0
C30938 net94 _283_ 0.03025f
C30939 _354_/a_170_412# VPWR 0
C30940 clknet_0_clk hold93/a_438_182# 0
C30941 _651_/a_1840_334# net168 0
C30942 net173 _400_/a_192_429# 0
C30943 clknet_4_3_0_clk _652_/a_612_127# 0.00762f
C30944 rx_data[7] hold118/a_438_182# 0.00197f
C30945 _674_/a_298_337# clknet_4_0_0_clk 0.03509f
C30946 _527_/a_341_118# _296_ 0
C30947 net120 net49 0.03181f
C30948 _632_/a_298_337# _264_ 0.018f
C30949 _222_ _402_/a_154_118# 0.00124f
C30950 hold152/a_438_182# _280_ 0
C30951 net44 _691_/a_1583_191# 0.01292f
C30952 _384_/a_559_412# _209_ 0
C30953 _654_/a_1583_191# _654_/a_2250_412# 0
C30954 _087_ _504_/a_209_168# 0
C30955 _200_ _665_/a_612_127# 0.00757f
C30956 clknet_4_12_0_clk hold143/a_56_118# 0
C30957 clknet_4_1_0_clk net40 0.10263f
C30958 net44 net162 0
C30959 _135_ net151 0.00338f
C30960 _680_/a_298_337# hold117/a_56_118# 0
C30961 _144_ _664_/a_324_432# 0
C30962 _194_ net168 0.00162f
C30963 _225_ _261_ 0
C30964 VPWR _348_/a_248_122# 0
C30965 clk _067_ 0.4555f
C30966 clknet_4_12_0_clk FILLER_19_118/a_32_246# 0.00211f
C30967 rx_inst.state\[2\] _257_ 0
C30968 hold173/a_438_182# clkbuf_4_4_0_clk/a_27_118# 0
C30969 hold128/a_438_182# _034_ 0
C30970 _233_ _224_ 0.0559f
C30971 net80 hold73/a_438_182# 0.00111f
C30972 _673_/a_1840_334# _672_/a_843_236# 0
C30973 _673_/a_2250_412# _672_/a_741_93# 0
C30974 _673_/a_843_236# _672_/a_1840_334# 0
C30975 _673_/a_741_93# _672_/a_2250_412# 0
C30976 VPWR _386_/a_382_118# 0.00318f
C30977 _668_/a_2250_412# rx_inst.state\[1\] 0.00531f
C30978 _100_ _014_ 0
C30979 _664_/a_132_114# _005_ 0
C30980 _664_/a_843_236# tx_inst.state\[2\] 0.00976f
C30981 net122 _667_/a_1489_191# 0.01081f
C30982 net37 _667_/a_550_127# 0
C30983 net87 _163_ 0.0025f
C30984 _692_/a_38_114# VPWR 0.00327f
C30985 _315_ VPWR 0.08915f
C30986 tx_data[2] _210_ 0.00867f
C30987 _678_/a_38_114# baud_inst.counter\[6\] 0.01351f
C30988 _518_/a_45_160# _684_/a_324_432# 0
C30989 _046_ hold111/a_326_118# 0.00397f
C30990 net101 _300_ 0.18366f
C30991 _346_/a_354_412# baud_inst.counter\[30\] 0.0025f
C30992 _663_/a_741_93# _666_/a_324_432# 0.00262f
C30993 _663_/a_324_432# _666_/a_741_93# 0
C30994 net153 _035_ 0.51179f
C30995 net2 _669_/a_1785_429# 0
C30996 _179_ _347_/a_146_122# 0.00177f
C30997 _704_/a_38_114# VPWR 0.00181f
C30998 VPWR _685_/a_2250_412# 0.00492f
C30999 _686_/a_1583_191# hold91/a_56_118# 0.00364f
C31000 _686_/a_38_114# net91 0.02294f
C31001 hold124/a_438_182# _264_ 0
C31002 clknet_4_14_0_clk FILLER_22_152/a_32_246# 0
C31003 _206_ _146_ 0.00872f
C31004 _675_/a_1583_191# baud_inst.counter\[3\] 0.00266f
C31005 VPWR FILLER_11_32/a_32_246# 0.09942f
C31006 net21 tx_inst.state\[2\] 0
C31007 VPWR _689_/a_2250_412# 0.03194f
C31008 _696_/a_1489_191# _025_ 0.01769f
C31009 FILLER_17_199/a_40_246# _647_/a_1489_191# 0
C31010 _270_ clknet_4_13_0_clk 0.56105f
C31011 _360_/a_589_385# clknet_4_4_0_clk 0.00127f
C31012 _360_/a_1109_431# _067_ 0
C31013 _360_/a_382_118# tx_inst.data_reg\[2\] 0.04987f
C31014 _288_ net116 0.08134f
C31015 _264_ _271_ 0.06772f
C31016 _447_/a_81_118# VPWR 0.03373f
C31017 clkbuf_4_1_0_clk/a_27_118# _209_ 0.00469f
C31018 _663_/a_1840_334# clkbuf_4_7_0_clk/a_27_118# 0.00165f
C31019 hold74/a_438_182# _240_ 0
C31020 clkbuf_0_clk/a_116_82# net62 0.02647f
C31021 _646_/a_1583_191# net48 0.00203f
C31022 _637_/a_550_127# net30 0
C31023 baud_inst.counter\[20\] _694_/a_681_505# 0
C31024 _182_ hold93/a_438_182# 0
C31025 rx_inst.bit_index\[2\] _250_ 0
C31026 net113 _310_ 0
C31027 net54 _664_/a_1785_429# 0
C31028 _132_ _249_ 0
C31029 fanout47/a_40_152# _056_ 0.01549f
C31030 clknet_4_14_0_clk _472_/a_120_432# 0.00285f
C31031 _648_/a_1583_191# rx_inst.data_reg\[5\] 0.00231f
C31032 clknet_4_5_0_clk _654_/a_2250_412# 0
C31033 _660_/a_1785_429# _144_ 0.00294f
C31034 _660_/a_612_127# _065_ 0
C31035 _660_/a_1840_334# tx_inst.data_reg\[0\] 0
C31036 tx_done net2 0.21883f
C31037 VPWR FILLER_3_141/a_40_246# 0.15817f
C31038 net32 _253_ 0.00341f
C31039 _641_/a_843_236# clknet_0_clk 0.00541f
C31040 rx_inst.state\[2\] fanout24/a_40_152# 0.01137f
C31041 clknet_4_5_0_clk _664_/a_1489_191# 0
C31042 hold140/a_438_182# _025_ 0
C31043 _663_/a_2250_412# net22 0
C31044 rx_data[4] _061_ 0.00101f
C31045 hold170/a_326_118# _660_/a_843_236# 0
C31046 tx_inst.data_reg\[6\] _660_/a_298_337# 0.00171f
C31047 hold170/a_438_182# _660_/a_741_93# 0
C31048 net48 hold118/a_56_118# 0
C31049 FILLER_12_166/a_40_246# VPWR 0.17102f
C31050 hold114/a_56_118# _027_ 0.02386f
C31051 _513_/a_192_429# clknet_0_clk 0.05361f
C31052 net26 net29 2.3969f
C31053 _106_ FILLER_22_22/a_32_246# 0
C31054 _206_ _656_/a_298_337# 0
C31055 _365_/a_155_412# _664_/a_298_337# 0
C31056 net179 _077_ 0.00335f
C31057 _039_ _682_/a_843_236# 0
C31058 _463_/a_22_110# net71 0.01505f
C31059 _463_/a_120_432# _268_ 0
C31060 _690_/a_1785_429# VPWR 0.00368f
C31061 _447_/a_81_118# _239_ 0
C31062 _225_ _452_/a_257_140# 0.00528f
C31063 _215_ VPWR 0.18882f
C31064 _302_ FILLER_17_24/a_32_246# 0
C31065 net105 _550_/a_177_436# 0.00104f
C31066 net32 net29 0.03552f
C31067 _233_ _235_ 0.06652f
C31068 _642_/a_550_127# _132_ 0
C31069 _642_/a_612_127# clknet_4_12_0_clk 0
C31070 clknet_0_clk _647_/a_843_236# 0.00182f
C31071 _691_/a_324_432# _692_/a_843_236# 0
C31072 hold107/a_56_118# _701_/a_741_93# 0.00785f
C31073 hold107/a_326_118# _701_/a_324_432# 0.00347f
C31074 clkload2/Y _026_ 0
C31075 _678_/a_741_93# _677_/a_38_114# 0
C31076 rx_data[4] _465_/a_22_110# 0
C31077 hold111/a_438_182# _049_ 0
C31078 hold159/a_326_118# _382_/a_382_118# 0
C31079 hold159/a_438_182# _382_/a_59_156# 0
C31080 _202_ net168 0.03622f
C31081 _201_ net172 0.15361f
C31082 _180_ FILLER_17_81/a_32_246# 0.0027f
C31083 _117_ rx_inst.state\[1\] 0
C31084 _260_ clknet_0_clk 0.00429f
C31085 _391_/a_46_156# net54 0.01607f
C31086 tx_inst.bit_index\[2\] _171_ 0
C31087 clk _143_ 0.10482f
C31088 hold146/a_326_118# VPWR 0.00702f
C31089 net35 _434_/a_354_412# 0
C31090 FILLER_28_176/a_32_246# _158_ 0
C31091 _341_/a_886_118# net168 0
C31092 tx net55 0.27498f
C31093 net12 _264_ 0.03386f
C31094 _379_/a_46_156# _208_ 0.0012f
C31095 _410_/a_155_412# net25 0
C31096 tx_inst.data_reg\[2\] net9 0.52115f
C31097 hold155/a_56_118# tx_inst.data_reg\[1\] 0.00411f
C31098 _680_/a_1840_334# net86 0.00193f
C31099 _680_/a_2250_412# net181 0
C31100 _636_/a_298_337# net30 0
C31101 clknet_4_14_0_clk _648_/a_324_432# 0.03931f
C31102 hold56/a_326_118# _651_/a_1489_191# 0
C31103 tx_inst.bit_index\[0\] _651_/a_2250_412# 0.03316f
C31104 VPWR hold51/a_56_118# 0.01249f
C31105 baud_inst.counter\[21\] _693_/a_2250_412# 0.0085f
C31106 _305_ _694_/a_324_432# 0.009f
C31107 net29 hold62/a_326_118# 0.00113f
C31108 _054_ clkbuf_4_15_0_clk/a_27_118# 0.0152f
C31109 net33 _665_/a_741_93# 0
C31110 clknet_4_4_0_clk _653_/a_132_114# 0
C31111 hold59/a_438_182# _180_ 0
C31112 _291_ FILLER_8_63/a_40_246# 0.01918f
C31113 _705_/a_1583_191# FILLER_8_236/a_40_246# 0
C31114 _035_ _280_ 0.07242f
C31115 hold111/a_326_118# _043_ 0.0077f
C31116 _643_/a_1840_334# clknet_4_15_0_clk 0
C31117 _660_/a_843_236# VPWR 0.03184f
C31118 _293_ hold91/a_56_118# 0
C31119 _646_/a_1840_334# _157_ 0.02035f
C31120 _083_ _670_/a_324_432# 0.01455f
C31121 baud_inst.counter\[27\] FILLER_19_77/a_32_246# 0
C31122 net65 _649_/a_1840_334# 0.007f
C31123 _475_/a_170_412# _001_ 0
C31124 hold160/a_56_118# _188_ 0.04551f
C31125 net115 FILLER_6_54/a_32_246# 0
C31126 tx_inst.bit_index\[1\] _398_/a_115_308# 0.00332f
C31127 _394_/a_22_110# _200_ 0.02585f
C31128 _073_ _275_ 0.59595f
C31129 net110 _505_/a_76_160# 0.00145f
C31130 _175_ _341_/a_1377_160# 0
C31131 _513_/a_192_429# _182_ 0
C31132 _296_ net40 0.21112f
C31133 baud_inst.counter\[30\] _703_/a_298_337# 0.01253f
C31134 baud_inst.counter\[31\] _703_/a_38_114# 0.0033f
C31135 baud_inst.counter\[28\] _703_/a_324_432# 0.00162f
C31136 _008_ _672_/a_38_114# 0.0396f
C31137 net79 _672_/a_324_432# 0.00487f
C31138 net26 hold119/a_56_118# 0
C31139 FILLER_21_192/a_40_246# _054_ 0.00393f
C31140 baud_inst.counter\[27\] clknet_4_8_0_clk 0.05529f
C31141 _661_/a_843_236# clknet_4_1_0_clk 0.01917f
C31142 _282_ clkbuf_4_3_0_clk/a_27_118# 0
C31143 _657_/a_2250_412# net41 0.00402f
C31144 _189_ _684_/a_1489_191# 0
C31145 hold88/a_326_118# _097_ 0
C31146 _691_/a_132_114# _164_ 0
C31147 _691_/a_843_236# _018_ 0
C31148 _691_/a_1583_191# _302_ 0
C31149 _170_ hold119/a_326_118# 0
C31150 _240_ _647_/a_1785_429# 0
C31151 _691_/a_1583_191# _690_/a_1840_334# 0
C31152 _217_ fanout34/a_40_152# 0
C31153 _694_/a_843_236# _701_/a_38_114# 0
C31154 _101_ _688_/a_38_114# 0.02967f
C31155 baud_inst.counter\[15\] fanout29/a_40_152# 0
C31156 hold69/a_56_118# rx_inst.data_reg\[6\] 0
C31157 hold168/a_438_182# clknet_4_4_0_clk 0
C31158 _486_/a_115_308# rx_inst.state\[3\] 0
C31159 _400_/a_341_118# clknet_0_clk 0
C31160 hold76/a_56_118# baud_inst.counter\[21\] 0.00232f
C31161 _644_/a_1583_191# net150 0.00294f
C31162 _447_/a_81_118# _167_ 0.0269f
C31163 _657_/a_132_114# _147_ 0
C31164 _258_ _264_ 0
C31165 _003_ _670_/a_1840_334# 0
C31166 net133 _700_/a_741_93# 0.01038f
C31167 _028_ _700_/a_38_114# 0
C31168 hold176/a_326_118# net25 0
C31169 _659_/a_324_432# tx_inst.data_reg\[1\] 0.00898f
C31170 _184_ clknet_0_clk 0.00381f
C31171 _009_ net29 0.02934f
C31172 hold106/a_438_182# VPWR 0.00434f
C31173 net72 VPWR 0.19006f
C31174 FILLER_2_208/a_40_246# tx_inst.state\[2\] 0
C31175 hold173/a_56_118# hold57/a_56_118# 0
C31176 net30 net19 0.03634f
C31177 _499_/a_209_168# _495_/a_154_118# 0
C31178 _191_ _035_ 0
C31179 net14 FILLER_29_221/a_32_246# 0.01475f
C31180 net158 net161 0.05382f
C31181 _643_/a_298_337# clknet_0_clk 0.00123f
C31182 _232_ _223_ 0.07458f
C31183 hold168/a_56_118# _198_ 0.01684f
C31184 hold161/a_438_182# baud_inst.counter\[16\] 0.00787f
C31185 hold54/a_438_182# net55 0
C31186 _143_ _653_/a_1840_334# 0.0049f
C31187 _216_ _653_/a_2250_412# 0.00436f
C31188 _642_/a_1583_191# net24 0.0017f
C31189 net47 _633_/a_1785_429# 0
C31190 _675_/a_38_114# VPWR 0.03103f
C31191 clkload3/Y clknet_4_15_0_clk 0.01413f
C31192 output21/a_40_152# tx_start 0
C31193 hold165/a_438_182# net54 0
C31194 hold165/a_56_118# _214_ 0
C31195 hold121/a_56_118# net120 0
C31196 hold63/a_438_182# clkbuf_0_clk/a_116_82# 0.00212f
C31197 hold126/a_326_118# _637_/a_298_337# 0
C31198 net133 hold106/a_56_118# 0.00237f
C31199 _668_/a_741_93# rx_inst.state\[4\] 0
C31200 VPWR FILLER_2_46/a_40_246# 0.13539f
C31201 _642_/a_298_337# _641_/a_324_432# 0
C31202 _660_/a_741_93# net179 0.00118f
C31203 _286_ _280_ 0
C31204 _641_/a_2250_412# _262_ 0.01495f
C31205 _641_/a_1840_334# _131_ 0.00292f
C31206 net41 FILLER_2_183/a_32_246# 0.00613f
C31207 net30 hold51/a_326_118# 0
C31208 _242_ _251_ 0.01226f
C31209 net108 _353_/a_350_122# 0.00309f
C31210 _061_ _668_/a_843_236# 0
C31211 _680_/a_38_114# net38 0.01411f
C31212 hold97/a_438_182# _290_ 0
C31213 _265_ clknet_4_13_0_clk 0.02687f
C31214 _129_ net81 0
C31215 _390_/a_59_156# net38 0.0062f
C31216 net101 net160 0.00208f
C31217 _060_ clkbuf_4_15_0_clk/a_27_118# 0.00145f
C31218 hold120/a_326_118# VPWR 0.008f
C31219 hold99/a_56_118# _110_ 0
C31220 FILLER_15_67/a_40_246# clknet_0_clk 0.00167f
C31221 fanout31/a_40_152# _241_ 0
C31222 FILLER_29_221/a_32_246# _637_/a_741_93# 0
C31223 net67 _702_/a_681_505# 0
C31224 fanout27/a_40_152# clknet_0_clk 0.00266f
C31225 net48 _429_/a_244_412# 0.0087f
C31226 _189_ _187_ 0.03428f
C31227 _699_/a_843_236# net99 0
C31228 _674_/a_1583_191# clknet_4_0_0_clk 0.03054f
C31229 tx_inst.data_reg\[7\] tx_inst.bit_index\[2\] 0.00179f
C31230 hold180/a_56_118# net25 0
C31231 _632_/a_1583_191# _264_ 0.01064f
C31232 net44 _691_/a_2002_114# 0
C31233 _654_/a_741_93# tx_inst.data_reg\[0\] 0.00147f
C31234 _087_ _287_ 0
C31235 _489_/a_115_308# _504_/a_209_168# 0
C31236 _095_ baud_inst.counter\[9\] 0
C31237 net172 tx_inst.state\[3\] 0
C31238 _291_ VPWR 0.18361f
C31239 net42 net39 0.00629f
C31240 FILLER_1_28/a_40_246# VPWR 0.151f
C31241 hold112/a_326_118# net24 0.01649f
C31242 hold76/a_438_182# _694_/a_843_236# 0
C31243 _184_ _182_ 0.38853f
C31244 _670_/a_843_236# FILLER_11_123/a_40_246# 0
C31245 _049_ clknet_0_clk 0.00223f
C31246 _683_/a_38_114# net29 0.00411f
C31247 hold170/a_56_118# _654_/a_298_337# 0
C31248 _213_ _066_ 0
C31249 _692_/a_1840_334# VPWR 0.01552f
C31250 _661_/a_1583_191# net41 0
C31251 _126_ FILLER_18_210/a_32_246# 0
C31252 _127_ net72 0
C31253 _678_/a_132_114# _185_ 0
C31254 _678_/a_1840_334# baud_inst.counter\[6\] 0.016f
C31255 net12 hold69/a_438_182# 0.00502f
C31256 rx_inst.state\[3\] _652_/a_324_432# 0
C31257 rx_inst.state\[2\] _408_/a_154_118# 0
C31258 net8 FILLER_0_103/a_32_246# 0.01865f
C31259 net30 _457_/a_22_110# 0.01274f
C31260 baud_inst.counter\[30\] _179_ 0.01512f
C31261 _663_/a_843_236# _666_/a_1840_334# 0
C31262 _663_/a_741_93# _666_/a_2250_412# 0
C31263 _306_ net75 0
C31264 net34 clknet_4_6_0_clk 0
C31265 baud_inst.counter\[22\] _305_ 0.00489f
C31266 baud_inst.counter\[23\] _023_ 0.00104f
C31267 _704_/a_1840_334# VPWR 0.00124f
C31268 _686_/a_1840_334# net91 0
C31269 _556_/a_341_118# _314_ 0
C31270 net58 net105 0
C31271 net159 _385_/a_46_156# 0
C31272 hold129/a_326_118# baud_inst.counter\[13\] 0.00909f
C31273 _264_ _648_/a_843_236# 0.03505f
C31274 tx_inst.data_reg\[7\] _657_/a_324_432# 0
C31275 _489_/a_115_308# hold135/a_56_118# 0.0013f
C31276 net42 _393_/a_170_412# 0
C31277 _082_ FILLER_15_127/a_32_246# 0
C31278 _657_/a_1489_191# clknet_4_1_0_clk 0.0052f
C31279 _062_ FILLER_10_145/a_40_246# 0.00375f
C31280 _644_/a_298_337# _158_ 0
C31281 hold100/a_326_118# net100 0.00452f
C31282 _255_ net52 0.05168f
C31283 VPWR _120_ 0.10622f
C31284 hold173/a_438_182# VPWR 0.0022f
C31285 FILLER_8_171/a_32_246# net34 0.00112f
C31286 _216_ hold169/a_326_118# 0.01036f
C31287 _689_/a_298_337# baud_inst.counter\[16\] 0
C31288 _360_/a_810_118# tx_inst.data_reg\[2\] 0
C31289 _360_/a_1023_118# clknet_4_4_0_clk 0
C31290 net34 _218_ 0.15436f
C31291 hold55/a_326_118# tx_inst.state\[3\] 0
C31292 _432_/a_350_122# net37 0
C31293 FILLER_9_72/a_32_246# _182_ 0.00293f
C31294 _132_ net51 0
C31295 net72 _266_ 0.00119f
C31296 baud_inst.counter\[20\] _694_/a_550_127# 0
C31297 net32 FILLER_24_156/a_32_246# 0
C31298 net8 _384_/a_59_156# 0
C31299 net60 _182_ 0.00374f
C31300 hold128/a_438_182# FILLER_13_89/a_40_246# 0.00941f
C31301 net84 _264_ 0.14357f
C31302 clknet_4_14_0_clk _123_ 0.53013f
C31303 _094_ hold117/a_56_118# 0
C31304 net14 hold83/a_56_118# 0.0026f
C31305 _546_/a_192_429# FILLER_23_83/a_32_246# 0
C31306 _641_/a_612_127# clknet_0_clk 0.00218f
C31307 _191_ net51 0
C31308 _698_/a_843_236# baud_inst.counter\[25\] 0
C31309 clknet_4_5_0_clk tx_inst.state\[2\] 0.01507f
C31310 baud_inst.counter\[31\] clknet_4_11_0_clk 0.19644f
C31311 net44 _111_ 0.09165f
C31312 net48 rx_data[1] 0
C31313 _634_/a_843_236# clknet_4_15_0_clk 0.02773f
C31314 tx_inst.data_reg\[6\] _660_/a_1583_191# 0.03469f
C31315 _058_ _647_/a_324_432# 0.02663f
C31316 _646_/a_1583_191# net143 0.00125f
C31317 tx_data[1] baud_inst.counter\[0\] 0.00345f
C31318 VPWR _664_/a_741_93# 0.03553f
C31319 _206_ _656_/a_1583_191# 0.01031f
C31320 baud_inst.counter\[6\] net29 0
C31321 net55 _665_/a_324_432# 0.01552f
C31322 _288_ _682_/a_1489_191# 0.01983f
C31323 baud_inst.counter\[22\] _701_/a_741_93# 0
C31324 _699_/a_1489_191# net113 0
C31325 baud_inst.counter\[23\] _701_/a_843_236# 0
C31326 net39 _670_/a_298_337# 0.00181f
C31327 _103_ VPWR 0.31869f
C31328 net105 _028_ 0.04736f
C31329 net115 _505_/a_272_160# 0.00326f
C31330 clkbuf_0_clk/a_116_82# rx_inst.state\[3\] 0.03981f
C31331 _109_ _686_/a_1583_191# 0
C31332 net44 hold103/a_56_118# 0.0109f
C31333 _053_ rx_inst.bit_index\[2\] 0.00114f
C31334 _132_ clknet_4_12_0_clk 0.1021f
C31335 _678_/a_1583_191# _677_/a_843_236# 0
C31336 _678_/a_1840_334# _677_/a_741_93# 0
C31337 net177 net87 0
C31338 hold88/a_326_118# net90 0
C31339 hold98/a_56_118# _682_/a_741_93# 0.00162f
C31340 hold98/a_326_118# _682_/a_324_432# 0
C31341 hold108/a_56_118# _186_ 0.04943f
C31342 hold154/a_438_182# _034_ 0.02951f
C31343 _241_ _168_ 0
C31344 rx_data[2] _634_/a_324_432# 0
C31345 net14 _634_/a_741_93# 0.00787f
C31346 tx_busy input2/a_40_152# 0
C31347 baud_inst.counter\[18\] net156 0.03135f
C31348 clkbuf_4_15_0_clk/a_27_118# _649_/a_741_93# 0.01858f
C31349 hold53/a_438_182# clknet_4_12_0_clk 0
C31350 _662_/a_2250_412# _706_/a_1583_191# 0.00159f
C31351 _662_/a_1489_191# _706_/a_741_93# 0
C31352 _662_/a_1840_334# _706_/a_1840_334# 0
C31353 _680_/a_1583_191# hold115/a_326_118# 0
C31354 net45 clknet_0_clk 0.20026f
C31355 _490_/a_45_160# _504_/a_209_168# 0.00148f
C31356 _206_ _382_/a_59_156# 0.03688f
C31357 net123 _191_ 0.09814f
C31358 hold74/a_326_118# net19 0
C31359 hold65/a_56_118# VPWR 0.01367f
C31360 net33 FILLER_8_236/a_40_246# 0.03231f
C31361 _229_ net25 0.12757f
C31362 _636_/a_1583_191# net30 0.04379f
C31363 clknet_4_14_0_clk _648_/a_2250_412# 0
C31364 _639_/a_1583_191# _668_/a_1583_191# 0.00424f
C31365 net122 net26 0.38957f
C31366 net142 VPWR 0.02342f
C31367 _183_ _502_/a_165_412# 0.00114f
C31368 hold56/a_438_182# clknet_4_6_0_clk 0.00136f
C31369 _023_ _694_/a_1840_334# 0
C31370 hold171/a_438_182# clk 0
C31371 net33 _665_/a_1785_429# 0
C31372 clknet_4_4_0_clk _653_/a_1489_191# 0.00352f
C31373 net56 clkbuf_4_4_0_clk/a_27_118# 0
C31374 rx _121_ 0.00765f
C31375 _170_ net37 0.11482f
C31376 _513_/a_341_118# net108 0
C31377 hold130/a_438_182# VPWR 0.00648f
C31378 net40 hold94/a_438_182# 0.03535f
C31379 _671_/a_132_114# VPWR 0
C31380 _081_ _000_ 0.01143f
C31381 _705_/a_843_236# tx_inst.state\[3\] 0
C31382 rx_data[4] _156_ 0
C31383 _660_/a_612_127# VPWR 0.00533f
C31384 FILLER_8_171/a_32_246# hold56/a_438_182# 0
C31385 net143 net64 0.01168f
C31386 _390_/a_382_118# _655_/a_324_432# 0
C31387 net41 _071_ 0.54718f
C31388 hold182/a_56_118# _676_/a_1840_334# 0
C31389 _023_ FILLER_21_33/a_32_246# 0
C31390 _637_/a_741_93# _634_/a_741_93# 0.00939f
C31391 _637_/a_324_432# _634_/a_843_236# 0
C31392 clknet_4_5_0_clk _197_ 0
C31393 _091_ hold94/a_326_118# 0.05126f
C31394 hold52/a_56_118# net52 0.01046f
C31395 net22 _166_ 0
C31396 _249_ _435_/a_411_436# 0.00112f
C31397 tx_inst.bit_index\[1\] _216_ 0.04497f
C31398 net148 VPWR 0.05559f
C31399 net179 net43 0.02812f
C31400 _364_/a_257_140# _196_ 0
C31401 net39 _682_/a_324_432# 0.00265f
C31402 FILLER_12_46/a_32_246# _509_/a_155_412# 0
C31403 baud_inst.counter\[31\] _703_/a_1840_334# 0.02213f
C31404 net79 _672_/a_2250_412# 0.0192f
C31405 _661_/a_741_93# _072_ 0.00207f
C31406 FILLER_12_0/a_32_246# net160 0
C31407 net37 hold62/a_56_118# 0.01936f
C31408 tx_data[0] _388_/a_285_118# 0
C31409 _661_/a_612_127# clknet_4_1_0_clk 0
C31410 hold117/a_438_182# VPWR 0.03339f
C31411 _097_ _295_ 0
C31412 net7 _381_/a_46_156# 0.00938f
C31413 _170_ _056_ 0.00373f
C31414 tx_inst.data_reg\[4\] _360_/a_382_118# 0.04424f
C31415 _691_/a_1489_191# _164_ 0
C31416 clknet_4_14_0_clk net124 0
C31417 hold112/a_56_118# VPWR 0.03767f
C31418 hold167/a_326_118# net29 0.01491f
C31419 _226_ _408_/a_154_118# 0.00318f
C31420 _691_/a_741_93# clknet_4_8_0_clk 0.02341f
C31421 hold63/a_56_118# _080_ 0.00808f
C31422 _640_/a_324_432# rx_inst.bit_index\[0\] 0
C31423 _640_/a_741_93# clknet_4_14_0_clk 0.02979f
C31424 hold179/a_438_182# _654_/a_324_432# 0
C31425 hold179/a_326_118# _654_/a_741_93# 0
C31426 hold179/a_56_118# _654_/a_843_236# 0.00118f
C31427 net94 _680_/a_843_236# 0
C31428 net180 hold180/a_326_118# 0.00765f
C31429 net125 clknet_0_clk 0.00574f
C31430 _101_ _688_/a_1840_334# -0
C31431 clknet_4_8_0_clk _541_/a_380_412# 0.01902f
C31432 hold69/a_56_118# _632_/a_2250_412# 0
C31433 hold69/a_326_118# _632_/a_1840_334# 0
C31434 hold69/a_438_182# _632_/a_1583_191# 0
C31435 _178_ _347_/a_146_122# 0.00488f
C31436 hold97/a_438_182# net108 0.00175f
C31437 hold97/a_326_118# net97 0.01133f
C31438 _646_/a_681_505# clknet_4_12_0_clk 0
C31439 _359_/a_120_432# net27 0.0062f
C31440 _359_/a_22_110# _176_ 0.00178f
C31441 _655_/a_1583_191# _655_/a_2250_412# -0
C31442 _267_ net30 0.32601f
C31443 _637_/a_132_114# net47 0
C31444 _350_/a_165_412# baud_inst.counter\[9\] 0.00108f
C31445 net44 baud_inst.counter\[16\] 0.00145f
C31446 _635_/a_741_93# _264_ 0.03891f
C31447 net36 rx_inst.state\[2\] 0.16757f
C31448 _378_/a_559_412# _209_ 0.00364f
C31449 net155 _381_/a_46_156# 0
C31450 VPWR baud_inst.counter\[4\] 0.69165f
C31451 hold133/a_438_182# _700_/a_1583_191# 0
C31452 hold133/a_326_118# _700_/a_1840_334# 0.00176f
C31453 _659_/a_2250_412# tx_inst.data_reg\[1\] 0.00386f
C31454 hold65/a_56_118# _127_ 0.00148f
C31455 _522_/a_474_130# net160 0
C31456 _097_ clknet_4_2_0_clk 0.0241f
C31457 _522_/a_380_412# _296_ 0.03693f
C31458 _161_ FILLER_25_141/a_32_246# 0.01921f
C31459 _051_ net52 0.00328f
C31460 net57 net43 0
C31461 clknet_4_4_0_clk _063_ 0
C31462 hold74/a_56_118# rx_data[7] 0.07377f
C31463 hold151/a_56_118# VPWR 0.04354f
C31464 hold150/a_326_118# net48 0.00697f
C31465 _462_/a_22_110# _154_ 0.00924f
C31466 _246_ _228_ 0
C31467 hold164/a_326_118# VPWR 0.0079f
C31468 _499_/a_380_412# _282_ 0.00548f
C31469 _170_ _134_ 0.18049f
C31470 net45 _551_/a_170_160# 0
C31471 _643_/a_1583_191# clknet_0_clk 0.05119f
C31472 rx_data[4] _050_ 0
C31473 net16 net81 0
C31474 net42 FILLER_8_189/a_40_246# 0.02273f
C31475 _675_/a_1840_334# VPWR 0.00233f
C31476 _498_/a_279_412# VPWR 0
C31477 clknet_4_12_0_clk _451_/a_257_140# 0
C31478 rx_inst.bit_index\[2\] _451_/a_155_412# 0.00176f
C31479 baud_inst.counter\[31\] hold113/a_326_118# 0
C31480 _282_ hold93/a_56_118# 0.0121f
C31481 net152 hold93/a_438_182# 0.00313f
C31482 _688_/a_843_236# net161 0
C31483 _647_/a_2250_412# net19 0
C31484 fanout29/a_40_152# clknet_4_9_0_clk 0
C31485 _157_ _647_/a_298_337# 0
C31486 net176 _697_/a_741_93# 0
C31487 hold65/a_326_118# net30 0.03176f
C31488 hold65/a_56_118# _266_ 0
C31489 _640_/a_550_127# net100 0
C31490 hold79/a_326_118# baud_inst.counter\[0\] 0.00628f
C31491 net108 _186_ 0.22094f
C31492 rx_inst.data_reg\[7\] _668_/a_1840_334# 0
C31493 _680_/a_1840_334# net38 0.00601f
C31494 _045_ VPWR 0.24885f
C31495 _687_/a_1583_191# _308_ 0
C31496 _555_/a_177_436# _115_ 0
C31497 _555_/a_209_168# net68 0.00147f
C31498 net67 _702_/a_550_127# 0
C31499 _671_/a_1583_191# net30 0
C31500 _671_/a_1840_334# _000_ 0.00509f
C31501 _519_/a_81_118# _296_ 0.01466f
C31502 hold64/a_326_118# _122_ 0.00187f
C31503 net155 _658_/a_612_127# 0
C31504 _674_/a_2002_114# clknet_4_0_0_clk 0.00101f
C31505 hold174/a_56_118# _216_ 0
C31506 hold98/a_56_118# FILLER_8_35/a_32_246# 0
C31507 net178 _688_/a_1583_191# 0.0015f
C31508 net49 fanout25/a_40_152# 0.00319f
C31509 _248_ clknet_0_clk 0.00797f
C31510 _114_ _701_/a_324_432# 0.01018f
C31511 _632_/a_2002_114# _264_ 0
C31512 FILLER_5_74/a_32_246# net29 0
C31513 _361_/a_248_122# tx_inst.bit_index\[1\] 0
C31514 _079_ hold122/a_56_118# 0
C31515 hold101/a_56_118# _017_ 0
C31516 baud_inst.counter\[18\] hold102/a_56_118# 0
C31517 fanout43/a_40_152# clknet_0_clk 0
C31518 hold103/a_56_118# _302_ 0
C31519 _654_/a_1785_429# tx_inst.data_reg\[0\] 0.00131f
C31520 _489_/a_358_436# net135 0.00134f
C31521 _489_/a_115_308# _287_ 0.00513f
C31522 _256_ FILLER_26_151/a_32_246# 0
C31523 _679_/a_741_93# net95 0.00167f
C31524 _679_/a_843_236# net29 0.04241f
C31525 _679_/a_38_114# _037_ 0.04043f
C31526 FILLER_18_169/a_40_246# _136_ 0
C31527 hold114/a_56_118# net49 0
C31528 net55 input7/a_40_152# 0
C31529 _377_/a_46_156# net7 0.00277f
C31530 fanout30/a_40_152# _157_ 0.00242f
C31531 net18 _637_/a_843_236# 0.00215f
C31532 _683_/a_1840_334# net29 0.00589f
C31533 tx_inst.data_reg\[6\] _654_/a_324_432# 0
C31534 _171_ _275_ 0
C31535 net42 _676_/a_843_236# 0
C31536 _673_/a_1583_191# clknet_4_0_0_clk 0.00263f
C31537 net128 _670_/a_132_114# 0
C31538 hold162/a_438_182# _309_ 0.00102f
C31539 _344_/a_150_412# baud_inst.counter\[27\] 0
C31540 _177_ _703_/a_38_114# 0
C31541 _232_ _447_/a_81_118# 0.03552f
C31542 _448_/a_142_412# _259_ 0
C31543 _005_ tx_inst.state\[2\] 0
C31544 _062_ clkbuf_4_6_0_clk/a_27_118# 0
C31545 _643_/a_1489_191# _240_ 0
C31546 FILLER_19_132/a_40_246# rx_inst.state\[2\] 0.00197f
C31547 _185_ hold95/a_56_118# 0.03379f
C31548 baud_inst.counter\[6\] hold95/a_438_182# 0
C31549 VPWR _687_/a_298_337# 0.00246f
C31550 hold143/a_438_182# VPWR 0.00509f
C31551 _697_/a_741_93# FILLER_21_96/a_40_246# 0.00107f
C31552 tx_inst.data_reg\[1\] net38 0.01789f
C31553 hold74/a_326_118# _636_/a_1583_191# 0.00234f
C31554 net74 _636_/a_324_432# 0.02558f
C31555 net37 _237_ 0.08175f
C31556 _688_/a_2250_412# _508_/a_209_168# 0
C31557 _075_ _666_/a_324_432# 0
C31558 rx_inst.data_reg\[0\] net47 0
C31559 net31 _257_ 0.19099f
C31560 hold166/a_438_182# _409_/a_73_118# 0
C31561 net31 _256_ 0
C31562 _378_/a_559_412# _207_ 0.00572f
C31563 _264_ _648_/a_612_127# 0
C31564 tx_inst.data_reg\[7\] _657_/a_2250_412# 0.00437f
C31565 _489_/a_494_160# baud_inst.counter\[8\] 0
C31566 tx_inst.data_reg\[3\] clknet_4_1_0_clk 0
C31567 _644_/a_1583_191# _158_ 0.02254f
C31568 net23 FILLER_8_236/a_40_246# 0
C31569 hold53/a_56_118# _161_ 0
C31570 hold181/a_326_118# _092_ 0
C31571 VPWR _492_/a_170_412# 0
C31572 _689_/a_1583_191# baud_inst.counter\[16\] 0
C31573 net45 _700_/a_843_236# 0
C31574 net58 hold58/a_438_182# 0.01188f
C31575 _214_ _144_ 0.02817f
C31576 net54 tx_inst.data_reg\[0\] 0.02724f
C31577 net184 tx_inst.data_reg\[2\] 0.01472f
C31578 hold57/a_326_118# _403_/a_22_110# 0
C31579 VPWR _688_/a_324_432# 0.02366f
C31580 net20 clknet_4_7_0_clk 0
C31581 _486_/a_115_308# _205_ 0.00494f
C31582 baud_inst.counter\[21\] _695_/a_843_236# 0
C31583 _245_ clknet_0_clk 0.04593f
C31584 baud_inst.counter\[23\] _695_/a_324_432# 0.03016f
C31585 baud_inst.counter\[22\] _695_/a_38_114# 0.0342f
C31586 net36 _226_ 0.09084f
C31587 tx_data[3] tx_data[4] 0.11847f
C31588 _499_/a_209_168# _162_ 0
C31589 _009_ _288_ 0.68224f
C31590 _660_/a_324_432# clk 0.00978f
C31591 _645_/a_132_114# _158_ 0
C31592 net176 clknet_0_clk 0.0288f
C31593 _698_/a_612_127# baud_inst.counter\[25\] 0
C31594 _698_/a_1489_191# net99 0
C31595 _654_/a_132_114# VPWR 0
C31596 clknet_4_8_0_clk clkbuf_4_8_0_clk/a_27_118# 0.00556f
C31597 _634_/a_612_127# clknet_4_15_0_clk 0
C31598 hold170/a_56_118# clknet_4_5_0_clk 0
C31599 tx_inst.data_reg\[6\] _660_/a_2002_114# 0
C31600 net92 _499_/a_177_436# 0.00143f
C31601 _283_ _499_/a_209_168# 0.02161f
C31602 hold78/a_56_118# net82 0
C31603 rx_inst.data_reg\[3\] hold143/a_56_118# 0.03637f
C31604 _646_/a_2002_114# net143 0
C31605 VPWR _664_/a_1785_429# 0
C31606 _294_ net40 0
C31607 _206_ _656_/a_2002_114# 0
C31608 _197_ _005_ 0.06798f
C31609 fanout27/a_40_152# net43 0.01267f
C31610 hold177/a_326_118# _296_ 0
C31611 VPWR _136_ 0.25259f
C31612 net116 clknet_4_2_0_clk 0
C31613 _080_ clknet_0_clk 0.00138f
C31614 _193_ _076_ 0
C31615 net92 hold153/a_326_118# 0
C31616 _283_ hold153/a_56_118# 0
C31617 _302_ baud_inst.counter\[16\] 0
C31618 net45 hold106/a_326_118# 0.07155f
C31619 _206_ tx_data[3] 0.00137f
C31620 net110 hold109/a_56_118# 0
C31621 _653_/a_298_337# net43 0.0013f
C31622 _220_ net168 0
C31623 _690_/a_1840_334# baud_inst.counter\[16\] 0
C31624 _696_/a_843_236# net90 0
C31625 clknet_0_clk net139 0
C31626 FILLER_25_198/a_32_246# _648_/a_1489_191# 0
C31627 net98 _682_/a_843_236# 0.00213f
C31628 _007_ _666_/a_298_337# 0
C31629 _166_ _666_/a_741_93# 0.01731f
C31630 _676_/a_741_93# _670_/a_38_114# 0
C31631 _676_/a_843_236# _670_/a_298_337# 0
C31632 net49 FILLER_17_162/a_32_246# 0
C31633 _045_ _266_ 0.0065f
C31634 net14 _634_/a_1785_429# 0
C31635 clknet_4_13_0_clk _632_/a_843_236# 0.00451f
C31636 output20/a_40_152# FILLER_8_236/a_40_246# 0
C31637 hold121/a_438_182# net147 0.00159f
C31638 FILLER_21_192/a_40_246# _257_ 0.00168f
C31639 _073_ _706_/a_681_505# 0
C31640 _040_ _706_/a_741_93# 0
C31641 net87 _188_ 0
C31642 _636_/a_298_337# hold73/a_56_118# 0.00187f
C31643 _490_/a_45_160# _287_ 0
C31644 _279_ _504_/a_380_412# 0.02108f
C31645 _699_/a_1489_191# baud_inst.counter\[29\] 0
C31646 input7/a_40_152# _389_/a_46_156# 0.00211f
C31647 _019_ clknet_0_clk 0
C31648 _185_ net40 0
C31649 hold152/a_326_118# _284_ 0.00159f
C31650 _636_/a_2002_114# net30 0
C31651 _636_/a_1489_191# _266_ 0
C31652 _543_/a_248_122# _309_ 0
C31653 hold109/a_326_118# _096_ 0.01025f
C31654 rx_inst.data_reg\[1\] _633_/a_298_337# 0
C31655 _021_ _106_ 0.13975f
C31656 clknet_4_0_0_clk net40 0
C31657 _642_/a_1489_191# VPWR 0.00155f
C31658 _391_/a_46_156# VPWR 0.00417f
C31659 FILLER_21_96/a_40_246# clknet_0_clk 0.00246f
C31660 tx_inst.data_reg\[5\] _339_/a_382_118# 0.02776f
C31661 hold123/a_56_118# VPWR 0.01655f
C31662 _025_ _309_ 0
C31663 net97 _684_/a_38_114# 0
C31664 _411_/a_115_308# hold166/a_326_118# 0.00105f
C31665 _105_ FILLER_20_0/a_40_246# 0.00415f
C31666 _671_/a_1489_191# VPWR 0.00533f
C31667 clkbuf_4_11_0_clk/a_27_118# hold100/a_438_182# 0
C31668 hold177/a_56_118# baud_inst.counter\[12\] 0.05682f
C31669 net44 FILLER_16_56/a_32_246# 0
C31670 hold66/a_56_118# clknet_4_13_0_clk 0.05685f
C31671 baud_inst.counter\[19\] _688_/a_1583_191# 0
C31672 hold134/a_56_118# _313_ 0
C31673 _128_ _638_/a_843_236# 0
C31674 hold87/a_326_118# net128 0
C31675 net121 net76 0
C31676 FILLER_2_110/a_32_246# tx_inst.data_reg\[1\] 0
C31677 hold120/a_56_118# net45 0
C31678 net144 _136_ 0
C31679 VPWR _686_/a_1489_191# 0
C31680 net48 _647_/a_132_114# 0
C31681 _632_/a_843_236# net65 0
C31682 _632_/a_741_93# _122_ 0.00636f
C31683 _481_/a_120_432# _192_ 0.00643f
C31684 baud_inst.counter\[8\] _505_/a_76_160# 0.05389f
C31685 hold143/a_438_182# _266_ 0.00641f
C31686 clkbuf_4_1_0_clk/a_27_118# _386_/a_382_118# 0.0108f
C31687 net86 _066_ 0
C31688 net39 _682_/a_2250_412# 0
C31689 _689_/a_298_337# _016_ 0
C31690 _689_/a_324_432# net157 0
C31691 _661_/a_1583_191# tx_inst.data_reg\[7\] 0.01507f
C31692 _702_/a_298_337# _115_ 0.01357f
C31693 tx_data[0] _146_ 0.03907f
C31694 _226_ FILLER_19_132/a_40_246# 0
C31695 _640_/a_1840_334# _263_ 0
C31696 net56 VPWR 0.21061f
C31697 hold104/a_438_182# _300_ 0
C31698 _646_/a_1583_191# FILLER_17_201/a_32_246# 0
C31699 net36 _434_/a_252_412# 0
C31700 baud_inst.counter\[23\] net99 0
C31701 _640_/a_2250_412# rx_inst.bit_index\[0\] 0.012f
C31702 _640_/a_1785_429# clknet_4_14_0_clk 0.00121f
C31703 _491_/a_192_429# _085_ 0.00355f
C31704 _488_/a_474_130# net86 0
C31705 _019_ _348_/a_146_122# 0.0022f
C31706 _186_ _495_/a_154_118# 0
C31707 _184_ net152 0
C31708 _090_ clknet_4_1_0_clk 0
C31709 _178_ baud_inst.counter\[30\] 0
C31710 _107_ _701_/a_324_432# 0
C31711 hold54/a_326_118# _077_ 0.00153f
C31712 net69 _632_/a_1785_429# 0
C31713 hold97/a_56_118# hold115/a_326_118# 0
C31714 _652_/a_843_236# net43 0.00334f
C31715 _357_/a_150_412# net29 0
C31716 _646_/a_550_127# clknet_4_12_0_clk 0
C31717 net179 _664_/a_2250_412# 0
C31718 net27 _192_ 0.52738f
C31719 _041_ clknet_0_clk 0.01212f
C31720 clknet_4_12_0_clk _435_/a_411_436# 0.00168f
C31721 _655_/a_681_505# _145_ 0
C31722 hold160/a_56_118# _528_/a_81_118# 0
C31723 net44 hold87/a_56_118# 0.01919f
C31724 net163 net101 0.00167f
C31725 _246_ _434_/a_150_412# 0
C31726 _183_ baud_inst.counter\[9\] 0.01611f
C31727 net177 _354_/a_170_412# 0
C31728 hold128/a_326_118# _685_/a_843_236# 0
C31729 hold128/a_438_182# _685_/a_741_93# 0.00275f
C31730 _690_/a_324_432# FILLER_17_22/a_40_246# 0
C31731 net71 FILLER_27_210/a_40_246# 0
C31732 hold132/a_438_182# _134_ 0
C31733 _635_/a_1785_429# _264_ 0.00112f
C31734 _677_/a_681_505# net40 0
C31735 net85 _264_ 0
C31736 hold158/a_438_182# baud_inst.counter\[16\] 0
C31737 _073_ net50 0.00857f
C31738 _177_ clknet_4_11_0_clk 0.01061f
C31739 hold75/a_326_118# baud_inst.counter\[22\] 0.0017f
C31740 hold75/a_438_182# baud_inst.counter\[23\] 0.02495f
C31741 _646_/a_298_337# VPWR 0.01609f
C31742 _679_/a_843_236# hold95/a_438_182# 0
C31743 clknet_4_3_0_clk _678_/a_298_337# 0.01305f
C31744 _690_/a_741_93# net157 0
C31745 net51 _459_/a_27_156# 0.00838f
C31746 clknet_4_11_0_clk _703_/a_550_127# 0
C31747 baud_inst.counter\[28\] _549_/a_155_412# 0
C31748 _091_ _677_/a_843_236# 0
C31749 tx_data[0] _656_/a_298_337# 0
C31750 baud_inst.counter\[8\] _092_ 0.01348f
C31751 hold177/a_56_118# net39 0
C31752 _650_/a_324_432# net119 0.00308f
C31753 _650_/a_741_93# _061_ 0.00267f
C31754 net132 FILLER_26_151/a_32_246# 0.01408f
C31755 _663_/a_1489_191# clknet_0_clk 0.018f
C31756 net178 _101_ 0
C31757 net131 net78 0.02468f
C31758 rx_inst.data_reg\[2\] net150 0.32021f
C31759 _230_ _407_/a_146_122# 0
C31760 _122_ FILLER_21_229/a_32_246# 0.02742f
C31761 net45 _314_ 0.02554f
C31762 VPWR _703_/a_38_114# 0
C31763 _643_/a_2002_114# clknet_0_clk 0
C31764 net41 _388_/a_59_156# 0
C31765 _167_ _136_ 0.10773f
C31766 net48 hold125/a_326_118# 0.01961f
C31767 net146 _275_ 0.00184f
C31768 _688_/a_612_127# net161 0.00152f
C31769 FILLER_29_221/a_32_246# hold82/a_438_182# 0.00985f
C31770 tx_inst.bit_index\[0\] _142_ 0
C31771 _136_ _647_/a_741_93# 0
C31772 _157_ _647_/a_1583_191# 0.04381f
C31773 _398_/a_115_308# _397_/a_165_412# 0
C31774 net42 tx_inst.bit_index\[0\] 0
C31775 clkbuf_0_clk/a_116_82# _205_ 0.04204f
C31776 _642_/a_741_93# _641_/a_1489_191# 0
C31777 hold147/a_56_118# _693_/a_1583_191# 0.00317f
C31778 _642_/a_1583_191# _641_/a_2250_412# 0
C31779 hold87/a_56_118# _517_/a_380_412# 0
C31780 _341_/a_71_118# tx_inst.data_reg\[2\] 0.02939f
C31781 _341_/a_1453_124# clknet_4_4_0_clk 0.02036f
C31782 _460_/a_120_432# _168_ 0
C31783 _650_/a_843_236# _264_ 0
C31784 _450_/a_398_96# _161_ 0
C31785 output19/a_40_152# net2 0
C31786 _284_ net153 0
C31787 _230_ _453_/a_170_412# 0
C31788 hold165/a_438_182# VPWR 0.01089f
C31789 _548_/a_76_160# _310_ 0
C31790 hold127/a_326_118# clknet_4_15_0_clk 0
C31791 _378_/a_59_156# net8 0
C31792 baud_inst.counter\[13\] _685_/a_298_337# 0.002f
C31793 net128 _296_ 0.00292f
C31794 hold162/a_56_118# net46 0.0016f
C31795 net36 FILLER_19_149/a_40_246# 0.03039f
C31796 _675_/a_1583_191# net60 0.0021f
C31797 _646_/a_298_337# net144 0.00101f
C31798 _511_/a_252_412# net108 0
C31799 _073_ _367_/a_170_412# 0
C31800 _116_ net67 0.00237f
C31801 _643_/a_324_432# net48 0
C31802 _065_ tx_inst.data_reg\[0\] 0.06091f
C31803 hold183/a_438_182# _220_ 0.03703f
C31804 hold183/a_326_118# _142_ 0.01501f
C31805 _671_/a_1489_191# _167_ 0
C31806 net115 baud_inst.counter\[9\] 0.01933f
C31807 hold119/a_56_118# _137_ 0
C31808 net48 hold144/a_56_118# 0.02469f
C31809 tx_inst.data_reg\[4\] net171 0
C31810 _679_/a_612_127# net29 0
C31811 _679_/a_1840_334# _037_ 0
C31812 net42 hold183/a_326_118# 0
C31813 hold167/a_56_118# _670_/a_843_236# 0
C31814 hold167/a_326_118# _670_/a_741_93# 0
C31815 _132_ _449_/a_27_156# 0
C31816 _046_ hold143/a_56_118# 0
C31817 FILLER_20_198/a_40_246# _157_ 0.01988f
C31818 _676_/a_324_432# _281_ 0
C31819 baud_inst.counter\[18\] _518_/a_45_160# 0
C31820 _690_/a_741_93# _298_ 0
C31821 hold67/a_438_182# net67 0
C31822 _431_/a_277_118# clknet_0_clk 0
C31823 _287_ _681_/a_2250_412# 0
C31824 _160_ _259_ 0.07185f
C31825 _296_ _014_ 0.35158f
C31826 VPWR _687_/a_1583_191# 0.00979f
C31827 net84 hold138/a_326_118# 0.00321f
C31828 _126_ _636_/a_1785_429# 0
C31829 net74 _636_/a_2250_412# 0.0031f
C31830 net49 baud_inst.counter\[15\] 0
C31831 _353_/a_146_122# _280_ 0
C31832 _655_/a_132_114# VPWR 0
C31833 _075_ _666_/a_2250_412# 0
C31834 clknet_4_7_0_clk _666_/a_1583_191# 0
C31835 clkbuf_4_12_0_clk/a_27_118# _170_ 0.0299f
C31836 net122 _676_/a_1840_334# 0
C31837 _126_ net48 0.19812f
C31838 tx_inst.data_reg\[0\] clkbuf_4_4_0_clk/a_27_118# 0
C31839 _519_/a_379_118# _295_ 0
C31840 _077_ _665_/a_38_114# 0.00138f
C31841 hold88/a_438_182# _295_ 0
C31842 hold86/a_56_118# baud_inst.counter\[1\] 0.03247f
C31843 _644_/a_2002_114# _158_ 0
C31844 net132 _440_/a_550_140# 0
C31845 _160_ _157_ 0
C31846 net166 net49 0.00288f
C31847 net45 _700_/a_612_127# 0
C31848 hold144/a_326_118# _259_ 0.00116f
C31849 hold57/a_438_182# _141_ 0.05431f
C31850 _089_ _685_/a_324_432# 0
C31851 VPWR _688_/a_2250_412# 0.00787f
C31852 net44 FILLER_16_70/a_40_246# 0
C31853 _345_/a_252_412# _178_ 0
C31854 net79 FILLER_0_35/a_40_246# 0
C31855 VPWR _476_/a_248_122# 0
C31856 _432_/a_350_122# net32 0
C31857 net49 _692_/a_843_236# 0.00728f
C31858 baud_inst.counter\[21\] _695_/a_612_127# 0
C31859 baud_inst.counter\[23\] _695_/a_2250_412# 0.02056f
C31860 baud_inst.counter\[22\] _695_/a_1840_334# 0
C31861 FILLER_19_178/a_40_246# _057_ 0.00384f
C31862 baud_inst.counter\[28\] net58 0.12945f
C31863 fanout45/a_40_152# _302_ 0
C31864 net14 hold71/a_438_182# 0
C31865 hold170/a_438_182# _214_ 0
C31866 baud_inst.counter\[12\] net88 0.00487f
C31867 _660_/a_2250_412# clk 0.00758f
C31868 net79 _679_/a_741_93# 0
C31869 _645_/a_1489_191# _158_ 0
C31870 _675_/a_132_114# _088_ 0
C31871 _651_/a_2250_412# _666_/a_38_114# 0
C31872 _284_ _280_ 0.24587f
C31873 net92 _036_ 1.1397f
C31874 _643_/a_741_93# _157_ 0
C31875 net175 net24 0.02925f
C31876 clknet_0_clk _684_/a_1489_191# 0.00229f
C31877 net31 _238_ 0
C31878 FILLER_1_90/a_32_246# net4 0
C31879 baud_inst.counter\[19\] _101_ 0
C31880 net167 hold90/a_56_118# 0
C31881 _245_ FILLER_26_172/a_40_246# 0.01985f
C31882 _361_/a_146_122# _173_ 0
C31883 _677_/a_298_337# clknet_4_1_0_clk 0
C31884 hold178/a_56_118# VPWR 0.02509f
C31885 baud_inst.counter\[26\] hold113/a_438_182# 0
C31886 _177_ hold113/a_326_118# 0
C31887 _152_ net27 0
C31888 _529_/a_139_160# _296_ 0
C31889 _661_/a_843_236# net165 0
C31890 _656_/a_2250_412# _380_/a_382_118# 0
C31891 fanout43/a_40_152# net43 0
C31892 FILLER_0_115/a_40_246# FILLER_0_117/a_32_246# 0.0524f
C31893 _653_/a_1583_191# net43 0.02446f
C31894 _095_ _682_/a_843_236# 0
C31895 _696_/a_612_127# net90 0
C31896 hold126/a_326_118# _462_/a_22_110# 0
C31897 net141 net46 0.02568f
C31898 _166_ _666_/a_1785_429# 0.00153f
C31899 _663_/a_1840_334# tx_inst.state\[4\] 0
C31900 _508_/a_209_168# _508_/a_474_130# 0
C31901 _661_/a_843_236# FILLER_3_123/a_32_246# 0
C31902 net98 _682_/a_612_127# 0.00907f
C31903 _009_ _682_/a_550_127# 0
C31904 _676_/a_1583_191# _670_/a_843_236# 0
C31905 rx _704_/a_1583_191# 0.01726f
C31906 net89 net87 0.0284f
C31907 net105 net49 0.01422f
C31908 _158_ net83 0
C31909 clknet_4_13_0_clk _632_/a_612_127# 0
C31910 net71 net30 0.00317f
C31911 _048_ hold83/a_56_118# 0.00413f
C31912 _200_ net11 0.12686f
C31913 _669_/a_741_93# net29 0.00376f
C31914 _674_/a_843_236# _504_/a_209_168# 0
C31915 _662_/a_1785_429# _042_ 0
C31916 _040_ _706_/a_1785_429# 0
C31917 _687_/a_2250_412# _541_/a_380_412# 0
C31918 clknet_4_15_0_clk _649_/a_1489_191# 0
C31919 _358_/a_166_436# _186_ 0
C31920 baud_inst.counter\[12\] net39 0
C31921 _171_ net26 0.41891f
C31922 net74 _157_ 0
C31923 _634_/a_741_93# hold82/a_438_182# 0.00168f
C31924 _634_/a_843_236# hold82/a_326_118# 0.00189f
C31925 baud_inst.counter\[10\] net29 0.02971f
C31926 FILLER_9_79/a_32_246# _280_ 0.00598f
C31927 _639_/a_1840_334# rx_inst.state\[1\] 0.00148f
C31928 baud_inst.counter\[28\] _028_ 0
C31929 _682_/a_1489_191# clknet_4_2_0_clk 0
C31930 _170_ net26 0.00915f
C31931 rx_inst.bit_index\[2\] VPWR 0.77471f
C31932 _206_ _198_ 0.03534f
C31933 baud_inst.counter\[28\] hold133/a_326_118# 0.0087f
C31934 _695_/a_1840_334# FILLER_22_54/a_40_246# 0
C31935 tx_inst.data_reg\[5\] _339_/a_810_118# 0.00213f
C31936 _248_ _436_/a_550_140# 0
C31937 _222_ _400_/a_192_429# 0.00959f
C31938 hold112/a_56_118# _232_ 0.006f
C31939 net36 _455_/a_155_412# 0
C31940 _672_/a_298_337# clknet_4_0_0_clk 0
C31941 hold153/a_56_118# clkbuf_4_3_0_clk/a_27_118# 0.08454f
C31942 hold98/a_326_118# net39 0
C31943 _671_/a_741_93# _235_ 0
C31944 net49 _690_/a_1489_191# 0.00209f
C31945 _671_/a_324_432# _140_ 0
C31946 clknet_4_11_0_clk VPWR 0.82855f
C31947 _170_ net32 1.07567f
C31948 baud_inst.counter\[19\] _688_/a_2002_114# 0
C31949 _462_/a_120_432# net70 0.00522f
C31950 net159 _655_/a_1840_334# 0
C31951 net72 _634_/a_324_432# 0.00131f
C31952 _048_ _634_/a_741_93# 0.02929f
C31953 _637_/a_1489_191# _634_/a_1583_191# 0
C31954 net48 _647_/a_1489_191# 0.00791f
C31955 _632_/a_612_127# net65 0
C31956 _023_ hold147/a_56_118# 0.00436f
C31957 net75 hold147/a_438_182# 0
C31958 _305_ hold147/a_326_118# 0
C31959 VPWR _196_ 0.09614f
C31960 input2/a_40_152# _707_/a_1583_191# 0
C31961 rx _707_/a_843_236# 0
C31962 net2 _707_/a_741_93# 0.0057f
C31963 hold138/a_438_182# _635_/a_324_432# 0
C31964 hold138/a_56_118# _635_/a_843_236# 0
C31965 net114 _695_/a_2250_412# 0
C31966 hold138/a_326_118# _635_/a_741_93# 0
C31967 _365_/a_257_140# _197_ 0.00131f
C31968 _395_/a_146_122# _166_ 0
C31969 hold85/a_56_118# hold138/a_56_118# 0.06338f
C31970 _454_/a_257_140# _263_ 0.00322f
C31971 _705_/a_298_337# _275_ 0
C31972 net26 hold62/a_56_118# 0
C31973 _675_/a_843_236# _087_ 0.00508f
C31974 _661_/a_2002_114# tx_inst.data_reg\[7\] 0.00103f
C31975 hold145/a_326_118# clknet_4_4_0_clk 0.01036f
C31976 FILLER_16_176/a_40_246# net51 0
C31977 _702_/a_132_114# net68 0
C31978 rx_inst.bit_index\[2\] _239_ 0
C31979 net113 _165_ 0.03965f
C31980 _284_ _191_ 0
C31981 _117_ _705_/a_132_114# 0
C31982 net87 _310_ 0
C31983 net24 _161_ 0.16424f
C31984 net62 _651_/a_2250_412# 0.00193f
C31985 net32 hold62/a_56_118# 0.00252f
C31986 _170_ hold62/a_326_118# 0
C31987 tx_inst.data_reg\[4\] net184 0
C31988 hold89/a_56_118# clknet_0_clk 0.00188f
C31989 net47 hold72/a_56_118# 0
C31990 FILLER_21_31/a_40_246# _693_/a_2250_412# 0
C31991 hold179/a_326_118# _065_ 0
C31992 baud_inst.counter\[17\] _684_/a_38_114# 0
C31993 _181_ _085_ 0.0255f
C31994 net66 _122_ 0.88879f
C31995 net34 net41 0.04795f
C31996 FILLER_5_164/a_40_246# _173_ 0.00279f
C31997 _243_ VPWR 0.13577f
C31998 net67 hold105/a_438_182# 0
C31999 net106 _701_/a_324_432# 0
C32000 _029_ _701_/a_38_114# 0.00106f
C32001 baud_inst.counter\[20\] _693_/a_324_432# 0.0011f
C32002 _652_/a_612_127# net43 0
C32003 hold78/a_438_182# _159_ 0
C32004 hold168/a_438_182# _664_/a_741_93# 0
C32005 hold168/a_326_118# _664_/a_843_236# 0
C32006 baud_inst.counter\[12\] _516_/a_165_412# 0.00119f
C32007 _519_/a_81_118# _294_ 0.00116f
C32008 net35 _131_ 0
C32009 hold67/a_56_118# _702_/a_1583_191# 0.00294f
C32010 _678_/a_324_432# net137 0
C32011 _080_ net43 0.05863f
C32012 FILLER_12_173/a_32_246# VPWR 0.06318f
C32013 hold69/a_56_118# rx_data[6] 0.00439f
C32014 net48 _224_ 0
C32015 _339_/a_1377_160# clkbuf_4_4_0_clk/a_27_118# 0
C32016 FILLER_12_89/a_40_246# net39 0
C32017 _164_ FILLER_17_22/a_40_246# 0.01656f
C32018 net44 _544_/a_46_156# 0.01504f
C32019 _158_ _470_/a_22_110# 0.0265f
C32020 _283_ _652_/a_298_337# 0
C32021 net58 _703_/a_843_236# 0.00162f
C32022 _032_ _703_/a_324_432# 0.02779f
C32023 _541_/a_209_168# _308_ 0.01469f
C32024 clknet_0_clk _649_/a_681_505# 0
C32025 _342_/a_170_412# net27 0
C32026 _174_ _359_/a_22_110# 0
C32027 _175_ _359_/a_120_432# 0
C32028 _114_ baud_inst.counter\[29\] 0.00107f
C32029 clknet_4_14_0_clk _425_/a_46_156# 0
C32030 _646_/a_1583_191# VPWR 0.00565f
C32031 clknet_4_3_0_clk _678_/a_1583_191# 0.04339f
C32032 _356_/a_248_122# baud_inst.counter\[14\] 0
C32033 _698_/a_1583_191# net46 0
C32034 baud_inst.counter\[28\] _027_ 0.00338f
C32035 _357_/a_354_412# net40 0.00136f
C32036 _650_/a_1583_191# rx_inst.data_reg\[7\] 0.00153f
C32037 hold101/a_438_182# _690_/a_324_432# 0
C32038 hold101/a_326_118# _690_/a_741_93# 0.0011f
C32039 hold101/a_56_118# _690_/a_843_236# 0.00232f
C32040 _489_/a_115_308# net181 0.01748f
C32041 tx_inst.state\[1\] clknet_0_clk 0
C32042 hold126/a_56_118# hold72/a_438_182# 0
C32043 net31 net36 1.2572f
C32044 _243_ _239_ 0.01052f
C32045 net179 FILLER_5_213/a_32_246# 0.01874f
C32046 _216_ _651_/a_1489_191# 0
C32047 VPWR _703_/a_1840_334# 0.00362f
C32048 _292_ _037_ 0
C32049 tx_inst.data_reg\[7\] FILLER_0_130/a_32_246# 0
C32050 hold118/a_56_118# VPWR 0.00868f
C32051 tx_data[4] tx_data[5] 1.56825f
C32052 FILLER_1_30/a_32_246# hold61/a_438_182# 0.00985f
C32053 net179 _214_ 0.15225f
C32054 _339_/a_1453_124# VPWR 0.00365f
C32055 hold129/a_326_118# net29 0.03529f
C32056 net37 _247_ 0.03395f
C32057 _355_/a_252_412# VPWR 0
C32058 _135_ _236_ 0
C32059 fanout29/a_40_152# hold91/a_56_118# 0.00117f
C32060 _157_ _647_/a_2002_114# 0
C32061 baud_inst.counter\[20\] _535_/a_248_122# 0.00447f
C32062 net176 _110_ 0.00485f
C32063 _052_ net142 0
C32064 clknet_4_4_0_clk _203_ 0
C32065 _398_/a_115_308# _219_ 0.01733f
C32066 _398_/a_358_436# _218_ 0
C32067 _414_/a_279_412# net29 0
C32068 _642_/a_681_505# net176 0
C32069 _053_ _641_/a_132_114# 0
C32070 _438_/a_146_122# _161_ 0.00185f
C32071 hold147/a_326_118# _693_/a_1489_191# 0
C32072 clknet_4_12_0_clk _641_/a_843_236# 0.00825f
C32073 _555_/a_209_168# baud_inst.counter\[29\] 0.01053f
C32074 FILLER_2_79/a_40_246# net86 0
C32075 _537_/a_341_118# _693_/a_741_93# 0
C32076 _341_/a_1377_160# clknet_4_4_0_clk 0.04194f
C32077 _129_ _168_ 0
C32078 _061_ _456_/a_257_140# 0.00295f
C32079 net119 _456_/a_155_412# 0.05872f
C32080 _650_/a_612_127# _264_ 0
C32081 net53 _641_/a_38_114# 0
C32082 _312_ _310_ 0.00318f
C32083 _633_/a_324_432# _648_/a_741_93# 0
C32084 _633_/a_741_93# _648_/a_324_432# 0
C32085 _206_ tx_data[5] 0
C32086 _390_/a_59_156# VPWR 0.06483f
C32087 _680_/a_38_114# VPWR 0.02293f
C32088 baud_inst.counter\[13\] _685_/a_1583_191# 0.00799f
C32089 net28 _667_/a_741_93# 0
C32090 _699_/a_741_93# hold114/a_56_118# 0.00612f
C32091 _699_/a_38_114# hold114/a_438_182# 0
C32092 _699_/a_324_432# hold114/a_326_118# 0
C32093 rx_inst.bit_index\[2\] _167_ 0
C32094 _088_ _085_ 0
C32095 _675_/a_2002_114# net60 0
C32096 baud_inst.counter\[3\] _491_/a_192_429# 0
C32097 _675_/a_1489_191# _181_ 0
C32098 _158_ net77 0.00324f
C32099 _651_/a_843_236# clknet_0_clk 0
C32100 VPWR net64 0.33627f
C32101 _040_ _200_ 0
C32102 hold156/a_326_118# _288_ 0.00363f
C32103 clknet_4_12_0_clk _647_/a_843_236# 0.03194f
C32104 clk _654_/a_843_236# 0.00515f
C32105 _650_/a_741_93# _156_ 0
C32106 _468_/a_22_110# net19 0
C32107 clknet_4_12_0_clk _260_ 0
C32108 net48 _235_ 0
C32109 rx_inst.bit_index\[2\] _225_ 0.6763f
C32110 _198_ _202_ 0.02774f
C32111 _103_ _523_/a_155_412# 0
C32112 clkbuf_4_8_0_clk/a_27_118# _687_/a_2250_412# 0.00201f
C32113 net18 net72 0
C32114 _440_/a_142_412# _253_ 0
C32115 _699_/a_681_505# _313_ 0
C32116 _041_ net43 0.09588f
C32117 hold177/a_326_118# _294_ 0
C32118 hold177/a_56_118# _012_ 0.00164f
C32119 _098_ net90 0.00248f
C32120 hold170/a_326_118# tx_inst.data_reg\[0\] 0
C32121 net38 _066_ 0.21971f
C32122 _006_ _200_ 0
C32123 rx_inst.data_reg\[0\] _649_/a_2250_412# 0
C32124 _643_/a_1583_191# hold143/a_326_118# 0
C32125 hold113/a_326_118# VPWR 0.00776f
C32126 _643_/a_324_432# net143 0
C32127 net142 FILLER_20_95/a_40_246# 0.02355f
C32128 net7 FILLER_0_80/a_40_246# 0
C32129 _227_ hold175/a_56_118# 0
C32130 tx_inst.state\[1\] _704_/a_298_337# 0.00266f
C32131 clknet_4_7_0_clk _704_/a_38_114# 0.03263f
C32132 output12/a_40_152# _637_/a_2250_412# 0
C32133 _655_/a_1489_191# VPWR 0.00299f
C32134 _223_ _416_/a_350_122# 0
C32135 net32 _237_ 0.00171f
C32136 clknet_4_13_0_clk _635_/a_1583_191# 0
C32137 _177_ _541_/a_209_168# 0
C32138 baud_inst.counter\[27\] _541_/a_380_412# 0
C32139 tx_inst.data_reg\[6\] FILLER_0_174/a_32_246# 0
C32140 hold158/a_438_182# _016_ 0.00365f
C32141 tx_data[2] _384_/a_382_118# 0.00326f
C32142 _283_ _186_ 0.00136f
C32143 _096_ net40 0
C32144 clk FILLER_3_207/a_40_246# 0
C32145 _206_ _666_/a_2250_412# 0
C32146 _663_/a_1489_191# net43 0.00145f
C32147 net55 _380_/a_59_156# 0.01843f
C32148 _661_/a_1583_191# _658_/a_298_337# 0
C32149 baud_inst.counter\[15\] FILLER_17_81/a_32_246# 0
C32150 FILLER_26_35/a_32_246# _694_/a_843_236# 0
C32151 net45 net134 0.12885f
C32152 net106 hold105/a_326_118# 0
C32153 clkbuf_4_14_0_clk/a_27_118# net24 0
C32154 baud_inst.counter\[8\] net117 0
C32155 _183_ hold95/a_326_118# 0
C32156 hold142/a_438_182# _697_/a_612_127# 0
C32157 _171_ net50 0
C32158 _646_/a_1840_334# net30 0
C32159 _646_/a_1583_191# _266_ 0.00351f
C32160 baud_inst.counter\[21\] net76 0.17244f
C32161 net49 _692_/a_612_127# 0
C32162 hold137/a_56_118# net137 0
C32163 _170_ FILLER_25_150/a_32_246# 0
C32164 _698_/a_324_432# clknet_0_clk 0.02166f
C32165 baud_inst.counter\[27\] _549_/a_257_140# 0
C32166 _633_/a_1489_191# net77 0
C32167 _505_/a_272_160# _182_ 0
C32168 _240_ _416_/a_350_122# 0
C32169 hold127/a_56_118# clknet_0_clk 0.00195f
C32170 net177 hold130/a_438_182# 0
C32171 net28 FILLER_15_162/a_40_246# 0
C32172 rx_inst.data_reg\[2\] _158_ 0.16741f
C32173 tx_inst.data_reg\[0\] VPWR 0.49488f
C32174 tx_inst.bit_index\[2\] _398_/a_115_308# 0.05749f
C32175 net42 _277_ 0
C32176 hold108/a_438_182# baud_inst.counter\[13\] 0
C32177 hold118/a_326_118# net30 0.01163f
C32178 _662_/a_843_236# net55 0.00692f
C32179 clknet_4_7_0_clk _215_ 0
C32180 clknet_4_13_0_clk _650_/a_38_114# 0
C32181 net173 _194_ 0.22607f
C32182 _250_ _235_ 0
C32183 _157_ _140_ 0
C32184 tx_inst.data_reg\[4\] _341_/a_71_118# 0.01194f
C32185 hold163/a_326_118# _305_ 0
C32186 baud_inst.counter\[20\] _537_/a_341_118# 0.0014f
C32187 clknet_4_14_0_clk _264_ 0.09295f
C32188 tx_inst.data_reg\[7\] _388_/a_59_156# 0
C32189 _661_/a_2250_412# _146_ 0
C32190 _067_ _380_/a_59_156# 0
C32191 _656_/a_1840_334# net170 0
C32192 _379_/a_46_156# net165 0
C32193 _656_/a_1583_191# _208_ 0.01317f
C32194 hold160/a_56_118# net40 0
C32195 _641_/a_324_432# net175 0
C32196 _641_/a_298_337# net24 0
C32197 _095_ _682_/a_612_127# 0
C32198 _286_ FILLER_9_72/a_32_246# 0
C32199 _515_/a_170_160# fanout29/a_40_152# 0
C32200 hold126/a_438_182# _128_ 0.0186f
C32201 _390_/a_285_412# net159 0
C32202 _171_ FILLER_5_181/a_32_246# 0.02551f
C32203 _009_ clknet_4_2_0_clk 0.15894f
C32204 rx _704_/a_2002_114# 0
C32205 net2 _704_/a_1489_191# 0.00917f
C32206 _465_/a_22_110# _639_/a_741_93# 0
C32207 net43 _665_/a_38_114# 0.00191f
C32208 net118 _650_/a_681_505# 0
C32209 _153_ _650_/a_843_236# 0.01454f
C32210 net45 _703_/a_298_337# 0
C32211 _669_/a_1785_429# net29 0
C32212 clknet_4_15_0_clk rx_inst.data_reg\[6\] 0.17321f
C32213 hold132/a_438_182# net32 0
C32214 _632_/a_324_432# clknet_4_15_0_clk 0
C32215 _674_/a_843_236# _287_ 0
C32216 _674_/a_741_93# _038_ 0
C32217 clknet_4_7_0_clk hold51/a_56_118# 0.00122f
C32218 hold162/a_438_182# clknet_0_clk 0
C32219 _643_/a_298_337# clknet_4_12_0_clk 0
C32220 _639_/a_843_236# _264_ 0
C32221 hold58/a_438_182# net49 0.00477f
C32222 net30 _273_ 0.02937f
C32223 net147 _694_/a_324_432# 0
C32224 _266_ net64 0.04337f
C32225 _481_/a_120_432# net168 0.00116f
C32226 net109 _682_/a_324_432# 0
C32227 _634_/a_1583_191# hold72/a_56_118# 0
C32228 _694_/a_324_432# net46 0.01411f
C32229 VPWR _508_/a_474_130# 0
C32230 _697_/a_741_93# _025_ 0
C32231 _646_/a_741_93# FILLER_20_198/a_40_246# 0.00238f
C32232 FILLER_1_90/a_32_246# net40 0
C32233 _392_/a_382_118# net168 0
C32234 _693_/a_843_236# FILLER_24_19/a_40_246# 0
C32235 fanout24/a_40_152# _262_ 0
C32236 _141_ net183 0.13359f
C32237 _248_ _249_ 0.00326f
C32238 clkbuf_4_10_0_clk/a_27_118# _699_/a_38_114# 0
C32239 _432_/a_248_122# net49 0
C32240 _251_ net52 0
C32241 _429_/a_244_412# VPWR 0.00396f
C32242 net36 _130_ 0
C32243 _672_/a_1583_191# clknet_4_0_0_clk 0.00325f
C32244 _128_ net70 0.02595f
C32245 _195_ clknet_4_4_0_clk 0.00134f
C32246 hold108/a_326_118# FILLER_9_70/a_40_246# 0
C32247 _048_ _634_/a_1785_429# 0
C32248 net17 _634_/a_1583_191# 0
C32249 VPWR _365_/a_155_412# 0.03153f
C32250 hold59/a_438_182# net105 0
C32251 net2 _707_/a_1785_429# 0.00193f
C32252 _446_/a_146_122# _223_ 0
C32253 _215_ _007_ 0
C32254 fanout41/a_40_152# hold137/a_326_118# 0
C32255 net27 net168 1.09864f
C32256 hold85/a_438_182# rx_inst.data_reg\[4\] 0.01358f
C32257 _537_/a_192_429# _305_ 0.02228f
C32258 _644_/a_38_114# net48 0.00121f
C32259 hold112/a_438_182# net47 0
C32260 _152_ hold50/a_326_118# 0
C32261 _705_/a_1583_191# _275_ 0
C32262 _675_/a_612_127# _087_ 0
C32263 _083_ net167 0
C32264 net55 input3/a_40_152# 0.00799f
C32265 _207_ net4 0.00411f
C32266 net34 _171_ 0
C32267 _646_/a_741_93# _160_ 0
C32268 _692_/a_298_337# _105_ 0.01253f
C32269 net143 _647_/a_1489_191# 0
C32270 _662_/a_298_337# _198_ 0
C32271 _658_/a_38_114# net41 0.00475f
C32272 _182_ _502_/a_165_412# 0
C32273 tx_inst.data_reg\[5\] _652_/a_324_432# 0
C32274 hold122/a_438_182# _374_/a_244_412# 0
C32275 _645_/a_298_337# net48 0.00887f
C32276 _424_/a_244_412# clknet_0_clk 0.00182f
C32277 baud_inst.counter\[20\] _693_/a_2250_412# 0.06138f
C32278 baud_inst.counter\[27\] FILLER_23_83/a_32_246# 0.01407f
C32279 FILLER_1_173/a_32_246# _206_ 0.00158f
C32280 _096_ _682_/a_741_93# 0.00106f
C32281 _683_/a_38_114# clknet_4_2_0_clk 0
C32282 _163_ _688_/a_2250_412# 0
C32283 net128 _294_ 0.69958f
C32284 baud_inst.counter\[12\] _012_ 0.17157f
C32285 _550_/a_209_168# VPWR 0.00632f
C32286 hold165/a_56_118# clk 0
C32287 FILLER_16_166/a_32_246# fanout32/a_40_152# 0
C32288 _125_ _636_/a_38_114# 0
C32289 hold67/a_326_118# _702_/a_1489_191# 0
C32290 _678_/a_2250_412# net137 0.00746f
C32291 _109_ _541_/a_177_436# 0
C32292 _696_/a_324_432# _294_ 0
C32293 _306_ _548_/a_76_160# 0
C32294 FILLER_25_177/a_40_246# _429_/a_244_412# 0
C32295 _165_ baud_inst.counter\[29\] 0.00183f
C32296 net48 FILLER_29_165/a_40_246# 0.00339f
C32297 _045_ _634_/a_324_432# 0.0226f
C32298 hold65/a_56_118# net18 0.00177f
C32299 hold65/a_438_182# net70 0.00702f
C32300 hold128/a_56_118# clknet_4_9_0_clk 0
C32301 hold77/a_326_118# _648_/a_1840_334# 0
C32302 rx_data[2] _271_ 0
C32303 net14 _124_ 0.0138f
C32304 _032_ _703_/a_2250_412# 0
C32305 net58 _703_/a_612_127# 0
C32306 hold107/a_56_118# _313_ 0
C32307 _633_/a_741_93# _123_ 0.0222f
C32308 _175_ _192_ 0.00595f
C32309 hold89/a_438_182# baud_inst.counter\[14\] 0.00206f
C32310 hold151/a_438_182# net47 0.01375f
C32311 rx_inst.bit_index\[0\] _242_ 0
C32312 _090_ _676_/a_741_93# 0
C32313 net39 _676_/a_843_236# 0.04102f
C32314 hold167/a_56_118# net26 0
C32315 clknet_4_3_0_clk hold95/a_326_118# 0.02538f
C32316 clknet_4_3_0_clk _678_/a_2002_114# 0
C32317 hold153/a_56_118# hold93/a_56_118# 0
C32318 _103_ net157 0
C32319 hold101/a_438_182# _164_ 0
C32320 _460_/a_22_110# net19 0.00217f
C32321 input3/a_40_152# _067_ 0.00396f
C32322 _190_ net40 0.03566f
C32323 _671_/a_843_236# _084_ 0
C32324 net39 _683_/a_843_236# 0
C32325 hold85/a_326_118# _047_ 0
C32326 hold178/a_56_118# _163_ 0
C32327 net16 _168_ 0
C32328 rx_data[1] VPWR 0.02054f
C32329 _360_/a_886_118# hold165/a_326_118# 0
C32330 _059_ _633_/a_324_432# 0
C32331 _339_/a_1377_160# VPWR 0.00352f
C32332 _691_/a_38_114# VPWR 0.00356f
C32333 FILLER_19_228/a_40_246# _264_ 0.00374f
C32334 _025_ clknet_0_clk 0.005f
C32335 _249_ net139 0
C32336 rx_inst.bit_index\[2\] _428_/a_252_412# 0.00214f
C32337 hold136/a_438_182# clknet_4_0_0_clk 0
C32338 clknet_4_4_0_clk _401_/a_22_110# 0
C32339 VPWR _541_/a_209_168# 0.00645f
C32340 _044_ net78 0.13849f
C32341 _159_ _633_/a_324_432# 0.03006f
C32342 _216_ _219_ 0.03363f
C32343 _143_ _218_ 0
C32344 FILLER_13_100/a_40_246# baud_inst.counter\[12\] 0
C32345 clknet_4_12_0_clk _641_/a_612_127# 0.0025f
C32346 clknet_4_5_0_clk hold168/a_326_118# 0.009f
C32347 hold77/a_56_118# net124 0.00108f
C32348 hold76/a_56_118# baud_inst.counter\[20\] 0.00597f
C32349 _706_/a_38_114# net172 0
C32350 net119 _264_ 0.00571f
C32351 net48 _649_/a_298_337# 0.00202f
C32352 net75 _693_/a_1583_191# 0
C32353 _410_/a_257_140# net26 0.0032f
C32354 _230_ _642_/a_741_93# 0.00109f
C32355 _179_ net45 0
C32356 hold179/a_326_118# VPWR 0.01174f
C32357 hold59/a_326_118# _700_/a_2250_412# 0
C32358 _633_/a_1840_334# _648_/a_843_236# 0
C32359 _394_/a_22_110# clkbuf_4_5_0_clk/a_27_118# 0
C32360 _699_/a_1583_191# clknet_0_clk 0.00174f
C32361 baud_inst.counter\[10\] _288_ 0.31119f
C32362 _083_ _676_/a_1489_191# 0
C32363 baud_inst.counter\[14\] _544_/a_268_412# 0
C32364 hold74/a_56_118# hold118/a_438_182# 0.00367f
C32365 _412_/a_22_110# rx_inst.state\[2\] 0
C32366 _227_ _410_/a_155_412# 0
C32367 hold74/a_326_118# hold118/a_326_118# 0.0024f
C32368 hold74/a_438_182# hold118/a_56_118# 0.00367f
C32369 _643_/a_843_236# _473_/a_22_110# 0
C32370 _680_/a_1840_334# VPWR 0
C32371 _012_ net39 0
C32372 baud_inst.counter\[13\] _685_/a_2002_114# 0
C32373 baud_inst.counter\[3\] _181_ 0.00188f
C32374 fanout25/a_40_152# net25 0.01049f
C32375 FILLER_24_133/a_32_246# _254_ 0.01283f
C32376 _656_/a_741_93# net41 0
C32377 clknet_4_12_0_clk _647_/a_612_127# 0
C32378 net146 net50 1.42771f
C32379 _075_ _081_ 0
C32380 _418_/a_268_412# net24 0
C32381 _414_/a_165_412# net37 0.00141f
C32382 _158_ _253_ 0.13719f
C32383 FILLER_4_100/a_40_246# _655_/a_1583_191# 0.00119f
C32384 VPWR _458_/a_165_412# 0
C32385 hold99/a_438_182# VPWR 0.00422f
C32386 net136 FILLER_6_21/a_40_246# 0
C32387 hold132/a_326_118# _242_ 0
C32388 _428_/a_252_412# _243_ 0.0024f
C32389 _384_/a_382_118# _210_ 0.04292f
C32390 tx_inst.bit_index\[1\] _659_/a_2250_412# 0
C32391 hold111/a_438_182# _632_/a_38_114# 0
C32392 _090_ _185_ 0
C32393 clknet_4_7_0_clk _704_/a_1840_334# 0
C32394 _388_/a_382_118# _388_/a_496_118# 0
C32395 hold170/a_56_118# tx_inst.data_reg\[6\] 0.03204f
C32396 _678_/a_298_337# clknet_0_clk 0
C32397 tx_inst.data_reg\[1\] VPWR 0.42566f
C32398 hold156/a_56_118# _682_/a_1489_191# 0
C32399 baud_inst.counter\[22\] net46 0.05605f
C32400 hold145/a_438_182# clknet_0_clk 0.00107f
C32401 baud_inst.counter\[7\] net40 0.13179f
C32402 hold57/a_326_118# VPWR 0.00373f
C32403 hold104/a_326_118# net104 0
C32404 input5/a_40_152# _148_ 0.0287f
C32405 tx_inst.state\[1\] net43 0.04868f
C32406 FILLER_13_100/a_40_246# net39 0.00662f
C32407 clknet_4_3_0_clk _091_ 0.04337f
C32408 _097_ FILLER_15_42/a_40_246# 0
C32409 _206_ _659_/a_298_337# 0.00723f
C32410 hold53/a_326_118# _224_ 0
C32411 _283_ _511_/a_252_412# 0
C32412 _516_/a_165_412# _012_ 0.00213f
C32413 _045_ net18 0
C32414 hold142/a_438_182# net142 0.0134f
C32415 _063_ baud_inst.counter\[4\] 0.01125f
C32416 hold104/a_438_182# net163 0
C32417 _646_/a_2002_114# _266_ 0
C32418 _159_ FILLER_26_151/a_32_246# 0.00209f
C32419 net121 hold148/a_56_118# 0.02454f
C32420 _688_/a_1583_191# baud_inst.counter\[16\] 0.00714f
C32421 net49 net164 0.00164f
C32422 net14 net82 0.14444f
C32423 _693_/a_38_114# net149 0.02491f
C32424 _698_/a_2250_412# clknet_0_clk 0.04557f
C32425 clk _191_ 0
C32426 net30 FILLER_28_204/a_32_246# 0.00402f
C32427 net49 FILLER_25_141/a_32_246# 0.00118f
C32428 _638_/a_681_505# _273_ 0
C32429 _635_/a_1489_191# _122_ 0
C32430 tx_inst.bit_index\[2\] _216_ 0.05703f
C32431 tx_inst.state\[1\] _707_/a_843_236# 0
C32432 clknet_4_7_0_clk _707_/a_681_505# 0
C32433 _293_ FILLER_12_82/a_32_246# 0
C32434 net2 fanout35/a_40_152# 0
C32435 baud_inst.counter\[3\] _088_ 0
C32436 hold179/a_56_118# net179 0.01635f
C32437 _662_/a_612_127# net55 0.00876f
C32438 _639_/a_1583_191# rx_inst.data_reg\[7\] 0
C32439 clknet_4_13_0_clk _650_/a_1840_334# 0.01232f
C32440 _531_/a_474_130# net163 0
C32441 net184 _396_/a_155_412# 0
C32442 hold130/a_56_118# baud_inst.counter\[13\] 0.00531f
C32443 clknet_4_0_0_clk FILLER_5_59/a_40_246# 0.01313f
C32444 net38 _681_/a_38_114# 0.04193f
C32445 hold150/a_326_118# VPWR 0.00996f
C32446 rx_inst.bit_index\[2\] _232_ 0.04353f
C32447 net149 FILLER_25_9/a_32_246# 0
C32448 _675_/a_38_114# net61 0.01953f
C32449 _675_/a_1583_191# hold61/a_56_118# 0
C32450 _699_/a_741_93# net105 0
C32451 _078_ hold169/a_56_118# 0
C32452 _656_/a_2002_114# _208_ 0
C32453 FILLER_22_54/a_40_246# net46 0
C32454 _641_/a_2250_412# net175 0.00115f
C32455 _641_/a_1583_191# net24 0.01064f
C32456 _360_/a_1377_160# net54 0.00271f
C32457 _090_ _677_/a_681_505# 0
C32458 _125_ rx_data[7] 0.00247f
C32459 _556_/a_192_429# _316_ 0.02421f
C32460 net100 net99 0.21034f
C32461 baud_inst.counter\[18\] baud_inst.counter\[15\] 0
C32462 net82 _637_/a_741_93# 0
C32463 FILLER_2_79/a_40_246# net38 0.01119f
C32464 FILLER_17_162/a_32_246# net25 0.00139f
C32465 output17/a_40_152# _637_/a_2250_412# 0
C32466 net43 _665_/a_1840_334# 0
C32467 _153_ _650_/a_612_127# 0
C32468 net72 hold71/a_326_118# 0
C32469 _048_ hold71/a_438_182# 0
C32470 rx_inst.data_reg\[1\] clknet_0_clk 0
C32471 _030_ _504_/a_209_168# 0
C32472 clkbuf_4_5_0_clk/a_27_118# FILLER_5_192/a_40_246# 0.00137f
C32473 hold117/a_56_118# _681_/a_1583_191# 0
C32474 clknet_4_3_0_clk _670_/a_324_432# 0
C32475 _409_/a_73_118# net51 0.03216f
C32476 _643_/a_1583_191# clknet_4_12_0_clk 0.00614f
C32477 _112_ _701_/a_1489_191# 0
C32478 _292_ _682_/a_1840_334# 0
C32479 _010_ _682_/a_1583_191# 0
C32480 net109 _682_/a_2250_412# 0.04561f
C32481 _694_/a_2250_412# net46 0.00362f
C32482 _352_/a_268_412# _185_ 0.00126f
C32483 _345_/a_354_412# net45 0
C32484 fanout43/a_40_152# net51 0.01255f
C32485 _246_ _223_ 0.00232f
C32486 net26 hold180/a_326_118# 0.00614f
C32487 _154_ net24 0.02194f
C32488 net48 _230_ 0
C32489 hold86/a_438_182# _181_ 0.01147f
C32490 _673_/a_843_236# _287_ 0.00295f
C32491 _415_/a_170_412# net32 0
C32492 clkbuf_4_12_0_clk/a_27_118# _247_ 0
C32493 baud_inst.counter\[28\] net49 3.20823f
C32494 FILLER_1_28/a_40_246# net61 0.01453f
C32495 hold159/a_56_118# net38 0
C32496 _657_/a_132_114# _209_ 0
C32497 hold184/a_326_118# _174_ 0
C32498 hold184/a_438_182# net34 0.00634f
C32499 _227_ hold180/a_56_118# 0.00958f
C32500 _672_/a_2002_114# clknet_4_0_0_clk 0
C32501 net30 _458_/a_279_412# 0
C32502 net28 _650_/a_843_236# 0
C32503 net37 _234_ 0.22321f
C32504 _126_ FILLER_17_201/a_32_246# 0
C32505 _673_/a_2250_412# hold60/a_438_182# 0
C32506 hold128/a_438_182# _293_ 0
C32507 _232_ _243_ 0
C32508 net33 _275_ 0.01847f
C32509 hold129/a_56_118# net90 0
C32510 rx net51 0
C32511 _258_ _223_ 0.16464f
C32512 _644_/a_1840_334# net48 0
C32513 net75 _023_ 0.58944f
C32514 net110 _682_/a_2250_412# 0
C32515 _432_/a_350_122# _137_ 0
C32516 net112 hold112/a_438_182# 0.01094f
C32517 _117_ net22 0
C32518 _248_ clknet_4_12_0_clk 0
C32519 net49 hold149/a_326_118# 0.00774f
C32520 hold147/a_438_182# _303_ 0.00175f
C32521 _688_/a_298_337# _016_ 0
C32522 _688_/a_324_432# net157 0.00307f
C32523 _692_/a_1583_191# _105_ 0
C32524 VPWR _418_/a_46_156# 0.01054f
C32525 _658_/a_1840_334# net41 0.01187f
C32526 clknet_4_1_0_clk _382_/a_59_156# 0
C32527 net154 _281_ 0.00122f
C32528 hold122/a_56_118# _204_ 0
C32529 _641_/a_2250_412# _161_ 0
C32530 _685_/a_298_337# net29 0.00409f
C32531 _645_/a_1583_191# net48 0.00653f
C32532 net45 hold113/a_56_118# 0.0042f
C32533 tx_data[1] FILLER_0_80/a_40_246# 0.02754f
C32534 _096_ _682_/a_1785_429# 0
C32535 _449_/a_27_156# _260_ 0.01102f
C32536 _270_ _636_/a_2250_412# 0.00821f
C32537 _125_ _636_/a_1840_334# 0.0112f
C32538 hold133/a_56_118# VPWR 0.04941f
C32539 baud_inst.counter\[22\] _313_ 0
C32540 hold153/a_326_118# _036_ 0
C32541 _132_ net2 0.00482f
C32542 fanout36/a_40_152# net24 0
C32543 _361_/a_248_122# tx_inst.bit_index\[2\] 0
C32544 hold57/a_56_118# net57 0
C32545 _646_/a_38_114# _054_ 0
C32546 _646_/a_324_432# net47 0
C32547 fanout30/a_40_152# net30 0
C32548 net58 net59 0.01021f
C32549 hold148/a_438_182# _105_ 0
C32550 net42 _666_/a_38_114# 0.01246f
C32551 net62 _667_/a_324_432# 0
C32552 _265_ hold81/a_56_118# 0.0019f
C32553 _633_/a_1785_429# _123_ 0
C32554 FILLER_21_147/a_40_246# net175 0.00401f
C32555 FILLER_7_82/a_32_246# _678_/a_38_114# 0
C32556 _004_ FILLER_14_164/a_32_246# 0
C32557 _155_ clkbuf_4_15_0_clk/a_27_118# 0
C32558 _112_ baud_inst.counter\[25\] 0
C32559 _206_ _385_/a_46_156# 0.0466f
C32560 _677_/a_324_432# baud_inst.counter\[6\] 0
C32561 net50 _705_/a_298_337# 0.00109f
C32562 _152_ _705_/a_741_93# 0
C32563 net39 _676_/a_612_127# 0.02974f
C32564 _424_/a_244_412# FILLER_26_172/a_40_246# 0
C32565 _207_ net40 0
C32566 net2 _191_ 0
C32567 net156 net160 0.63887f
C32568 net3 tx_inst.data_reg\[2\] 0
C32569 net55 FILLER_0_115/a_40_246# 0.02713f
C32570 hold101/a_326_118# _103_ 0
C32571 baud_inst.counter\[18\] _690_/a_1489_191# 0
C32572 _478_/a_27_156# _665_/a_843_236# 0.00103f
C32573 FILLER_17_81/a_32_246# _686_/a_2250_412# 0
C32574 _550_/a_474_130# _028_ 0
C32575 _160_ net24 0.00196f
C32576 _342_/a_170_412# _175_ 0.00186f
C32577 _089_ baud_inst.counter\[4\] 0.03904f
C32578 _080_ net51 0
C32579 _638_/a_324_432# VPWR 0.01196f
C32580 _639_/a_38_114# clknet_4_13_0_clk 0.00102f
C32581 _639_/a_324_432# net81 0.01498f
C32582 net26 _247_ 0
C32583 _059_ _633_/a_2250_412# 0
C32584 hold166/a_56_118# net180 0
C32585 _691_/a_1840_334# VPWR 0.02794f
C32586 _170_ _137_ 0.6066f
C32587 _696_/a_298_337# net99 0
C32588 net32 _247_ 0.05242f
C32589 _159_ _633_/a_2250_412# 0
C32590 _315_ hold107/a_326_118# 0
C32591 FILLER_4_100/a_40_246# _390_/a_382_118# 0
C32592 _282_ _505_/a_76_160# 0
C32593 _064_ clknet_4_4_0_clk 0.00851f
C32594 clknet_4_12_0_clk net176 0.1453f
C32595 _688_/a_324_432# _298_ 0
C32596 _129_ hold51/a_438_182# 0
C32597 _268_ net47 0.29696f
C32598 _706_/a_132_114# _200_ 0
C32599 _643_/a_741_93# net24 0.00184f
C32600 net36 _262_ 0.039f
C32601 net22 net11 0
C32602 _411_/a_115_308# _132_ 0
C32603 _230_ _642_/a_1785_429# 0
C32604 hold144/a_326_118# net24 0
C32605 net47 _473_/a_22_110# 0
C32606 _313_ FILLER_22_54/a_40_246# 0
C32607 _661_/a_843_236# _209_ 0
C32608 FILLER_17_201/a_32_246# _647_/a_1489_191# 0
C32609 _094_ FILLER_8_19/a_40_246# 0
C32610 _227_ _229_ 0.36618f
C32611 _377_/a_268_412# tx_data[7] 0
C32612 net55 input10/a_40_152# 0.0018f
C32613 hold181/a_326_118# baud_inst.counter\[2\] 0.00156f
C32614 net49 _703_/a_843_236# 0.02099f
C32615 _303_ _693_/a_298_337# 0
C32616 hold68/a_438_182# _702_/a_38_114# 0
C32617 _656_/a_2250_412# _071_ 0
C32618 output16/a_40_152# output19/a_40_152# 0.0015f
C32619 clknet_4_12_0_clk net139 0.00345f
C32620 _061_ _156_ 0
C32621 clk _144_ 0.02482f
C32622 hold61/a_438_182# net38 0.019f
C32623 _233_ net37 0.01705f
C32624 net79 _504_/a_177_436# 0.00212f
C32625 _376_/a_272_160# _166_ -0
C32626 _270_ _157_ 0.02361f
C32627 _009_ hold156/a_56_118# 0.00405f
C32628 _101_ baud_inst.counter\[16\] 0.00111f
C32629 FILLER_21_147/a_40_246# _161_ 0.00272f
C32630 hold162/a_438_182# _110_ 0
C32631 _217_ clknet_0_clk 0.0053f
C32632 clknet_4_3_0_clk _281_ 0
C32633 net42 net62 0.02328f
C32634 _673_/a_843_236# clkbuf_4_0_0_clk/a_27_118# 0
C32635 _673_/a_38_114# clknet_0_clk 0
C32636 hold126/a_438_182# _268_ 0.01082f
C32637 net79 hold60/a_326_118# 0
C32638 FILLER_19_178/a_40_246# clknet_0_clk 0.00352f
C32639 VPWR _647_/a_132_114# 0
C32640 net126 VPWR 0.17805f
C32641 _292_ _296_ 0.03855f
C32642 _307_ _301_ 0.0012f
C32643 _047_ hold84/a_56_118# 0
C32644 _678_/a_1583_191# clknet_0_clk 0.01161f
C32645 _092_ _282_ 0
C32646 hold156/a_326_118# clknet_4_2_0_clk 0.00345f
C32647 rx_data[7] _129_ 0.00425f
C32648 hold139/a_56_118# FILLER_20_177/a_32_246# 0
C32649 net34 hold56/a_326_118# 0
C32650 _127_ _638_/a_324_432# 0
C32651 clknet_4_15_0_clk hold70/a_56_118# 0.01816f
C32652 _679_/a_1583_191# _352_/a_46_156# 0.00167f
C32653 hold172/a_326_118# _665_/a_741_93# 0.00222f
C32654 _339_/a_886_118# _172_ 0.00197f
C32655 _041_ net51 0.0199f
C32656 tx_inst.state\[4\] _394_/a_120_432# 0
C32657 tx_data[3] tx_data[7] 1.52351f
C32658 _360_/a_589_385# tx_inst.data_reg\[0\] 0.00119f
C32659 net79 hold135/a_326_118# 0.00261f
C32660 _661_/a_843_236# _069_ 0
C32661 tx_inst.data_reg\[7\] _658_/a_38_114# 0.01584f
C32662 FILLER_17_94/a_40_246# net29 0
C32663 hold66/a_326_118# rx_inst.data_reg\[0\] 0.00128f
C32664 net66 hold111/a_56_118# 0.08442f
C32665 _147_ _382_/a_59_156# 0.00177f
C32666 _206_ _659_/a_1583_191# 0
C32667 hold134/a_438_182# net134 0
C32668 hold97/a_326_118# VPWR 0.00529f
C32669 net31 _427_/a_248_122# 0
C32670 _404_/a_46_156# _667_/a_2250_412# 0
C32671 net44 net29 0.00604f
C32672 _268_ net70 0
C32673 _688_/a_2002_114# baud_inst.counter\[16\] 0
C32674 hold157/a_438_182# _690_/a_741_93# 0
C32675 _433_/a_142_412# _156_ 0.00435f
C32676 _145_ _181_ 0
C32677 _638_/a_550_127# _273_ 0
C32678 FILLER_19_132/a_40_246# _262_ 0
C32679 _695_/a_2250_412# _296_ 0.00159f
C32680 _166_ _475_/a_170_412# 0
C32681 tx_inst.state\[1\] _707_/a_612_127# 0
C32682 clknet_4_7_0_clk _707_/a_550_127# 0
C32683 _656_/a_38_114# _388_/a_382_118# 0
C32684 hold139/a_438_182# _137_ 0.00184f
C32685 _638_/a_741_93# net30 0.01914f
C32686 _638_/a_324_432# _266_ 0.05843f
C32687 _438_/a_350_122# _236_ 0
C32688 _073_ net55 0.06165f
C32689 _547_/a_379_118# net113 0.00399f
C32690 net38 _681_/a_1840_334# 0
C32691 rx_data[4] _636_/a_298_337# 0.03082f
C32692 net16 _636_/a_38_114# 0.0103f
C32693 _138_ _429_/a_244_412# 0.00134f
C32694 _675_/a_2250_412# _033_ 0.00168f
C32695 _675_/a_1489_191# hold61/a_326_118# 0
C32696 _706_/a_741_93# _042_ 0.00361f
C32697 _644_/a_132_114# net151 0
C32698 _031_ net67 0.00974f
C32699 _112_ baud_inst.counter\[24\] 0
C32700 _661_/a_132_114# net55 0
C32701 _661_/a_843_236# _207_ 0
C32702 hold164/a_56_118# _105_ 0
C32703 _442_/a_146_122# _161_ 0
C32704 _536_/a_341_118# _693_/a_298_337# 0
C32705 tx_inst.data_reg\[2\] _150_ 0.0346f
C32706 hold102/a_56_118# net160 0
C32707 _232_ _429_/a_244_412# 0
C32708 _447_/a_379_118# net25 0
C32709 _641_/a_2002_114# net24 0
C32710 fanout33/a_40_152# _706_/a_324_432# 0
C32711 hold98/a_56_118# _292_ 0
C32712 hold98/a_326_118# net109 0
C32713 net39 _677_/a_1489_191# 0.01766f
C32714 _060_ net71 0
C32715 hold125/a_326_118# VPWR 0.04813f
C32716 net58 _032_ 0.13039f
C32717 _353_/a_146_122# _184_ 0.00493f
C32718 hold69/a_56_118# net69 0
C32719 net94 _505_/a_76_160# 0.00103f
C32720 _678_/a_1583_191# _182_ 0.00375f
C32721 _637_/a_324_432# hold70/a_56_118# 0
C32722 hold112/a_326_118# _257_ 0
C32723 _153_ net119 0.00324f
C32724 net49 _450_/a_398_96# 0
C32725 _030_ _287_ 0
C32726 hold117/a_326_118# _681_/a_1489_191# 0
C32727 hold63/a_438_182# _667_/a_324_432# 0
C32728 _127_ net126 0.12778f
C32729 _677_/a_1583_191# _676_/a_741_93# 0.00123f
C32730 FILLER_15_67/a_40_246# _297_ 0.03281f
C32731 net81 _264_ 0.00321f
C32732 net48 hold127/a_438_182# 0.05421f
C32733 baud_inst.counter\[20\] _695_/a_843_236# 0
C32734 _360_/a_1453_124# VPWR 0.01007f
C32735 _699_/a_843_236# clknet_4_8_0_clk 0.02877f
C32736 _110_ _025_ 0.01749f
C32737 _178_ net45 0.5704f
C32738 net142 _310_ 0.00344f
C32739 net145 _659_/a_298_337# 0
C32740 _206_ net5 0.04499f
C32741 _081_ _129_ 0
C32742 _074_ net21 0
C32743 _118_ input2/a_40_152# 0.0018f
C32744 _513_/a_192_429# _513_/a_435_412# -0
C32745 FILLER_15_162/a_40_246# _223_ 0.01328f
C32746 _663_/a_38_114# VPWR 0.01927f
C32747 net28 _650_/a_612_127# 0
C32748 tx_inst.data_reg\[7\] _656_/a_741_93# 0
C32749 _643_/a_324_432# VPWR 0.0166f
C32750 _118_ output21/a_40_152# 0.08553f
C32751 hold160/a_438_182# _296_ 0.0151f
C32752 _660_/a_1489_191# _206_ 0.00188f
C32753 hold144/a_56_118# VPWR 0.03622f
C32754 baud_inst.counter\[8\] baud_inst.counter\[2\] 0.00143f
C32755 _284_ _184_ 0
C32756 hold166/a_326_118# net29 0.0073f
C32757 net141 _686_/a_1583_191# 0.00205f
C32758 net126 _266_ 0.17481f
C32759 hold151/a_326_118# _256_ 0
C32760 _154_ net30 0
C32761 net46 hold90/a_438_182# 0.00403f
C32762 _099_ hold90/a_326_118# 0
C32763 clknet_4_15_0_clk _648_/a_1489_191# 0
C32764 net39 net109 0.00692f
C32765 FILLER_16_221/a_32_246# rx_inst.data_reg\[7\] 0
C32766 clk _339_/a_886_118# 0.03776f
C32767 rx_data[0] _267_ 0
C32768 net21 _665_/a_1489_191# 0.0095f
C32769 FILLER_24_218/a_40_246# net72 0
C32770 _073_ _076_ 0.00273f
C32771 net94 _092_ 0.23208f
C32772 _642_/a_324_432# net25 0
C32773 _153_ _433_/a_244_412# 0
C32774 hold99/a_56_118# _111_ 0.00549f
C32775 hold99/a_326_118# net45 0
C32776 _175_ net168 0.00232f
C32777 FILLER_5_213/a_32_246# _665_/a_38_114# 0
C32778 hold101/a_56_118# _688_/a_741_93# 0.00109f
C32779 hold101/a_438_182# _688_/a_38_114# 0
C32780 hold101/a_326_118# _688_/a_324_432# 0
C32781 rx_data[4] net19 0.03341f
C32782 net173 _220_ 0
C32783 _126_ VPWR 0.17334f
C32784 baud_inst.counter\[28\] hold59/a_438_182# 0.00406f
C32785 baud_inst.counter\[30\] hold59/a_56_118# 0.00877f
C32786 _685_/a_1583_191# net29 -0
C32787 _645_/a_2002_114# net48 0
C32788 net54 _665_/a_741_93# 0.00178f
C32789 net51 FILLER_14_185/a_32_246# 0.00133f
C32790 net44 _526_/a_146_122# 0
C32791 net75 _695_/a_324_432# 0.03343f
C32792 _305_ _695_/a_38_114# 0.00161f
C32793 _023_ _695_/a_298_337# 0
C32794 _241_ _435_/a_72_436# 0
C32795 net110 net39 0
C32796 hold138/a_326_118# FILLER_19_228/a_40_246# 0.00327f
C32797 _343_/a_257_140# _197_ 0.00143f
C32798 clknet_4_5_0_clk _665_/a_132_114# 0
C32799 FILLER_9_79/a_32_246# _184_ 0
C32800 _653_/a_324_432# VPWR 0.00356f
C32801 net42 hold63/a_438_182# 0
C32802 _488_/a_380_412# _145_ 0
C32803 net42 _666_/a_1840_334# 0
C32804 net62 _667_/a_2250_412# 0
C32805 _244_ _633_/a_38_114# 0
C32806 _069_ _657_/a_1489_191# 0
C32807 net39 _034_ 0.01652f
C32808 net144 hold144/a_56_118# 0
C32809 FILLER_12_89/a_40_246# _034_ 0.01164f
C32810 _141_ _651_/a_298_337# 0.00279f
C32811 net56 _651_/a_741_93# 0.00546f
C32812 _231_ FILLER_14_148/a_40_246# 0
C32813 FILLER_27_194/a_40_246# _158_ 0
C32814 _203_ _120_ 0
C32815 _124_ hold82/a_438_182# 0
C32816 fanout38/a_40_152# net40 0.03244f
C32817 baud_inst.counter\[20\] _536_/a_192_429# 0
C32818 _689_/a_324_432# net40 0.00384f
C32819 hold124/a_438_182# net72 0.01484f
C32820 rx_inst.data_reg\[0\] _635_/a_38_114# 0
C32821 _491_/a_192_429# net60 0.00411f
C32822 hold110/a_56_118# _683_/a_741_93# 0
C32823 hold110/a_438_182# _683_/a_38_114# 0
C32824 net178 _684_/a_132_114# 0
C32825 _447_/a_81_118# _258_ 0
C32826 _679_/a_741_93# FILLER_5_74/a_32_246# 0
C32827 _206_ _376_/a_170_160# -0
C32828 net49 FILLER_25_36/a_32_246# 0
C32829 net55 net41 0.08491f
C32830 _638_/a_2250_412# VPWR 0.00426f
C32831 net182 _685_/a_1583_191# 0
C32832 _639_/a_1840_334# clknet_4_13_0_clk 0.00163f
C32833 hold125/a_438_182# net30 0
C32834 net56 _007_ 0
C32835 net49 _421_/a_252_412# 0
C32836 _698_/a_1840_334# net142 0
C32837 net72 _271_ 0
C32838 _048_ _124_ 0.0366f
C32839 hold100/a_56_118# net46 0
C32840 _206_ tx_data[2] 0.02763f
C32841 _691_/a_1489_191# FILLER_17_24/a_32_246# 0
C32842 _160_ net30 0
C32843 net79 _349_/a_146_122# 0
C32844 _278_ _667_/a_38_114# 0
C32845 rx_inst.state\[3\] _667_/a_324_432# 0.00128f
C32846 net89 _687_/a_298_337# 0.00921f
C32847 _706_/a_1489_191# _200_ 0
C32848 _217_ FILLER_6_189/a_40_246# 0
C32849 _230_ _053_ 0.00103f
C32850 _216_ _667_/a_1489_191# 0
C32851 _658_/a_1583_191# _388_/a_59_156# 0
C32852 net49 _435_/a_166_436# 0
C32853 net67 net46 -0
C32854 _054_ _273_ 0.02085f
C32855 _547_/a_175_118# net99 0.00134f
C32856 _643_/a_1489_191# net64 0
C32857 _480_/a_120_432# VPWR 0.00483f
C32858 net49 _703_/a_612_127# 0.00515f
C32859 _672_/a_324_432# hold60/a_438_182# 0
C32860 _672_/a_741_93# hold60/a_326_118# 0.00165f
C32861 _201_ net21 0
C32862 _705_/a_843_236# net172 0
C32863 _705_/a_324_432# _200_ 0
C32864 _643_/a_324_432# _266_ 0
C32865 clkbuf_4_11_0_clk/a_27_118# _180_ 0.0016f
C32866 hold57/a_438_182# _221_ 0
C32867 _675_/a_843_236# _674_/a_843_236# 0
C32868 _067_ net41 0.20988f
C32869 _282_ hold92/a_326_118# 0.0191f
C32870 hold108/a_438_182# net29 0.00113f
C32871 hold160/a_326_118# net39 0
C32872 _414_/a_165_412# net26 0.00514f
C32873 net16 rx_data[7] 0.01005f
C32874 _675_/a_1489_191# _279_ 0
C32875 baud_inst.counter\[13\] _280_ 0
C32876 _000_ _417_/a_22_110# 0
C32877 net79 _038_ 0.00887f
C32878 _188_ _688_/a_2250_412# 0
C32879 VPWR _684_/a_38_114# 0.00157f
C32880 baud_inst.counter\[13\] _688_/a_1583_191# 0
C32881 net31 _412_/a_22_110# 0
C32882 _314_ hold107/a_438_182# 0.01062f
C32883 _638_/a_38_114# _049_ 0.0103f
C32884 net173 FILLER_6_151/a_40_246# 0.00223f
C32885 net31 fanout32/a_40_152# 0.00123f
C32886 FILLER_27_135/a_32_246# net47 0.0115f
C32887 hold120/a_326_118# _694_/a_741_93# 0.00316f
C32888 hold120/a_438_182# _694_/a_324_432# 0
C32889 _674_/a_1583_191# FILLER_2_46/a_40_246# 0
C32890 FILLER_27_194/a_40_246# _633_/a_1489_191# 0
C32891 hold170/a_438_182# clk 0
C32892 hold167/a_438_182# net167 0.00423f
C32893 _359_/a_120_432# clknet_4_4_0_clk 0.00155f
C32894 VPWR _066_ 0.21358f
C32895 _657_/a_1489_191# clknet_4_4_0_clk 0
C32896 baud_inst.counter\[10\] clknet_4_2_0_clk 0
C32897 hold144/a_438_182# _647_/a_38_114# 0
C32898 clknet_0_clk _667_/a_843_236# 0
C32899 net49 net24 0.12341f
C32900 net165 _146_ 0.31316f
C32901 clknet_0_clk hold95/a_326_118# 0.00107f
C32902 clknet_4_5_0_clk FILLER_2_237/a_40_246# 0
C32903 _126_ _266_ 0.42986f
C32904 net74 net30 0.58627f
C32905 net55 FILLER_0_109/a_32_246# 0.01863f
C32906 _068_ net6 0
C32907 net121 clknet_4_10_0_clk 0.7142f
C32908 _378_/a_59_156# _655_/a_2250_412# 0
C32909 _076_ net41 0.01515f
C32910 net174 _078_ 0
C32911 rx_inst.state\[3\] FILLER_11_144/a_32_246# 0.0189f
C32912 _043_ _638_/a_298_337# 0
C32913 _679_/a_1840_334# _185_ 0
C32914 net128 _190_ 0.02468f
C32915 _488_/a_474_130# VPWR 0
C32916 _283_ hold154/a_56_118# 0
C32917 FILLER_14_202/a_40_246# _650_/a_741_93# 0.00171f
C32918 _699_/a_324_432# clknet_4_10_0_clk 0
C32919 baud_inst.counter\[5\] _281_ 0
C32920 tx_inst.data_reg\[7\] _658_/a_1840_334# 0.0016f
C32921 rx_inst.state\[3\] _142_ 0
C32922 hold55/a_438_182# _705_/a_741_93# 0.00164f
C32923 hold55/a_326_118# _705_/a_843_236# 0.00243f
C32924 _121_ _668_/a_1489_191# 0
C32925 FILLER_26_35/a_32_246# _029_ 0.00147f
C32926 tx_inst.data_reg\[4\] net3 0.00156f
C32927 net42 rx_inst.state\[3\] 1.90469f
C32928 hold75/a_438_182# net75 0
C32929 hold75/a_56_118# _023_ 0
C32930 tx_inst.data_reg\[6\] _360_/a_382_118# 0.02764f
C32931 _680_/a_298_337# FILLER_5_32/a_40_246# 0
C32932 hold103/a_326_118# VPWR 0.00338f
C32933 rx_inst.bit_index\[2\] _445_/a_279_412# 0
C32934 _228_ _002_ 0
C32935 _433_/a_550_140# _137_ 0.00101f
C32936 _224_ VPWR 0.73112f
C32937 FILLER_18_169/a_40_246# _235_ 0
C32938 net2 _459_/a_27_156# 0.01144f
C32939 net45 net133 0.34263f
C32940 hold69/a_326_118# net65 0
C32941 _673_/a_741_93# net86 0.02371f
C32942 _673_/a_843_236# net181 0.00484f
C32943 _400_/a_435_412# net183 0.0034f
C32944 _485_/a_22_110# rx_inst.state\[3\] 0.01536f
C32945 _668_/a_843_236# net19 0
C32946 hold124/a_56_118# _128_ 0
C32947 _656_/a_298_337# net165 0
C32948 hold96/a_326_118# baud_inst.counter\[6\] 0
C32949 _168_ _650_/a_324_432# 0.02251f
C32950 net82 hold82/a_438_182# 0.01227f
C32951 _252_ _236_ 0.07229f
C32952 _638_/a_1785_429# net30 0
C32953 _164_ net103 0.12998f
C32954 tx_inst.bit_index\[1\] clkbuf_4_4_0_clk/a_27_118# 0.05148f
C32955 _312_ _165_ 0.00468f
C32956 _689_/a_741_93# _682_/a_324_432# 0
C32957 _690_/a_324_432# net101 0.04619f
C32958 _690_/a_2250_412# net103 0.0069f
C32959 net16 _636_/a_1840_334# 0
C32960 rx_data[4] _636_/a_1583_191# 0
C32961 _206_ _664_/a_550_127# 0
C32962 _314_ _694_/a_843_236# 0
C32963 _706_/a_1785_429# _042_ 0
C32964 _191_ baud_inst.counter\[13\] 0
C32965 _661_/a_1489_191# net55 0
C32966 _143_ net41 0
C32967 hold90/a_326_118# _685_/a_843_236# 0
C32968 hold90/a_438_182# _685_/a_741_93# 0
C32969 net120 _693_/a_843_236# 0.00904f
C32970 _074_ _654_/a_1583_191# 0.00185f
C32971 _017_ _015_ 0.01016f
C32972 net102 _296_ 0.00333f
C32973 _259_ net25 0.00114f
C32974 _662_/a_324_432# _120_ 0
C32975 _662_/a_741_93# net43 0
C32976 net98 _010_ 0
C32977 net48 _272_ 0
C32978 net49 _438_/a_146_122# 0
C32979 _376_/a_76_160# _201_ 0
C32980 net82 _048_ 0.00544f
C32981 _182_ hold95/a_326_118# 0
C32982 net73 clknet_4_13_0_clk 0.03065f
C32983 _230_ _451_/a_155_412# 0.0149f
C32984 hold122/a_56_118# VPWR 0.05102f
C32985 net76 FILLER_21_31/a_40_246# 0.00405f
C32986 _425_/a_46_156# _455_/a_257_140# 0
C32987 hold117/a_326_118# baud_inst.counter\[9\] 0.00174f
C32988 hold131/a_438_182# _429_/a_244_412# 0
C32989 _060_ _273_ 0
C32990 _641_/a_1583_191# _641_/a_2250_412# 0
C32991 hold173/a_56_118# _218_ 0.00905f
C32992 hold173/a_326_118# _217_ 0.0014f
C32993 hold173/a_438_182# _195_ 0.00477f
C32994 _217_ net43 0
C32995 clkbuf_4_5_0_clk/a_27_118# _479_/a_120_432# 0
C32996 baud_inst.counter\[20\] _695_/a_612_127# 0
C32997 baud_inst.counter\[28\] _699_/a_741_93# 0
C32998 baud_inst.counter\[31\] _699_/a_324_432# 0
C32999 _360_/a_1377_160# VPWR 0.01726f
C33000 _101_ _016_ 0.01442f
C33001 _645_/a_550_127# net151 0
C33002 rx_data[6] clknet_4_15_0_clk 0
C33003 _699_/a_612_127# clknet_4_8_0_clk 0
C33004 _635_/a_843_236# clknet_0_clk 0
C33005 clknet_0_clk _086_ 0.00198f
C33006 _007_ _476_/a_248_122# 0
C33007 _113_ _702_/a_324_432# 0
C33008 tx_inst.data_reg\[6\] net9 0.04583f
C33009 net145 _659_/a_1583_191# 0.00576f
C33010 _696_/a_681_505# baud_inst.counter\[24\] 0
C33011 _696_/a_741_93# _309_ 0
C33012 net28 rx_inst.state\[4\] 0.0177f
C33013 _432_/a_248_122# net25 0
C33014 _157_ net25 0
C33015 net92 hold92/a_56_118# 0
C33016 _513_/a_192_429# _011_ 0.01752f
C33017 _234_ net26 0.78781f
C33018 net67 _313_ 0.0086f
C33019 _114_ _315_ 0
C33020 FILLER_8_21/a_32_246# _288_ 0.01683f
C33021 _091_ clknet_0_clk 0.04522f
C33022 _663_/a_1840_334# VPWR 0.00188f
C33023 _168_ FILLER_14_164/a_32_246# 0
C33024 _511_/a_150_412# VPWR 0
C33025 net26 _669_/a_2250_412# 0.00124f
C33026 net28 net119 0.15453f
C33027 fanout41/a_40_152# _068_ 0.08754f
C33028 _643_/a_2250_412# VPWR 0.00662f
C33029 _379_/a_46_156# clknet_4_4_0_clk 0
C33030 _234_ net32 0.19591f
C33031 hold147/a_326_118# net147 0.00201f
C33032 _547_/a_81_118# net140 0
C33033 _266_ _647_/a_1489_191# 0
C33034 hold147/a_326_118# net46 0
C33035 net141 _686_/a_2002_114# 0
C33036 VPWR _235_ 0.05586f
C33037 net95 net86 0
C33038 clknet_4_15_0_clk rx_inst.data_reg\[5\] 0.01031f
C33039 _170_ _633_/a_132_114# 0
C33040 _660_/a_298_337# net170 0
C33041 net21 tx_inst.state\[3\] 0.50722f
C33042 _519_/a_81_118# net87 0
C33043 _082_ _670_/a_324_432# 0
C33044 net13 _634_/a_741_93# 0
C33045 FILLER_23_204/a_40_246# _049_ 0.00415f
C33046 clknet_4_5_0_clk _074_ 0.02085f
C33047 hold161/a_56_118# net160 0.0086f
C33048 _642_/a_2250_412# net25 0
C33049 _647_/a_1583_191# _647_/a_2250_412# -0
C33050 hold77/a_56_118# _264_ 0.01695f
C33051 FILLER_12_128/a_40_246# VPWR 0.13784f
C33052 _064_ _386_/a_382_118# 0
C33053 _671_/a_843_236# clknet_4_6_0_clk 0.02441f
C33054 _023_ _303_ 0.01624f
C33055 _234_ hold62/a_326_118# 0.00454f
C33056 _555_/a_209_168# _315_ 0
C33057 hold155/a_56_118# _657_/a_324_432# 0
C33058 clk net179 0.08505f
C33059 baud_inst.counter\[12\] FILLER_13_89/a_40_246# 0
C33060 _409_/a_269_412# VPWR 0
C33061 _021_ _694_/a_38_114# 0.00307f
C33062 net54 _665_/a_1785_429# 0.00221f
C33063 _010_ _683_/a_324_432# 0
C33064 _292_ _683_/a_741_93# 0.03779f
C33065 net40 _348_/a_248_122# 0
C33066 _674_/a_741_93# net38 0
C33067 _516_/a_279_412# _190_ 0.0022f
C33068 net129 _180_ 0.0054f
C33069 net75 _695_/a_2250_412# 0
C33070 hold126/a_56_118# VPWR 0.00825f
C33071 net37 hold166/a_56_118# 0
C33072 _188_ _355_/a_252_412# 0
C33073 _680_/a_843_236# _489_/a_115_308# 0.00258f
C33074 _343_/a_155_412# VPWR 0.02746f
C33075 hold120/a_438_182# baud_inst.counter\[22\] 0.05412f
C33076 _443_/a_150_412# net24 0
C33077 FILLER_1_173/a_32_246# _208_ 0.00159f
C33078 hold128/a_326_118# net91 0
C33079 _653_/a_2250_412# VPWR 0.00662f
C33080 _701_/a_843_236# baud_inst.counter\[29\] 0
C33081 baud_inst.counter\[31\] _698_/a_843_236# 0
C33082 _069_ tx_inst.data_reg\[3\] 0
C33083 _670_/a_324_432# clknet_0_clk 0.00943f
C33084 _257_ _473_/a_120_432# 0
C33085 _224_ _167_ 0
C33086 tx_inst.bit_index\[1\] _339_/a_589_385# 0.00137f
C33087 _680_/a_324_432# _681_/a_843_236# 0
C33088 hold173/a_438_182# _401_/a_22_110# 0
C33089 net12 hold65/a_56_118# 0
C33090 _171_ net55 0
C33091 _375_/a_170_412# _275_ 0
C33092 tx_data[7] tx_data[5] 1.48227f
C33093 fanout32/a_40_152# _422_/a_248_122# 0
C33094 hold74/a_438_182# _126_ 0.00597f
C33095 hold74/a_326_118# net74 0.00156f
C33096 _206_ _210_ 0.04989f
C33097 _173_ _364_/a_155_412# 0.00121f
C33098 _286_ _502_/a_165_412# 0.00159f
C33099 _091_ _182_ 0
C33100 FILLER_11_32/a_32_246# net40 0.00231f
C33101 FILLER_7_40/a_32_246# _288_ 0
C33102 _166_ _197_ 0
C33103 _689_/a_2250_412# net40 0.04745f
C33104 net60 _181_ 1.67222f
C33105 hold115/a_438_182# baud_inst.counter\[9\] 0.00228f
C33106 _079_ net37 0.07488f
C33107 _637_/a_324_432# rx_inst.data_reg\[5\] 0
C33108 _555_/a_380_412# _551_/a_76_160# 0
C33109 _225_ _224_ 0.01817f
C33110 _294_ _292_ 0.10642f
C33111 baud_inst.counter\[13\] _101_ 0
C33112 hold167/a_326_118# _669_/a_324_432# 0
C33113 hold167/a_56_118# _669_/a_741_93# 0
C33114 net71 _649_/a_1785_429# 0
C33115 _633_/a_741_93# _264_ 0
C33116 _268_ _649_/a_2250_412# 0.00271f
C33117 net57 clk 0
C33118 hold174/a_326_118# _197_ 0.00797f
C33119 clknet_4_0_0_clk _506_/a_155_412# 0
C33120 _683_/a_681_505# _096_ 0
C33121 net39 _351_/a_46_156# 0
C33122 _042_ _200_ 0.00153f
C33123 _240_ _650_/a_843_236# 0
C33124 clknet_4_11_0_clk _698_/a_38_114# 0.00246f
C33125 net27 _666_/a_324_432# 0
C33126 _241_ _000_ 0
C33127 _199_ _665_/a_132_114# 0
C33128 clknet_4_13_0_clk net118 0.11289f
C33129 net39 FILLER_13_89/a_40_246# 0
C33130 net113 net99 0.07588f
C33131 FILLER_12_89/a_40_246# FILLER_13_89/a_40_246# 0.00322f
C33132 _226_ rx_inst.state\[2\] 0.50487f
C33133 _392_/a_559_412# clknet_4_4_0_clk 0
C33134 net27 FILLER_9_169/a_32_246# 0.00106f
C33135 baud_inst.counter\[13\] hold91/a_438_182# 0
C33136 _639_/a_612_127# hold80/a_56_118# 0
C33137 _639_/a_681_505# net80 0
C33138 _292_ clknet_4_0_0_clk 0
C33139 _045_ hold124/a_438_182# 0
C33140 net49 net59 0.00781f
C33141 _701_/a_324_432# net107 0.00348f
C33142 VPWR _525_/a_46_156# 0.0095f
C33143 rx_inst.data_reg\[7\] _047_ 0
C33144 net35 _435_/a_72_436# 0.05529f
C33145 hold126/a_56_118# _127_ 0.01205f
C33146 hold68/a_56_118# _115_ 0.00115f
C33147 _643_/a_2250_412# _266_ 0.01907f
C33148 hold140/a_326_118# baud_inst.counter\[25\] 0.0237f
C33149 _241_ _647_/a_38_114# 0
C33150 hold138/a_438_182# _156_ 0.01264f
C33151 _081_ _668_/a_741_93# 0.00137f
C33152 _233_ net26 0.60345f
C33153 input4/a_40_152# net38 0
C33154 _411_/a_358_436# VPWR 0
C33155 _691_/a_843_236# net49 0.00337f
C33156 _443_/a_354_412# _161_ 0.00103f
C33157 _678_/a_1583_191# net152 0
C33158 _652_/a_1489_191# VPWR 0.00108f
C33159 hold130/a_56_118# net29 0
C33160 _671_/a_843_236# net29 0.0162f
C33161 net30 _140_ 0.42138f
C33162 _638_/a_1840_334# _049_ 0
C33163 _283_ FILLER_8_92/a_32_246# 0
C33164 VPWR _684_/a_1840_334# 0.0025f
C33165 _537_/a_341_118# _022_ 0
C33166 _677_/a_38_114# net154 0.01622f
C33167 _233_ net32 0.01466f
C33168 _045_ _271_ 0.02583f
C33169 _206_ FILLER_7_121/a_40_246# 0
C33170 net129 baud_inst.counter\[11\] 0
C33171 _670_/a_38_114# _685_/a_2250_412# 0
C33172 _167_ _235_ 0.11248f
C33173 net48 _648_/a_298_337# 0.00647f
C33174 _043_ _049_ 0.05479f
C33175 _192_ clknet_4_4_0_clk 0.0123f
C33176 _686_/a_843_236# net29 0
C33177 hold169/a_326_118# VPWR 0.0126f
C33178 net42 _671_/a_298_337# 0
C33179 _643_/a_681_505# _154_ 0
C33180 tx_inst.data_reg\[3\] clknet_4_4_0_clk 1.82443f
C33181 _171_ _076_ 0
C33182 FILLER_16_176/a_40_246# net2 0
C33183 _392_/a_496_118# _076_ 0
C33184 clknet_4_5_0_clk _201_ 0.01445f
C33185 _678_/a_298_337# _035_ 0
C33186 _644_/a_38_114# VPWR 0.00115f
C33187 net60 _088_ 0
C33188 hold126/a_56_118# _266_ 0
C33189 hold126/a_326_118# net30 0.0073f
C33190 _206_ _655_/a_1840_334# 0
C33191 clknet_4_8_0_clk _100_ 0.69837f
C33192 clknet_4_14_0_clk _633_/a_1840_334# 0
C33193 _474_/a_22_110# _122_ 0.00123f
C33194 net178 _187_ 0
C33195 _233_ hold62/a_326_118# 0
C33196 _313_ _702_/a_681_505# 0
C33197 _230_ _421_/a_354_412# 0
C33198 fanout32/a_40_152# net62 0
C33199 VPWR FILLER_23_158/a_40_246# 0.1689f
C33200 _555_/a_380_412# _700_/a_741_93# 0
C33201 net106 _552_/a_155_412# 0.00193f
C33202 _170_ clknet_4_15_0_clk 0
C33203 _662_/a_38_114# FILLER_2_208/a_40_246# 0.00201f
C33204 _121_ rx_inst.state\[1\] 0.00547f
C33205 VPWR hold83/a_438_182# 0.00479f
C33206 _114_ hold106/a_438_182# 0
C33207 _651_/a_2250_412# _001_ 0
C33208 hold125/a_326_118# _138_ 0.00395f
C33209 _653_/a_741_93# _652_/a_324_432# 0
C33210 _653_/a_324_432# _652_/a_741_93# 0
C33211 _645_/a_298_337# VPWR 0.00169f
C33212 _676_/a_741_93# FILLER_12_106/a_40_246# 0.00392f
C33213 tx_inst.data_reg\[6\] _360_/a_810_118# 0.00114f
C33214 net27 _198_ 0.14196f
C33215 net55 _706_/a_843_236# 0.00124f
C33216 _228_ FILLER_14_148/a_40_246# 0.00112f
C33217 net27 _168_ 0.0184f
C33218 _247_ _137_ 0.14097f
C33219 VPWR FILLER_29_165/a_40_246# 0.16773f
C33220 FILLER_19_132/a_40_246# _642_/a_1583_191# 0.00208f
C33221 _673_/a_612_127# net181 0.00415f
C33222 net183 _221_ 0.25561f
C33223 _707_/a_38_114# _668_/a_2250_412# 0
C33224 _003_ _278_ 0.10725f
C33225 rx_data[3] VPWR 0.0801f
C33226 _170_ _158_ 1.36852f
C33227 _656_/a_681_505# _146_ 0
C33228 _488_/a_380_412# net60 0
C33229 rx_inst.bit_index\[2\] _424_/a_142_412# 0
C33230 hold138/a_56_118# clknet_4_13_0_clk 0.02754f
C33231 hold75/a_56_118# _695_/a_324_432# 0
C33232 _216_ net26 0.01635f
C33233 FILLER_11_32/a_32_246# _682_/a_741_93# 0
C33234 _164_ net101 0
C33235 rx_inst.bit_index\[0\] net52 0.02259f
C33236 _689_/a_2250_412# _682_/a_741_93# 0
C33237 _062_ clknet_0_clk 0
C33238 _690_/a_2250_412# net101 0
C33239 net111 _474_/a_120_432# 0.00305f
C33240 net22 hold50/a_56_118# 0.01022f
C33241 VPWR _681_/a_38_114# 0.00776f
C33242 FILLER_19_139/a_40_246# VPWR 0.13338f
C33243 hold100/a_438_182# clknet_0_clk 0.00612f
C33244 tx_inst.data_reg\[7\] net55 0.07644f
C33245 net120 _693_/a_612_127# 0.00174f
C33246 _095_ _010_ 0
C33247 _696_/a_38_114# net46 0.05832f
C33248 _260_ net2 0.29883f
C33249 _643_/a_1583_191# FILLER_23_204/a_40_246# 0
C33250 _643_/a_324_432# _232_ 0
C33251 _281_ clknet_0_clk 0.1424f
C33252 hold182/a_56_118# hold152/a_326_118# 0
C33253 _205_ _667_/a_324_432# 0
C33254 _097_ baud_inst.counter\[14\] 0
C33255 _641_/a_681_505# net176 0
C33256 VPWR FILLER_2_79/a_40_246# 0.13675f
C33257 _641_/a_132_114# _052_ 0
C33258 hold171/a_438_182# net41 0
C33259 net154 _676_/a_132_114# 0
C33260 _168_ _456_/a_155_412# -0
C33261 _117_ _704_/a_843_236# 0.00293f
C33262 clkbuf_4_5_0_clk/a_27_118# _006_ 0.00472f
C33263 clknet_4_3_0_clk _677_/a_38_114# 0.0023f
C33264 _179_ _699_/a_1583_191# 0.00122f
C33265 baud_inst.counter\[30\] _699_/a_1840_334# 0.00244f
C33266 baud_inst.counter\[31\] _699_/a_2250_412# 0
C33267 baud_inst.counter\[20\] net76 0.00379f
C33268 tx_inst.bit_index\[1\] VPWR 1.1193f
C33269 VPWR _649_/a_298_337# 0.00913f
C33270 net114 clknet_4_8_0_clk 0
C33271 net43 _667_/a_843_236# 0.02744f
C33272 net145 _659_/a_2002_114# 0
C33273 _678_/a_38_114# _280_ 0
C33274 _097_ net97 0
C33275 _696_/a_550_127# baud_inst.counter\[24\] 0
C33276 net34 _398_/a_115_308# 0.00171f
C33277 net156 _102_ 0.00248f
C33278 _513_/a_341_118# _684_/a_843_236# 0
C33279 _163_ _684_/a_38_114# 0.00206f
C33280 _513_/a_192_429# _684_/a_1583_191# 0
C33281 _283_ _678_/a_741_93# 0
C33282 net92 _678_/a_843_236# 0.00165f
C33283 hold159/a_56_118# VPWR 0.05694f
C33284 tx_inst.data_reg\[7\] _067_ 0.00726f
C33285 hold115/a_326_118# net29 0
C33286 rx_inst.state\[3\] _670_/a_1583_191# 0.00139f
C33287 _695_/a_2250_412# net113 0
C33288 _198_ _706_/a_298_337# 0
C33289 _679_/a_324_432# net115 0
C33290 net55 net146 0
C33291 _537_/a_192_429# net147 0
C33292 hold149/a_56_118# _694_/a_38_114# 0.00876f
C33293 net50 FILLER_6_205/a_40_246# 0
C33294 _411_/a_115_308# _260_ 0.00323f
C33295 _545_/a_248_122# _311_ -0
C33296 _545_/a_350_122# baud_inst.counter\[25\] 0.00227f
C33297 _660_/a_132_114# _208_ 0
C33298 hold76/a_438_182# net120 0
C33299 hold76/a_56_118# _022_ 0
C33300 hold140/a_438_182# net140 0.01403f
C33301 _117_ _707_/a_38_114# 0
C33302 _032_ net49 0.98009f
C33303 net22 FILLER_8_238/a_32_246# 0
C33304 _255_ FILLER_23_143/a_32_246# 0
C33305 rx_inst.state\[2\] FILLER_19_149/a_40_246# 0.00166f
C33306 _065_ FILLER_1_212/a_32_246# 0
C33307 net50 clkbuf_4_7_0_clk/a_27_118# 0.01321f
C33308 _674_/a_1785_429# net38 0
C33309 _281_ _182_ 0.00255f
C33310 hold158/a_56_118# _300_ 0
C33311 rx_data[6] _637_/a_2250_412# 0.0078f
C33312 _662_/a_38_114# clknet_4_5_0_clk 0.00247f
C33313 net87 _014_ 0.22947f
C33314 clknet_4_5_0_clk tx_inst.state\[3\] 0
C33315 _133_ _043_ 0
C33316 net42 _205_ 0
C33317 net45 _111_ 0.26453f
C33318 FILLER_4_100/a_40_246# FILLER_4_102/a_32_246# 0.0524f
C33319 VPWR _665_/a_741_93# 0.02202f
C33320 _670_/a_2250_412# clknet_0_clk 0
C33321 _442_/a_350_122# _236_ 0
C33322 _257_ _273_ 0
C33323 net3 _654_/a_298_337# 0
C33324 _680_/a_298_337# _681_/a_1489_191# 0
C33325 _680_/a_843_236# _681_/a_2250_412# 0
C33326 _488_/a_209_168# _488_/a_474_130# 0
C33327 _673_/a_741_93# net38 0.01339f
C33328 _686_/a_324_432# hold90/a_56_118# 0
C33329 net94 _503_/a_279_412# 0
C33330 hold156/a_438_182# net156 0
C33331 _486_/a_115_308# net49 0.00186f
C33332 _173_ _197_ 0.26996f
C33333 net26 _666_/a_843_236# 0.00654f
C33334 net110 _683_/a_612_127# 0
C33335 hold110/a_56_118# _096_ 0.00161f
C33336 net177 _513_/a_155_160# 0
C33337 net79 net86 1.5168f
C33338 clknet_4_3_0_clk _676_/a_132_114# 0
C33339 net48 hold119/a_326_118# 0
C33340 FILLER_8_70/a_32_246# _683_/a_1489_191# 0
C33341 _702_/a_324_432# _700_/a_324_432# 0
C33342 _702_/a_38_114# _700_/a_741_93# 0
C33343 _702_/a_298_337# _700_/a_843_236# 0
C33344 _679_/a_38_114# baud_inst.counter\[7\] 0
C33345 hold184/a_56_118# clknet_4_4_0_clk 0.00565f
C33346 _679_/a_324_432# clknet_4_3_0_clk 0.00565f
C33347 _519_/a_175_118# clknet_0_clk 0.00236f
C33348 net167 _669_/a_843_236# 0.00619f
C33349 baud_inst.counter\[21\] clknet_4_10_0_clk 0.02359f
C33350 _643_/a_1583_191# _043_ 0.00113f
C33351 _195_ net56 0
C33352 hold88/a_56_118# clknet_0_clk 0.01344f
C33353 _246_ _136_ 0.00201f
C33354 _226_ _434_/a_252_412# 0
C33355 _643_/a_298_337# clkload3/Y 0
C33356 hold174/a_56_118# VPWR 0.01467f
C33357 net173 net27 0.00502f
C33358 _390_/a_382_118# net7 0
C33359 hold59/a_326_118# VPWR 0.00505f
C33360 clknet_4_0_0_clk _289_ 0
C33361 tx_inst.data_reg\[7\] _143_ 0
C33362 _652_/a_2250_412# net183 0
C33363 _683_/a_2250_412# baud_inst.counter\[11\] 0.00434f
C33364 _100_ _687_/a_324_432# 0.01056f
C33365 _420_/a_146_122# net24 0.00241f
C33366 net124 hold72/a_56_118# 0
C33367 _266_ _649_/a_298_337# 0
C33368 _693_/a_132_114# net46 0
C33369 _177_ _699_/a_324_432# 0.02874f
C33370 net53 _698_/a_132_114# 0
C33371 clknet_4_11_0_clk _698_/a_1840_334# 0.00193f
C33372 baud_inst.counter\[27\] _699_/a_843_236# 0
C33373 baud_inst.counter\[26\] _699_/a_741_93# 0
C33374 net27 _666_/a_2250_412# 0
C33375 net131 net30 0
C33376 fanout24/a_40_152# net175 0.00348f
C33377 tx_data[0] net5 0
C33378 hold159/a_438_182# net159 0
C33379 _658_/a_550_127# net165 0
C33380 _258_ _136_ 0
C33381 FILLER_4_172/a_32_246# _364_/a_155_412# 0.0055f
C33382 hold76/a_56_118# _108_ 0.00161f
C33383 _659_/a_1583_191# _657_/a_843_236# 0
C33384 _659_/a_843_236# _657_/a_1583_191# 0
C33385 FILLER_17_22/a_40_246# FILLER_17_24/a_32_246# 0.0524f
C33386 hold116/a_438_182# net116 0.00982f
C33387 clknet_4_3_0_clk _497_/a_170_412# 0
C33388 _639_/a_550_127# net80 0
C33389 net81 hold80/a_56_118# 0.00468f
C33390 _050_ hold80/a_326_118# 0.0089f
C33391 _094_ _681_/a_132_114# 0
C33392 _078_ clknet_4_6_0_clk 0.00161f
C33393 _075_ _000_ 0
C33394 _103_ net40 0
C33395 _378_/a_382_118# net159 0
C33396 net155 _390_/a_382_118# 0.00388f
C33397 _206_ _390_/a_285_412# 0.00383f
C33398 net37 _436_/a_244_412# 0
C33399 hold124/a_326_118# net71 0.00639f
C33400 _178_ _699_/a_298_337# 0.00272f
C33401 _675_/a_2250_412# _674_/a_1489_191# 0
C33402 _675_/a_843_236# _030_ 0
C33403 _257_ _161_ 0
C33404 hold165/a_56_118# _380_/a_59_156# 0
C33405 _230_ VPWR 0.65745f
C33406 _256_ _161_ 0.05701f
C33407 _245_ _236_ 0
C33408 _341_/a_382_118# clkbuf_4_4_0_clk/a_27_118# 0
C33409 baud_inst.counter\[4\] hold95/a_56_118# 0
C33410 net152 hold95/a_326_118# 0
C33411 _678_/a_2002_114# net152 0
C33412 _671_/a_612_127# net29 0.01652f
C33413 _145_ input7/a_40_152# 0
C33414 FILLER_15_89/a_32_246# _686_/a_1489_191# 0
C33415 hold52/a_438_182# VPWR 0.00583f
C33416 VPWR hold61/a_438_182# 0.00853f
C33417 _358_/a_411_436# net29 0.00356f
C33418 hold120/a_326_118# _107_ 0
C33419 net95 net38 0
C33420 net102 net104 0
C33421 hold139/a_56_118# _223_ 0.00365f
C33422 _154_ _054_ 0.00182f
C33423 _680_/a_1489_191# _279_ 0
C33424 _286_ baud_inst.counter\[9\] 0
C33425 baud_inst.counter\[6\] net137 0.04511f
C33426 _512_/a_279_412# baud_inst.counter\[10\] 0.00228f
C33427 _643_/a_550_127# _154_ 0
C33428 net42 _671_/a_1583_191# 0
C33429 VPWR FILLER_22_175/a_32_246# 0.09551f
C33430 net74 hold73/a_56_118# 0
C33431 hold113/a_326_118# _310_ 0
C33432 _216_ net50 0
C33433 hold157/a_326_118# _688_/a_741_93# 0.00125f
C33434 hold157/a_438_182# _688_/a_324_432# 0
C33435 clknet_0_clk net63 0.00126f
C33436 _704_/a_298_337# rx_inst.state\[1\] 0
C33437 hold89/a_56_118# _297_ 0.0011f
C33438 _680_/a_2250_412# _505_/a_76_160# 0
C33439 _097_ clkbuf_4_2_0_clk/a_27_118# 0
C33440 baud_inst.counter\[20\] _307_ 0
C33441 _638_/a_843_236# net70 0
C33442 _232_ _224_ 0.0646f
C33443 _658_/a_2250_412# _656_/a_38_114# 0
C33444 _013_ net90 0.08589f
C33445 _644_/a_1840_334# VPWR 0.00466f
C33446 net49 _428_/a_150_412# 0
C33447 FILLER_8_19/a_40_246# _681_/a_298_337# 0
C33448 _187_ _297_ 0
C33449 hold130/a_438_182# net40 0
C33450 _378_/a_559_412# tx_inst.data_reg\[1\] 0
C33451 _357_/a_252_412# _180_ 0
C33452 baud_inst.counter\[17\] _526_/a_248_122# 0.00216f
C33453 net128 _685_/a_324_432# 0.06917f
C33454 _650_/a_741_93# net19 0
C33455 hold119/a_438_182# _157_ 0
C33456 hold59/a_438_182# net59 0
C33457 net43 _668_/a_1489_191# 0
C33458 baud_inst.counter\[14\] net90 0.16751f
C33459 _230_ _239_ 0.02018f
C33460 net37 _671_/a_741_93# 0
C33461 _694_/a_132_114# clknet_4_10_0_clk 0
C33462 net108 _682_/a_1583_191# 0
C33463 _695_/a_1583_191# net99 0
C33464 FILLER_14_202/a_40_246# _061_ 0
C33465 _545_/a_146_122# _309_ 0
C33466 net106 _315_ 0.13665f
C33467 _545_/a_350_122# baud_inst.counter\[24\] 0.00204f
C33468 output23/a_40_152# _705_/a_843_236# 0.00157f
C33469 _226_ FILLER_19_149/a_40_246# 0.00195f
C33470 output13/a_40_152# _471_/a_22_110# 0
C33471 hold132/a_438_182# _158_ 0.00775f
C33472 _653_/a_843_236# _652_/a_1840_334# 0
C33473 FILLER_13_102/a_32_246# hold128/a_56_118# 0
C33474 hold177/a_438_182# clknet_0_clk 0.01117f
C33475 _054_ FILLER_20_198/a_40_246# 0
C33476 hold110/a_326_118# _183_ 0
C33477 _645_/a_1583_191# VPWR 0.00655f
C33478 _660_/a_38_114# _071_ 0.01713f
C33479 _660_/a_324_432# net41 0.02256f
C33480 net151 _251_ 0
C33481 _135_ _253_ 0.05893f
C33482 tx_inst.data_reg\[6\] net184 0.04988f
C33483 net55 _706_/a_612_127# 0
C33484 fanout24/a_40_152# _161_ 0.0066f
C33485 tx_inst.bit_index\[2\] _403_/a_22_110# 0
C33486 hold76/a_326_118# net76 0
C33487 hold117/a_438_182# net40 0
C33488 FILLER_26_227/a_40_246# hold72/a_56_118# 0.00786f
C33489 _487_/a_248_122# clknet_0_clk 0
C33490 hold178/a_326_118# hold109/a_56_118# 0.00494f
C33491 _483_/a_120_432# net28 0
C33492 hold134/a_438_182# net133 0.01149f
C33493 hold134/a_56_118# _028_ 0.0242f
C33494 baud_inst.counter\[20\] FILLER_25_25/a_40_246# 0.0023f
C33495 hold118/a_438_182# _129_ 0.00624f
C33496 _019_ _181_ 0.49754f
C33497 clknet_4_1_0_clk _386_/a_559_412# 0
C33498 hold166/a_438_182# net63 0
C33499 hold70/a_438_182# hold72/a_326_118# 0
C33500 _201_ _199_ 0.15105f
C33501 net55 _705_/a_298_337# 0
C33502 _661_/a_1583_191# FILLER_0_128/a_40_246# 0
C33503 _689_/a_298_337# clknet_4_2_0_clk 0.00237f
C33504 _654_/a_324_432# net170 0
C33505 rx_data[0] _273_ 0
C33506 net111 _122_ 0.12568f
C33507 tx_data[0] tx_data[2] 0.41845f
C33508 _680_/a_2250_412# _092_ 0
C33509 net145 FILLER_7_121/a_40_246# 0
C33510 _646_/a_741_93# FILLER_21_194/a_32_246# 0
C33511 VPWR _681_/a_1840_334# 0.0038f
C33512 hold89/a_438_182# VPWR 0.00187f
C33513 hold85/a_56_118# clkbuf_4_13_0_clk/a_27_118# 0.00383f
C33514 hold90/a_56_118# clknet_4_9_0_clk 0.02353f
C33515 net120 net149 0.00369f
C33516 net153 net29 0.1917f
C33517 _423_/a_165_412# _241_ 0.00652f
C33518 _696_/a_1840_334# net46 0.01612f
C33519 _696_/a_1583_191# _099_ 0
C33520 _160_ _054_ 0.0112f
C33521 baud_inst.counter\[4\] net40 0.02336f
C33522 net74 output15/a_40_152# 0.00359f
C33523 _643_/a_550_127# _160_ 0
C33524 clk _409_/a_73_118# 0
C33525 _659_/a_298_337# clknet_4_1_0_clk 0.00191f
C33526 hold96/a_56_118# _183_ 0
C33527 _091_ net152 0
C33528 net39 _685_/a_741_93# 0
C33529 _168_ _264_ 0.03019f
C33530 _117_ _704_/a_612_127# 0
C33531 net39 _689_/a_741_93# 0.00979f
C33532 clknet_4_3_0_clk _677_/a_1840_334# 0.01335f
C33533 _547_/a_277_118# net46 0.00146f
C33534 net33 _705_/a_1840_334# 0
C33535 tx_busy FILLER_13_228/a_40_246# 0.00132f
C33536 _314_ _702_/a_298_337# 0.00149f
C33537 VPWR _649_/a_1583_191# 0.00913f
C33538 _217_ _476_/a_146_122# 0.00105f
C33539 clk fanout43/a_40_152# 0.00137f
C33540 hold99/a_56_118# _698_/a_741_93# 0.00773f
C33541 hold99/a_326_118# _698_/a_324_432# 0
C33542 clk _653_/a_1583_191# 0.01675f
C33543 _498_/a_279_412# net40 0.00277f
C33544 _073_ _664_/a_38_114# 0
C33545 net31 rx_inst.state\[2\] 0.44638f
C33546 _643_/a_843_236# net47 0.01328f
C33547 _643_/a_741_93# _054_ 0.00152f
C33548 _698_/a_2250_412# hold113/a_56_118# 0
C33549 hold181/a_438_182# clknet_4_0_0_clk 0.00186f
C33550 hold110/a_326_118# net115 0
C33551 net34 _216_ 0.47522f
C33552 _705_/a_324_432# net22 0.03077f
C33553 rx_data[7] _650_/a_324_432# 0
C33554 hold121/a_326_118# _106_ 0
C33555 clknet_0_clk FILLER_8_191/a_32_246# 0
C33556 _163_ _684_/a_1840_334# 0.01417f
C33557 _230_ _167_ 0
C33558 net92 _678_/a_612_127# 0.002f
C33559 _060_ _154_ 0.05309f
C33560 net49 FILLER_21_147/a_40_246# 0.00276f
C33561 net54 _380_/a_382_118# 0
C33562 net182 net153 0
C33563 _170_ FILLER_18_158/a_40_246# 0.00111f
C33564 _651_/a_38_114# _400_/a_192_429# 0
C33565 net75 _304_ 0
C33566 _305_ net147 0
C33567 clknet_4_0_0_clk FILLER_0_54/a_40_246# 0
C33568 hold182/a_56_118# _191_ 0.01819f
C33569 VPWR _544_/a_268_412# 0
C33570 _305_ net46 0.02065f
C33571 rx_data[5] net71 0
C33572 _556_/a_192_429# _699_/a_843_236# 0
C33573 _230_ _225_ 0.31603f
C33574 _672_/a_298_337# FILLER_2_46/a_40_246# 0
C33575 net110 net109 0
C33576 baud_inst.counter\[25\] _311_ 0.05306f
C33577 _653_/a_1785_429# _221_ 0
C33578 _117_ _707_/a_1840_334# 0
C33579 _256_ clkbuf_4_14_0_clk/a_27_118# 0
C33580 VPWR FILLER_9_70/a_40_246# 0.13205f
C33581 net121 VPWR 0.15108f
C33582 _097_ baud_inst.counter\[17\] 0
C33583 net49 _423_/a_279_412# 0
C33584 _116_ net46 0.01489f
C33585 net135 _683_/a_741_93# 0
C33586 hold117/a_56_118# _288_ 0.00824f
C33587 hold85/a_438_182# net48 0.01278f
C33588 _662_/a_681_505# net54 0
C33589 net28 FILLER_14_148/a_40_246# 0.00248f
C33590 _699_/a_324_432# VPWR 0.00993f
C33591 tx_inst.state\[4\] _275_ 0
C33592 _292_ _096_ 0.07386f
C33593 hold166/a_56_118# net26 0.08607f
C33594 net48 net37 0.00139f
C33595 _062_ net43 0
C33596 output18/a_40_152# net17 0.05015f
C33597 hold171/a_326_118# _388_/a_59_156# 0
C33598 hold171/a_56_118# _388_/a_382_118# 0
C33599 _662_/a_1840_334# clknet_4_5_0_clk 0.00143f
C33600 net44 _696_/a_843_236# 0.00209f
C33601 clknet_4_12_0_clk FILLER_19_178/a_40_246# 0.01143f
C33602 _270_ net30 0.08972f
C33603 _031_ hold105/a_438_182# 0.03363f
C33604 VPWR FILLER_8_236/a_40_246# 0.12391f
C33605 _280_ net29 0.38161f
C33606 _494_/a_165_412# clknet_0_clk 0
C33607 rx_inst.data_reg\[4\] net138 0
C33608 _255_ _236_ 0.43645f
C33609 _673_/a_2250_412# _085_ 0
C33610 _673_/a_1785_429# net38 0.00142f
C33611 _686_/a_741_93# net90 0
C33612 net180 _451_/a_155_412# 0
C33613 _488_/a_380_412# _019_ 0.0011f
C33614 _127_ _649_/a_1583_191# 0
C33615 _285_ net95 -0
C33616 net92 _037_ 0.00552f
C33617 hold117/a_438_182# _682_/a_741_93# 0
C33618 _223_ net119 0
C33619 fanout48/a_40_152# net47 0.02495f
C33620 _701_/a_741_93# net46 0
C33621 _080_ clk 0.06384f
C33622 _111_ FILLER_21_96/a_40_246# 0
C33623 FILLER_5_192/a_40_246# _197_ 0
C33624 net26 _666_/a_612_127# 0.01372f
C33625 _079_ net26 0
C33626 _468_/a_22_110# _647_/a_1583_191# 0
C33627 _032_ hold59/a_438_182# 0.00464f
C33628 net132 _161_ 0
C33629 net177 _684_/a_38_114# 0
C33630 net48 _056_ 0.07357f
C33631 _044_ output13/a_40_152# 0
C33632 _283_ FILLER_5_84/a_40_246# 0.00169f
C33633 _276_ clkbuf_4_5_0_clk/a_27_118# 0
C33634 net168 _666_/a_298_337# 0
C33635 FILLER_26_227/a_40_246# _128_ 0.0013f
C33636 _492_/a_170_412# net40 0
C33637 hold56/a_438_182# _216_ 0.00283f
C33638 _702_/a_324_432# _700_/a_2250_412# 0
C33639 _702_/a_741_93# _700_/a_1840_334# 0.00149f
C33640 _679_/a_2250_412# clknet_4_3_0_clk 0.00139f
C33641 _679_/a_1840_334# baud_inst.counter\[7\] 0
C33642 _688_/a_324_432# net40 0.03233f
C33643 net167 _669_/a_612_127# 0.0039f
C33644 hold104/a_56_118# _690_/a_843_236# 0
C33645 net49 _442_/a_146_122# 0
C33646 _147_ _386_/a_559_412# 0.00264f
C33647 _068_ _386_/a_285_118# 0.00178f
C33648 _163_ _356_/a_248_122# 0.00145f
C33649 _696_/a_741_93# clknet_0_clk 0.00168f
C33650 _659_/a_741_93# net41 0.03379f
C33651 net67 hold58/a_56_118# 0
C33652 net106 hold106/a_438_182# 0.00615f
C33653 hold137/a_438_182# FILLER_7_121/a_40_246# 0.00941f
C33654 net182 _280_ 0.00935f
C33655 _240_ rx_inst.state\[4\] 0
C33656 _310_ _541_/a_209_168# 0
C33657 net147 _693_/a_1489_191# 0
C33658 _266_ _649_/a_1583_191# 0.00878f
C33659 net30 _649_/a_1840_334# 0
C33660 _693_/a_1489_191# net46 0.00517f
C33661 hold88/a_438_182# _013_ 0
C33662 net2 _409_/a_73_118# 0.04624f
C33663 _240_ net119 0.01151f
C33664 VPWR _471_/a_120_432# 0
C33665 _177_ _699_/a_2250_412# 0.00159f
C33666 tx_inst.bit_index\[1\] _652_/a_741_93# 0
C33667 net147 _020_ 0
C33668 net100 _546_/a_192_429# 0
C33669 _361_/a_248_122# net34 0
C33670 _199_ tx_inst.state\[3\] 0
C33671 hold139/a_326_118# clknet_0_clk 0
C33672 _636_/a_324_432# hold84/a_438_182# 0
C33673 _069_ _146_ 0
C33674 tx_inst.data_reg\[6\] _341_/a_71_118# 0.05391f
C33675 clknet_4_0_0_clk net135 0.08451f
C33676 _519_/a_379_118# baud_inst.counter\[14\] 0
C33677 net26 fanout26/a_40_152# 0.00476f
C33678 FILLER_4_172/a_32_246# _197_ 0
C33679 fanout27/a_40_152# _084_ 0
C33680 hold88/a_438_182# baud_inst.counter\[14\] 0.00269f
C33681 VPWR FILLER_1_212/a_32_246# 0.0797f
C33682 tx_inst.data_reg\[4\] _072_ 0
C33683 hold171/a_438_182# tx_inst.data_reg\[7\] 0.01654f
C33684 _659_/a_298_337# _147_ 0.00857f
C33685 _659_/a_38_114# _068_ 0.03157f
C33686 _659_/a_2250_412# _657_/a_2250_412# 0.00235f
C33687 net156 _189_ 0.00222f
C33688 rx_inst.data_reg\[4\] _047_ 0
C33689 _698_/a_843_236# VPWR 0.0053f
C33690 hold100/a_438_182# _110_ 0
C33691 hold100/a_326_118# net142 0
C33692 clknet_4_1_0_clk _385_/a_46_156# 0
C33693 clknet_4_4_0_clk net168 1.51065f
C33694 fanout43/a_40_152# net2 0.00623f
C33695 clknet_4_13_0_clk net80 0.01029f
C33696 hold96/a_326_118# net96 0.00136f
C33697 hold96/a_56_118# clknet_4_3_0_clk 0
C33698 net158 _522_/a_209_168# 0
C33699 _644_/a_38_114# _232_ 0.00175f
C33700 hold127/a_438_182# VPWR 0.02091f
C33701 _246_ rx_inst.bit_index\[2\] 0.00108f
C33702 _206_ net159 0.16161f
C33703 net26 _395_/a_248_122# 0
C33704 net37 _250_ 0.02285f
C33705 _178_ _699_/a_1583_191# 0.01066f
C33706 baud_inst.counter\[3\] _674_/a_2250_412# 0
C33707 _154_ _649_/a_741_93# 0.01067f
C33708 _661_/a_38_114# _383_/a_46_156# 0
C33709 _494_/a_165_412# _182_ 0
C33710 net31 _226_ 0.13791f
C33711 _232_ FILLER_23_158/a_40_246# 0.00251f
C33712 hold115/a_326_118# _288_ 0
C33713 _191_ net29 0.10661f
C33714 _077_ _706_/a_741_93# 0
C33715 rx net2 0.58823f
C33716 _354_/a_170_412# _014_ 0
C33717 FILLER_10_78/a_32_246# _180_ 0
C33718 net42 hold123/a_326_118# 0.00167f
C33719 baud_inst.counter\[16\] _684_/a_132_114# 0
C33720 rx_inst.data_reg\[1\] _429_/a_142_412# 0.0032f
C33721 net45 fanout45/a_40_152# 0.01081f
C33722 _010_ _183_ 0
C33723 _205_ _670_/a_1583_191# 0
C33724 net103 _687_/a_132_114# 0
C33725 _645_/a_298_337# _232_ 0
C33726 FILLER_19_75/a_40_246# net140 0
C33727 _690_/a_38_114# _104_ 0
C33728 _497_/a_170_412# baud_inst.counter\[5\] 0
C33729 FILLER_13_100/a_40_246# net46 0
C33730 net24 net25 0.00142f
C33731 _638_/a_2250_412# net18 0.00568f
C33732 _638_/a_612_127# net70 0
C33733 hold52/a_56_118# _236_ 0
C33734 hold175/a_56_118# clknet_0_clk 0.00321f
C33735 _371_/a_170_412# _200_ 0
C33736 _411_/a_115_308# _409_/a_73_118# 0
C33737 rx_inst.data_reg\[0\] _264_ 0.01235f
C33738 _384_/a_59_156# net171 0.00494f
C33739 _041_ clk 0
C33740 _650_/a_1785_429# net19 0.00115f
C33741 net69 clknet_4_15_0_clk 0.01368f
C33742 _201_ _365_/a_257_140# 0
C33743 _180_ _189_ 0.08192f
C33744 _240_ _433_/a_244_412# 0
C33745 hold130/a_56_118# FILLER_14_72/a_32_246# 0.00404f
C33746 _341_/a_382_118# VPWR 0.00336f
C33747 _694_/a_1489_191# clknet_4_10_0_clk 0.0049f
C33748 rx_data[4] hold118/a_326_118# 0
C33749 _222_ _220_ 0.00937f
C33750 net67 _700_/a_1489_191# 0
C33751 _448_/a_142_412# _257_ 0.00548f
C33752 _311_ baud_inst.counter\[24\] 0.04197f
C33753 _660_/a_1583_191# _392_/a_59_156# 0
C33754 _478_/a_27_156# net11 0.07207f
C33755 net23 _705_/a_1840_334# 0
C33756 tx_done _705_/a_1583_191# 0
C33757 _116_ _313_ 0.00276f
C33758 _653_/a_324_432# _063_ 0.00118f
C33759 net182 _191_ 0.76024f
C33760 baud_inst.counter\[27\] _698_/a_1489_191# 0
C33761 net55 _119_ 0.13982f
C33762 hold98/a_438_182# FILLER_11_32/a_32_246# 0
C33763 net178 hold109/a_438_182# 0
C33764 net28 _004_ 0.02524f
C33765 hold147/a_438_182# _692_/a_1840_334# 0
C33766 hold57/a_56_118# _651_/a_612_127# 0
C33767 baud_inst.counter\[16\] _523_/a_257_140# 0.00137f
C33768 net51 _668_/a_132_114# 0
C33769 _707_/a_843_236# rx_inst.state\[1\] 0.0036f
C33770 _138_ _649_/a_298_337# 0.00174f
C33771 _506_/a_257_140# net115 0.0014f
C33772 net47 _634_/a_298_337# 0.02208f
C33773 net55 _656_/a_324_432# 0.00182f
C33774 clknet_4_4_0_clk _146_ 0
C33775 _292_ _190_ 0.02488f
C33776 _080_ net2 0
C33777 net79 net38 0.10226f
C33778 _275_ FILLER_7_210/a_40_246# 0
C33779 _183_ baud_inst.counter\[11\] 0.00143f
C33780 net12 net64 0
C33781 net184 net183 0.0018f
C33782 _232_ _649_/a_298_337# 0
C33783 _160_ _649_/a_741_93# 0
C33784 tx_inst.bit_index\[0\] _666_/a_38_114# 0.01504f
C33785 hold56/a_56_118# _666_/a_132_114# 0
C33786 _689_/a_1583_191# clknet_4_2_0_clk 0.01029f
C33787 hold129/a_438_182# _180_ 0.00825f
C33788 _671_/a_2250_412# _650_/a_38_114# 0
C33789 hold161/a_56_118# _102_ 0
C33790 FILLER_16_166/a_32_246# net62 0
C33791 _635_/a_612_127# clkbuf_4_13_0_clk/a_27_118# 0
C33792 _313_ _701_/a_741_93# 0
C33793 _029_ _314_ 0.02596f
C33794 _051_ _236_ 0
C33795 _010_ net115 0
C33796 hold184/a_326_118# clknet_0_clk 0
C33797 hold74/a_56_118# _125_ 0
C33798 net36 net175 0.11618f
C33799 net30 _471_/a_22_110# 0.01136f
C33800 _266_ _471_/a_120_432# 0.00206f
C33801 _424_/a_550_140# VPWR 0
C33802 net53 FILLER_22_118/a_32_246# 0.01567f
C33803 _659_/a_1583_191# clknet_4_1_0_clk 0.00368f
C33804 net153 _493_/a_45_160# 0
C33805 _233_ _137_ 0
C33806 net31 _434_/a_252_412# 0.00292f
C33807 _277_ _482_/a_154_118# 0.00315f
C33808 _691_/a_1583_191# _105_ 0
C33809 _230_ _428_/a_252_412# 0.00181f
C33810 tx_inst.data_reg\[6\] _074_ 0
C33811 _643_/a_843_236# _649_/a_324_432# 0
C33812 _643_/a_741_93# _649_/a_741_93# 0
C33813 FILLER_10_78/a_32_246# baud_inst.counter\[11\] 0.01342f
C33814 hold55/a_56_118# tx_start 0.00894f
C33815 net39 _689_/a_1785_429# 0
C33816 net44 _104_ 0.07733f
C33817 net4 _390_/a_59_156# 0
C33818 _662_/a_324_432# tx_inst.data_reg\[0\] 0
C33819 _265_ net30 0.03312f
C33820 _431_/a_175_118# _224_ 0
C33821 VPWR _649_/a_2002_114# 0
C33822 FILLER_8_92/a_32_246# hold93/a_56_118# 0.00404f
C33823 _217_ _274_ 0.03103f
C33824 _656_/a_298_337# clknet_4_4_0_clk 0
C33825 _656_/a_324_432# _067_ 0.03069f
C33826 net154 baud_inst.counter\[11\] 0
C33827 clk _653_/a_2002_114# 0
C33828 net37 _374_/a_550_140# 0.00146f
C33829 _180_ _309_ 0
C33830 hold162/a_438_182# net162 0.0223f
C33831 _536_/a_192_429# _022_ 0.00239f
C33832 _643_/a_612_127# net47 0.00277f
C33833 _088_ hold61/a_56_118# 0
C33834 _073_ _664_/a_1840_334# 0.00348f
C33835 _663_/a_38_114# clknet_4_7_0_clk 0.00219f
C33836 _695_/a_843_236# _108_ 0
C33837 _705_/a_2250_412# net22 0.01769f
C33838 FILLER_15_67/a_40_246# baud_inst.counter\[13\] 0
C33839 rx_data[7] _650_/a_2250_412# 0.00284f
C33840 _652_/a_132_114# _063_ 0
C33841 _011_ _684_/a_1489_191# 0
C33842 FILLER_21_194/a_32_246# net24 0
C33843 _675_/a_1583_191# _672_/a_38_114# 0
C33844 net92 net93 0.00571f
C33845 _091_ _035_ 0.00176f
C33846 _189_ baud_inst.counter\[11\] 0
C33847 FILLER_29_221/a_32_246# _634_/a_843_236# 0
C33848 _286_ hold95/a_326_118# 0
C33849 net116 net38 0.00358f
C33850 hold172/a_56_118# net11 0.0156f
C33851 _651_/a_324_432# net183 0
C33852 FILLER_0_130/a_32_246# FILLER_0_128/a_40_246# 0.0524f
C33853 _677_/a_1840_334# baud_inst.counter\[5\] 0.00228f
C33854 net51 _667_/a_843_236# 0
C33855 baud_inst.counter\[27\] baud_inst.counter\[23\] 0
C33856 _316_ _699_/a_843_236# 0
C33857 hold140/a_56_118# _697_/a_324_432# 0
C33858 hold86/a_438_182# _673_/a_324_432# 0
C33859 hold86/a_326_118# _673_/a_741_93# 0.00171f
C33860 net20 net81 0
C33861 rx_done _050_ 0
C33862 _073_ FILLER_3_207/a_40_246# 0.00315f
C33863 _679_/a_132_114# net135 0
C33864 _679_/a_681_505# _287_ 0
C33865 rx_inst.state\[2\] net62 0.05057f
C33866 _487_/a_248_122# net43 0
C33867 net42 _001_ 0.04161f
C33868 _083_ clknet_4_9_0_clk 0.00565f
C33869 _248_ _169_ 0
C33870 clkbuf_4_12_0_clk/a_27_118# _436_/a_244_412# 0
C33871 hold131/a_326_118# net49 0
C33872 _533_/a_146_122# _303_ 0
C33873 net147 _532_/a_257_140# 0
C33874 _219_ clkbuf_4_4_0_clk/a_27_118# 0
C33875 hold108/a_438_182# clknet_4_2_0_clk 0.0016f
C33876 fanout43/a_40_152# _169_ 0
C33877 net75 FILLER_22_22/a_32_246# 0
C33878 _532_/a_257_140# net46 0.0014f
C33879 net169 net183 0
C33880 tx_inst.bit_index\[0\] net62 0.00253f
C33881 _041_ net2 0.00278f
C33882 FILLER_17_96/a_32_246# _025_ 0
C33883 _290_ _683_/a_324_432# 0
C33884 _444_/a_244_412# _243_ 0
C33885 _699_/a_2250_412# VPWR 0.0066f
C33886 hold91/a_438_182# net29 0.01408f
C33887 _639_/a_741_93# net19 0.01118f
C33888 net36 _161_ 0.37596f
C33889 _661_/a_2250_412# net5 0.00161f
C33890 _674_/a_741_93# VPWR 0.02209f
C33891 VPWR _651_/a_1489_191# 0
C33892 _227_ net166 0
C33893 _018_ _529_/a_45_160# 0
C33894 net44 _696_/a_612_127# 0.00222f
C33895 hold148/a_56_118# _693_/a_741_93# 0.00324f
C33896 tx_inst.data_reg\[4\] _388_/a_559_412# 0
C33897 hold87/a_326_118# clknet_4_8_0_clk 0.00441f
C33898 net79 FILLER_0_42/a_32_246# 0.01198f
C33899 _070_ _211_ 0.13415f
C33900 tx_inst.data_reg\[5\] _142_ 0
C33901 _663_/a_843_236# _166_ 0.00197f
C33902 _655_/a_132_114# net40 0
C33903 _139_ net24 0.02347f
C33904 _493_/a_45_160# _280_ 0
C33905 _658_/a_681_505# _069_ 0
C33906 _397_/a_165_412# VPWR 0
C33907 _152_ _215_ 0
C33908 _238_ clkbuf_4_14_0_clk/a_27_118# 0.00267f
C33909 _701_/a_1785_429# net46 0
C33910 _677_/a_38_114# clknet_0_clk 0.06421f
C33911 net70 net47 0
C33912 net140 _309_ 0.16107f
C33913 _270_ _647_/a_2250_412# 0.01022f
C33914 _639_/a_324_432# hold51/a_438_182# 0
C33915 _639_/a_843_236# hold51/a_56_118# 0
C33916 _639_/a_741_93# hold51/a_326_118# 0.00279f
C33917 net172 _666_/a_1840_334# 0
C33918 net177 _684_/a_1840_334# 0.00226f
C33919 net44 hold140/a_56_118# 0.0187f
C33920 _098_ _685_/a_298_337# 0.01417f
C33921 hold104/a_56_118# _018_ 0.03219f
C33922 hold104/a_438_182# _164_ 0.01142f
C33923 net104 _530_/a_257_140# 0.00233f
C33924 _678_/a_324_432# VPWR 0
C33925 _412_/a_22_110# _205_ 0
C33926 _115_ _700_/a_38_114# 0.00161f
C33927 _152_ hold146/a_326_118# 0
C33928 _688_/a_2250_412# net40 0.00564f
C33929 _696_/a_1785_429# clknet_0_clk 0
C33930 _111_ _051_ 0.00626f
C33931 _275_ _478_/a_229_118# 0.00115f
C33932 _188_ _684_/a_38_114# 0
C33933 _187_ _684_/a_298_337# 0
C33934 hold158/a_438_182# clknet_4_2_0_clk 0
C33935 hold105/a_438_182# _313_ 0
C33936 _693_/a_2250_412# _302_ 0.00208f
C33937 baud_inst.counter\[0\] FILLER_0_80/a_40_246# 0
C33938 _036_ hold92/a_56_118# 0
C33939 _230_ _232_ 0.66321f
C33940 hold64/a_326_118# VPWR 0.00548f
C33941 _632_/a_1583_191# net64 0.0014f
C33942 _025_ net162 0
C33943 hold176/a_56_118# _261_ 0
C33944 _153_ _168_ 0.42193f
C33945 VPWR _272_ 0.04839f
C33946 _431_/a_81_118# net49 0.00165f
C33947 net2 _255_ 0
C33948 _671_/a_324_432# clkbuf_4_6_0_clk/a_27_118# 0
C33949 _636_/a_38_114# _264_ 0.00202f
C33950 net45 FILLER_27_46/a_32_246# 0
C33951 rx_data[1] _271_ 0
C33952 net13 _124_ 0.00154f
C33953 net55 _658_/a_1583_191# 0
C33954 tx_inst.data_reg\[6\] _341_/a_1109_431# 0.00148f
C33955 _232_ FILLER_22_175/a_32_246# 0.00365f
C33956 _678_/a_38_114# hold93/a_438_182# 0
C33957 _678_/a_741_93# hold93/a_56_118# 0
C33958 _676_/a_1489_191# baud_inst.counter\[5\] 0
C33959 rx_inst.state\[3\] _676_/a_843_236# 0
C33960 baud_inst.counter\[12\] _514_/a_155_412# 0.02388f
C33961 hold126/a_438_182# net70 0
C33962 _655_/a_843_236# input10/a_40_152# 0
C33963 _659_/a_1840_334# _068_ 0
C33964 _698_/a_612_127# VPWR 0
C33965 _654_/a_843_236# net41 0
C33966 hold178/a_56_118# net40 0.01556f
C33967 _080_ _169_ 0.02539f
C33968 _382_/a_59_156# _209_ 0.02987f
C33969 _094_ baud_inst.counter\[9\] 0
C33970 net158 _296_ 0
C33971 _044_ net30 0
C33972 _178_ _699_/a_2002_114# 0
C33973 _268_ _648_/a_2250_412# 0.0011f
C33974 _661_/a_324_432# _210_ 0.00301f
C33975 _299_ baud_inst.counter\[16\] 0.88216f
C33976 _170_ _436_/a_244_140# 0
C33977 net32 _436_/a_244_412# 0
C33978 _122_ clknet_4_15_0_clk 0
C33979 tx_inst.bit_index\[2\] clkbuf_4_4_0_clk/a_27_118# 0.0289f
C33980 rx_data[7] _639_/a_324_432# 0
C33981 input4/a_40_152# VPWR 0.0297f
C33982 baud_inst.counter\[20\] _692_/a_681_505# 0
C33983 hold163/a_438_182# _692_/a_1840_334# 0.00197f
C33984 tx_inst.state\[4\] net26 0
C33985 _670_/a_550_127# clknet_4_9_0_clk 0
C33986 _154_ _420_/a_350_122# 0
C33987 _677_/a_38_114# _182_ 0.01487f
C33988 _414_/a_279_412# _234_ 0
C33989 _302_ _104_ 0.11295f
C33990 _644_/a_741_93# net47 0
C33991 _191_ _493_/a_45_160# 0
C33992 net136 net181 0
C33993 _009_ net97 0.00109f
C33994 _555_/a_209_168# clknet_4_11_0_clk 0
C33995 _257_ fanout36/a_40_152# 0
C33996 hold76/a_56_118# _302_ 0.00275f
C33997 tx_inst.data_reg\[7\] hold155/a_326_118# 0.00524f
C33998 hold63/a_326_118# _002_ 0
C33999 hold74/a_56_118# _129_ 0
C34000 hold74/a_326_118# _265_ 0
C34001 fanout36/a_40_152# _256_ 0
C34002 net148 _693_/a_298_337# 0
C34003 _658_/a_1583_191# _067_ 0.02298f
C34004 FILLER_3_207/a_40_246# net41 0
C34005 net44 hold176/a_438_182# 0
C34006 net84 net64 0.02544f
C34007 _040_ hold172/a_56_118# 0
C34008 _073_ hold172/a_438_182# 0
C34009 _061_ net19 0.00459f
C34010 baud_inst.counter\[20\] hold148/a_56_118# 0
C34011 net26 _671_/a_741_93# 0.00342f
C34012 _226_ net62 0
C34013 _650_/a_1840_334# _157_ 0
C34014 net145 _339_/a_500_118# 0.00124f
C34015 _676_/a_132_114# clknet_0_clk 0
C34016 _704_/a_324_432# hold50/a_438_182# 0
C34017 net177 _356_/a_248_122# 0
C34018 clknet_4_6_0_clk _459_/a_27_156# 0
C34019 clknet_4_8_0_clk _296_ 0.25322f
C34020 _341_/a_810_118# VPWR 0
C34021 _645_/a_324_432# net47 0
C34022 net122 _191_ 0
C34023 net2 FILLER_14_185/a_32_246# 0.00132f
C34024 _155_ net71 0.39304f
C34025 net124 _268_ 0.00677f
C34026 output12/a_40_152# _638_/a_1583_191# 0
C34027 _679_/a_324_432# clknet_0_clk 0.00432f
C34028 _396_/a_257_140# net27 0
C34029 _160_ _257_ 0.22511f
C34030 _660_/a_1489_191# _392_/a_382_118# 0
C34031 hold75/a_326_118# net46 0
C34032 _672_/a_324_432# _085_ 0.00498f
C34033 _672_/a_741_93# net38 0
C34034 hold172/a_326_118# _275_ 0.00683f
C34035 _644_/a_298_337# _255_ 0
C34036 _444_/a_142_412# _161_ 0
C34037 _695_/a_2250_412# _548_/a_76_160# 0
C34038 _699_/a_38_114# net45 0.01937f
C34039 net33 net55 0.01612f
C34040 net25 _647_/a_324_432# 0
C34041 hold176/a_326_118# clknet_0_clk 0.00739f
C34042 net57 _651_/a_550_127# 0
C34043 net51 _668_/a_1489_191# 0.00424f
C34044 _707_/a_612_127# rx_inst.state\[1\] 0
C34045 _381_/a_268_412# _209_ 0.00408f
C34046 net75 _692_/a_741_93# 0.00134f
C34047 _305_ _692_/a_324_432# 0
C34048 net47 _634_/a_1583_191# 0
C34049 hold52/a_56_118# net2 0
C34050 net55 _656_/a_2250_412# 0
C34051 _706_/a_324_432# _120_ 0.01104f
C34052 _706_/a_741_93# net43 0.00803f
C34053 hold169/a_56_118# _477_/a_22_110# 0
C34054 clkbuf_4_12_0_clk/a_27_118# net48 0.00488f
C34055 hold144/a_326_118# _257_ 0.00106f
C34056 _041_ _169_ 0.82666f
C34057 baud_inst.counter\[21\] VPWR 0.34476f
C34058 tx_busy _705_/a_741_93# 0
C34059 _313_ _701_/a_1785_429# 0
C34060 _696_/a_298_337# clknet_4_8_0_clk 0.02359f
C34061 clknet_4_1_0_clk _655_/a_38_114# 0.01941f
C34062 _660_/a_298_337# _174_ 0
C34063 hold57/a_326_118# _195_ 0
C34064 hold57/a_56_118# _217_ 0
C34065 net48 _639_/a_298_337# 0
C34066 FILLER_18_65/a_40_246# _024_ 0.00303f
C34067 hold131/a_326_118# net131 0
C34068 hold137/a_56_118# VPWR 0.04317f
C34069 net98 FILLER_10_14/a_40_246# 0
C34070 net180 VPWR 0.04785f
C34071 _266_ _272_ 0.51174f
C34072 _645_/a_741_93# net49 0.00678f
C34073 net97 _683_/a_38_114# 0.00173f
C34074 net108 _683_/a_324_432# 0.1109f
C34075 net55 _382_/a_285_412# 0
C34076 hold123/a_326_118# _670_/a_1583_191# 0
C34077 net123 _670_/a_324_432# 0.02333f
C34078 hold123/a_56_118# _670_/a_1840_334# 0.00143f
C34079 net67 _703_/a_324_432# 0
C34080 FILLER_22_86/a_32_246# clknet_0_clk 0.00394f
C34081 _035_ _281_ 0.07003f
C34082 _187_ baud_inst.counter\[16\] 0
C34083 FILLER_15_173/a_40_246# net62 0
C34084 net47 _649_/a_324_432# 0
C34085 _054_ _649_/a_38_114# 0
C34086 FILLER_0_174/a_32_246# net170 0.00152f
C34087 _525_/a_46_156# net157 0.01187f
C34088 _191_ _670_/a_741_93# 0.00419f
C34089 hold77/a_326_118# _633_/a_1583_191# 0.00463f
C34090 rx_inst.bit_index\[1\] _641_/a_38_114# 0
C34091 net13 net82 0
C34092 VPWR _632_/a_741_93# 0.01254f
C34093 _679_/a_324_432# _182_ 0.03455f
C34094 net142 _696_/a_324_432# 0
C34095 _656_/a_1583_191# clknet_4_4_0_clk 0.00403f
C34096 net37 _204_ 0.0826f
C34097 hold135/a_56_118# net115 0
C34098 net112 net47 0
C34099 net49 _445_/a_165_412# 0
C34100 _663_/a_1840_334# clknet_4_7_0_clk 0
C34101 _663_/a_1583_191# tx_inst.state\[1\] 0
C34102 _695_/a_612_127# _108_ 0
C34103 _315_ _701_/a_843_236# 0
C34104 clknet_0_clk _200_ 0.03662f
C34105 hold130/a_438_182# net128 0.00208f
C34106 net49 _443_/a_354_412# 0
C34107 _277_ _404_/a_46_156# 0.0019f
C34108 VPWR _668_/a_38_114# 0.00303f
C34109 net28 _404_/a_268_412# 0
C34110 clknet_0_clk hold180/a_56_118# 0
C34111 _644_/a_1583_191# _245_ 0
C34112 VPWR _528_/a_379_118# 0
C34113 _694_/a_38_114# _106_ 0
C34114 input6/a_40_152# net6 0.00161f
C34115 hold171/a_56_118# _658_/a_324_432# 0
C34116 baud_inst.counter\[20\] _534_/a_268_412# 0
C34117 hold105/a_56_118# _700_/a_38_114# 0
C34118 net54 FILLER_2_183/a_32_246# 0.00167f
C34119 baud_inst.counter\[8\] net109 0
C34120 baud_inst.counter\[28\] _702_/a_741_93# 0.00505f
C34121 baud_inst.counter\[30\] _702_/a_38_114# 0
C34122 _111_ _698_/a_324_432# 0.03274f
C34123 net45 _698_/a_741_93# 0.00626f
C34124 FILLER_8_70/a_32_246# _287_ 0.00113f
C34125 _376_/a_170_160# net27 0
C34126 net50 _704_/a_681_505# 0
C34127 _414_/a_279_412# _233_ 0
C34128 _390_/a_59_156# net40 0
C34129 _518_/a_45_160# _189_ 0
C34130 net28 fanout31/a_40_152# 0
C34131 VPWR _648_/a_298_337# 0.02216f
C34132 VPWR _380_/a_382_118# 0.00593f
C34133 _707_/a_1583_191# FILLER_13_228/a_40_246# 0
C34134 _635_/a_741_93# net64 0.00887f
C34135 rx_inst.state\[2\] _262_ 0.05077f
C34136 hold182/a_326_118# VPWR 0.00307f
C34137 net7 FILLER_0_103/a_32_246# 0.0015f
C34138 hold116/a_56_118# clknet_4_0_0_clk 0.00102f
C34139 tx_inst.bit_index\[1\] _653_/a_1489_191# 0.00747f
C34140 _077_ _200_ 0.57426f
C34141 rx_data[7] _264_ 0.04688f
C34142 clkbuf_4_12_0_clk/a_27_118# _250_ 0.11918f
C34143 _264_ hold72/a_56_118# 0
C34144 _304_ _303_ 0.02427f
C34145 _312_ net99 0.00156f
C34146 hold165/a_56_118# net41 0.01091f
C34147 _657_/a_1583_191# _339_/a_71_118# 0
C34148 _020_ _692_/a_324_432# 0.00493f
C34149 net163 _692_/a_843_236# 0.00112f
C34150 _694_/a_132_114# VPWR 0
C34151 _639_/a_1583_191# _707_/a_324_432# 0
C34152 _639_/a_324_432# _707_/a_1583_191# 0
C34153 _082_ net167 0.03749f
C34154 _639_/a_1785_429# net19 0
C34155 _363_/a_22_110# _360_/a_1377_160# 0
C34156 _041_ _084_ 0.01614f
C34157 net35 _241_ 0.00528f
C34158 _695_/a_1840_334# net46 0
C34159 FILLER_24_218/a_40_246# _638_/a_324_432# 0.00155f
C34160 net35 FILLER_25_163/a_32_246# 0
C34161 hold111/a_326_118# _122_ 0.00635f
C34162 hold111/a_438_182# net65 0.00767f
C34163 _382_/a_382_118# _149_ 0.01216f
C34164 tx_inst.data_reg\[7\] _387_/a_268_412# 0
C34165 hold98/a_438_182# hold117/a_438_182# 0
C34166 net110 baud_inst.counter\[8\] 0
C34167 net48 net32 0.00218f
C34168 _674_/a_1785_429# VPWR 0
C34169 net44 _024_ 0.00145f
C34170 _230_ _406_/a_154_118# 0
C34171 _206_ tx_data[6] 0.03608f
C34172 VPWR FILLER_21_229/a_32_246# 0.07816f
C34173 _554_/a_146_122# baud_inst.counter\[29\] 0
C34174 net20 hold80/a_438_182# 0.0011f
C34175 rx_done hold80/a_326_118# 0.0094f
C34176 _662_/a_681_505# VPWR 0
C34177 _638_/a_298_337# rx_inst.data_reg\[6\] 0
C34178 net70 _649_/a_324_432# 0
C34179 _638_/a_324_432# _632_/a_298_337# 0
C34180 _638_/a_298_337# _632_/a_324_432# 0
C34181 net54 _275_ 0.04985f
C34182 _663_/a_612_127# _166_ 0.00176f
C34183 baud_inst.counter\[30\] FILLER_26_88/a_40_246# 0.0016f
C34184 net7 _384_/a_59_156# 0
C34185 _655_/a_1489_191# net40 0
C34186 rx_inst.state\[2\] rx_inst.state\[3\] 0.0446f
C34187 net53 _640_/a_741_93# 0.00317f
C34188 hold75/a_326_118# _313_ 0
C34189 _219_ VPWR 0.02666f
C34190 hold117/a_56_118# clknet_4_2_0_clk 0
C34191 _191_ _667_/a_550_127# 0
C34192 _695_/a_550_127# net76 0
C34193 _645_/a_324_432# _644_/a_741_93# 0.00318f
C34194 _645_/a_741_93# _644_/a_324_432# 0.00489f
C34195 hold121/a_438_182# net49 0.0569f
C34196 _087_ _033_ 0
C34197 _673_/a_741_93# VPWR 0.01638f
C34198 _677_/a_1840_334# clknet_0_clk 0
C34199 net167 clknet_0_clk 0.00254f
C34200 _636_/a_843_236# rx_inst.data_reg\[7\] 0
C34201 net125 hold127/a_326_118# 0.00253f
C34202 _098_ _685_/a_1583_191# 0
C34203 _674_/a_38_114# _181_ 0
C34204 _678_/a_2250_412# VPWR 0.00538f
C34205 net104 _690_/a_550_127# 0
C34206 hold104/a_326_118# _103_ 0.01271f
C34207 _115_ _700_/a_1840_334# 0.00497f
C34208 tx_inst.state\[4\] net50 0.00724f
C34209 baud_inst.counter\[19\] net103 0.05318f
C34210 _232_ hold127/a_438_182# 0.02154f
C34211 hold108/a_438_182# _683_/a_1583_191# 0
C34212 hold108/a_326_118# _683_/a_1840_334# 0
C34213 _206_ _384_/a_382_118# 0.02112f
C34214 net155 _384_/a_59_156# 0
C34215 net111 hold111/a_56_118# 0.00113f
C34216 net23 tx_done 0.15028f
C34217 hold176/a_438_182# _697_/a_2250_412# 0
C34218 _632_/a_1489_191# _273_ 0
C34219 _060_ _649_/a_38_114# 0.03378f
C34220 net73 _636_/a_324_432# 0
C34221 _687_/a_324_432# _296_ 0.04602f
C34222 net36 FILLER_18_148/a_40_246# 0.0084f
C34223 _632_/a_843_236# net30 0.05746f
C34224 _632_/a_741_93# _266_ 0
C34225 tx_inst.bit_index\[1\] _063_ 0
C34226 net163 _690_/a_1489_191# 0
C34227 _636_/a_1840_334# _264_ 0
C34228 hold168/a_56_118# _206_ 0.02057f
C34229 _171_ _664_/a_1840_334# 0
C34230 baud_inst.counter\[12\] _293_ 0.10439f
C34231 _112_ clknet_4_10_0_clk 0.00563f
C34232 _229_ clknet_0_clk 0.00443f
C34233 _266_ _668_/a_38_114# 0.00293f
C34234 _000_ _668_/a_741_93# 0
C34235 net26 _250_ 0
C34236 net156 _689_/a_38_114# 0.0021f
C34237 output15/a_40_152# _270_ 0
C34238 _455_/a_155_412# _130_ 0.00142f
C34239 FILLER_11_142/a_40_246# _667_/a_324_432# 0
C34240 baud_inst.counter\[5\] baud_inst.counter\[11\] 0
C34241 net23 net55 0
C34242 hold74/a_56_118# net16 0.0068f
C34243 clknet_4_1_0_clk _210_ 0.00525f
C34244 _093_ net135 0
C34245 _215_ net168 0.0401f
C34246 net32 _250_ 0.00198f
C34247 _536_/a_341_118# _304_ 0.01036f
C34248 clkbuf_4_2_0_clk/a_27_118# _683_/a_38_114# 0
C34249 _688_/a_843_236# _296_ 0
C34250 clknet_4_11_0_clk hold100/a_326_118# 0
C34251 net39 _282_ 0.00168f
C34252 _090_ baud_inst.counter\[4\] 0
C34253 hold101/a_438_182# baud_inst.counter\[16\] 0
C34254 rx_data[7] _639_/a_2250_412# 0
C34255 hold66/a_56_118# net30 0.00213f
C34256 tx _665_/a_1840_334# 0
C34257 _183_ _287_ 0.01026f
C34258 _277_ net62 0.06397f
C34259 net28 _168_ 0.61581f
C34260 _636_/a_298_337# _156_ 0
C34261 _703_/a_741_93# _702_/a_843_236# 0
C34262 _680_/a_612_127# _030_ 0
C34263 baud_inst.counter\[20\] _692_/a_550_127# 0
C34264 baud_inst.counter\[10\] _509_/a_257_140# 0
C34265 _154_ _238_ 0.07507f
C34266 _677_/a_1840_334# _182_ 0
C34267 _266_ _648_/a_298_337# 0.00225f
C34268 net30 _648_/a_38_114# 0
C34269 hold146/a_56_118# _200_ 0.00918f
C34270 hold146/a_438_182# net172 0
C34271 _204_ _667_/a_1489_191# 0
C34272 FILLER_18_65/a_40_246# baud_inst.counter\[25\] 0
C34273 net36 _418_/a_268_412# 0
C34274 VPWR net95 0.11776f
C34275 _095_ net108 0
C34276 _662_/a_843_236# net179 0.00403f
C34277 _114_ _550_/a_209_168# 0
C34278 _377_/a_268_412# _207_ 0.00167f
C34279 rx_done output23/a_40_152# 0
C34280 output20/a_40_152# tx_done 0.00315f
C34281 rx_inst.data_reg\[7\] hold81/a_438_182# 0
C34282 hold88/a_438_182# _687_/a_843_236# 0
C34283 _021_ _693_/a_681_505# 0.00109f
C34284 _680_/a_843_236# _030_ 0
C34285 hold86/a_326_118# net79 0.00313f
C34286 _022_ net76 0.00977f
C34287 _180_ _685_/a_38_114# 0.00579f
C34288 _227_ _642_/a_2250_412# 0.00565f
C34289 hold124/a_326_118# _154_ 0
C34290 hold124/a_438_182# net126 0
C34291 hold77/a_438_182# _158_ 0
C34292 _674_/a_38_114# _088_ 0.00197f
C34293 hold97/a_326_118# hold109/a_326_118# 0
C34294 net26 _671_/a_1785_429# 0.00185f
C34295 _226_ _262_ 0.00171f
C34296 _641_/a_2250_412# net25 0
C34297 _676_/a_1489_191# clknet_0_clk 0
C34298 hold101/a_56_118# net49 0.00389f
C34299 hold89/a_56_118# FILLER_16_56/a_32_246# 0.00404f
C34300 net12 _638_/a_324_432# 0.00242f
C34301 hold120/a_326_118# _023_ 0.00195f
C34302 tx_inst.bit_index\[2\] VPWR 0.58703f
C34303 net31 _404_/a_46_156# 0
C34304 _645_/a_2250_412# net47 0.00195f
C34305 _697_/a_324_432# baud_inst.counter\[25\] 0.00799f
C34306 _697_/a_843_236# net99 0
C34307 net54 _071_ 0.10445f
C34308 net105 hold105/a_56_118# 0.03064f
C34309 hold106/a_438_182# _701_/a_843_236# 0
C34310 clknet_4_5_0_clk _392_/a_285_412# 0.00109f
C34311 _679_/a_2250_412# clknet_0_clk 0.00363f
C34312 _398_/a_358_436# _216_ 0.00126f
C34313 _398_/a_115_308# _143_ 0.0074f
C34314 _482_/a_154_118# net62 0
C34315 clknet_4_13_0_clk clknet_0_clk 0
C34316 _045_ clknet_4_14_0_clk 0.00275f
C34317 hold93/a_438_182# net29 0.00147f
C34318 FILLER_14_185/a_32_246# _084_ 0
C34319 net73 hold81/a_56_118# 0
C34320 FILLER_15_185/a_32_246# VPWR 0.07942f
C34321 _128_ _264_ 1.30189f
C34322 FILLER_25_198/a_32_246# net48 0
C34323 _356_/a_248_122# _188_ 0
C34324 _356_/a_146_122# _187_ 0.00183f
C34325 _155_ _273_ 0
C34326 clknet_0_clk _683_/a_1489_191# 0
C34327 _687_/a_38_114# net88 0
C34328 _687_/a_298_337# _014_ 0
C34329 baud_inst.counter\[31\] _112_ 0
C34330 net39 _293_ 0
C34331 net51 _670_/a_2250_412# 0
C34332 _159_ _161_ 0.00213f
C34333 FILLER_11_142/a_40_246# FILLER_11_144/a_32_246# 0.0524f
C34334 _695_/a_2250_412# _312_ 0
C34335 _695_/a_1840_334# _313_ 0.00174f
C34336 hold158/a_56_118# _102_ 0.0014f
C34337 _232_ _424_/a_550_140# 0.00127f
C34338 _699_/a_1840_334# net45 0.01231f
C34339 clkbuf_4_11_0_clk/a_27_118# _026_ 0
C34340 net51 rx_inst.state\[1\] 0.22137f
C34341 net57 clknet_4_6_0_clk 0.00106f
C34342 _697_/a_843_236# clkbuf_4_9_0_clk/a_27_118# 0
C34343 hold125/a_326_118# net127 0.00219f
C34344 FILLER_11_142/a_40_246# _142_ 0
C34345 _292_ _685_/a_324_432# 0.04326f
C34346 _305_ _692_/a_2250_412# 0
C34347 _023_ _692_/a_1840_334# 0
C34348 _706_/a_1785_429# net43 0
C34349 _671_/a_612_127# hold62/a_56_118# 0
C34350 _671_/a_132_114# rx_inst.state\[4\] 0
C34351 clkbuf_4_8_0_clk/a_27_118# _100_ 0.00205f
C34352 _226_ rx_inst.state\[3\] 0
C34353 net42 FILLER_11_142/a_40_246# 0.02564f
C34354 rx_inst.bit_index\[2\] _427_/a_350_122# 0.00376f
C34355 hold169/a_438_182# net169 0
C34356 hold169/a_326_118# _007_ 0.0343f
C34357 _705_/a_741_93# _704_/a_741_93# 0.00191f
C34358 _705_/a_324_432# _704_/a_843_236# 0
C34359 _671_/a_1583_191# _061_ 0
C34360 net10 net6 0.00786f
C34361 _657_/a_324_432# VPWR 0.01011f
C34362 net115 _287_ 0.2938f
C34363 hold178/a_56_118# _519_/a_81_118# 0
C34364 net65 clknet_0_clk 0.00465f
C34365 _696_/a_1583_191# clknet_4_8_0_clk 0
C34366 net37 _421_/a_354_412# 0.00108f
C34367 net57 _218_ 0
C34368 clknet_4_1_0_clk _655_/a_1840_334# 0
C34369 _095_ FILLER_10_14/a_40_246# 0.00355f
C34370 _688_/a_298_337# clknet_4_2_0_clk 0.00657f
C34371 net48 _639_/a_1583_191# 0
C34372 net90 hold91/a_326_118# 0.01539f
C34373 hold90/a_326_118# net91 0.00846f
C34374 hold119/a_326_118# VPWR 0.03615f
C34375 _693_/a_2250_412# FILLER_22_32/a_40_246# 0
C34376 _046_ _632_/a_38_114# 0
C34377 _055_ fanout48/a_40_152# 0.0096f
C34378 hold170/a_56_118# net170 0.00221f
C34379 net27 _222_ 0.0019f
C34380 net108 _683_/a_2250_412# 0.00265f
C34381 net123 _670_/a_2250_412# 0
C34382 _483_/a_22_110# clknet_0_clk 0.00268f
C34383 hold65/a_438_182# _264_ 0
C34384 _646_/a_1583_191# net85 0
C34385 net47 _649_/a_2250_412# 0.00315f
C34386 _054_ _649_/a_1840_334# 0
C34387 net44 baud_inst.counter\[25\] 0.08343f
C34388 _299_ _016_ 0.01149f
C34389 net16 _647_/a_1840_334# 0
C34390 rx_data[4] _647_/a_1583_191# 0
C34391 _191_ _670_/a_1785_429# 0.00158f
C34392 _082_ _669_/a_38_114# 0.00358f
C34393 net44 _669_/a_324_432# 0.05201f
C34394 hold139/a_56_118# _136_ 0.05438f
C34395 hold139/a_326_118# _249_ 0
C34396 rx_inst.bit_index\[1\] _641_/a_1840_334# 0
C34397 _388_/a_382_118# _212_ 0.07271f
C34398 FILLER_24_229/a_32_246# _267_ 0.0012f
C34399 VPWR _632_/a_1785_429# 0
C34400 hold113/a_326_118# _165_ 0
C34401 _656_/a_1489_191# tx_inst.data_reg\[2\] 0.00867f
C34402 hold54/a_438_182# _665_/a_1840_334# 0.00197f
C34403 _034_ _685_/a_741_93# 0
C34404 _135_ _170_ 0.02047f
C34405 net142 _696_/a_2250_412# 0
C34406 net50 FILLER_7_210/a_40_246# 0.02048f
C34407 _191_ FILLER_11_123/a_40_246# 0.0064f
C34408 net39 _688_/a_741_93# 0
C34409 _446_/a_248_122# _043_ 0
C34410 net49 _257_ 0.02312f
C34411 _182_ _683_/a_1489_191# 0
C34412 _508_/a_177_436# _288_ 0.00182f
C34413 net76 _108_ 0.01292f
C34414 net49 _256_ 1.78757f
C34415 baud_inst.counter\[1\] baud_inst.counter\[2\] 0.1724f
C34416 hold168/a_56_118# _202_ 0.00228f
C34417 _004_ _223_ 0
C34418 VPWR _668_/a_1840_334# 0.00237f
C34419 _644_/a_2002_114# _245_ 0
C34420 baud_inst.counter\[3\] _672_/a_324_432# 0.00265f
C34421 _675_/a_741_93# clknet_4_0_0_clk 0.03186f
C34422 VPWR _301_ 0.41757f
C34423 tx_inst.data_reg\[4\] _658_/a_843_236# 0.00302f
C34424 net39 FILLER_12_117/a_40_246# 0
C34425 _513_/a_192_429# net29 0
C34426 net103 FILLER_17_24/a_32_246# 0.01136f
C34427 _696_/a_1583_191# _686_/a_1840_334# 0
C34428 baud_inst.counter\[30\] _702_/a_1840_334# 0.01791f
C34429 _116_ hold58/a_56_118# 0
C34430 net45 _698_/a_1785_429# 0
C34431 clknet_0_clk _669_/a_38_114# 0.00232f
C34432 net66 VPWR 0.02826f
C34433 _006_ tx_inst.state\[2\] 0.00172f
C34434 _269_ rx_data[7] 0.00363f
C34435 clk hold145/a_438_182# 0.01428f
C34436 tx_inst.state\[4\] _705_/a_38_114# 0.00126f
C34437 _698_/a_843_236# FILLER_20_95/a_40_246# 0
C34438 hold96/a_56_118# _182_ 0.05111f
C34439 FILLER_16_154/a_32_246# _229_ 0
C34440 VPWR _648_/a_1583_191# 0.00759f
C34441 _698_/a_741_93# FILLER_21_96/a_40_246# 0.00114f
C34442 clknet_4_3_0_clk _287_ 0
C34443 _693_/a_741_93# clknet_4_10_0_clk 0.06655f
C34444 _635_/a_1785_429# net64 0
C34445 net85 net64 0.00497f
C34446 _508_/a_380_412# _682_/a_843_236# 0
C34447 clknet_4_5_0_clk _706_/a_38_114# 0.0059f
C34448 FILLER_6_23/a_32_246# net38 0.01978f
C34449 tx_busy hold80/a_56_118# 0.00275f
C34450 _219_ _400_/a_155_160# 0
C34451 _218_ _400_/a_341_118# 0
C34452 _633_/a_298_337# net78 0.01008f
C34453 _253_ _252_ 0.81731f
C34454 net105 _701_/a_1840_334# 0
C34455 _635_/a_298_337# net30 0.02334f
C34456 FILLER_1_90/a_32_246# tx_data[5] 0
C34457 net163 _692_/a_612_127# 0
C34458 _049_ rx_inst.data_reg\[6\] 0
C34459 _632_/a_324_432# _049_ 0
C34460 _694_/a_1489_191# VPWR 0.00139f
C34461 _639_/a_1489_191# _707_/a_741_93# 0
C34462 _639_/a_741_93# _707_/a_1489_191# 0
C34463 _050_ net19 0.00331f
C34464 _363_/a_22_110# tx_inst.bit_index\[1\] 0
C34465 _294_ net130 0
C34466 FILLER_18_65/a_40_246# baud_inst.counter\[24\] 0.00149f
C34467 net31 net62 0
C34468 hold155/a_56_118# _658_/a_38_114# 0.02058f
C34469 _677_/a_38_114# net152 0.00959f
C34470 hold57/a_438_182# _142_ 0.01465f
C34471 _102_ _689_/a_550_127# 0
C34472 _303_ FILLER_22_22/a_32_246# 0.02669f
C34473 net49 fanout24/a_40_152# 0.00146f
C34474 _235_ _416_/a_350_122# 0
C34475 net118 hold81/a_56_118# 0
C34476 clknet_4_11_0_clk _702_/a_132_114# 0
C34477 _155_ _429_/a_244_140# 0
C34478 net70 _649_/a_2250_412# 0.00518f
C34479 _138_ _272_ 0.00206f
C34480 hold102/a_56_118# _690_/a_324_432# 0.00352f
C34481 hold123/a_326_118# net39 0
C34482 _043_ _632_/a_38_114# 0.00916f
C34483 FILLER_21_175/a_32_246# _259_ 0.01888f
C34484 _697_/a_298_337# _309_ 0
C34485 _697_/a_324_432# baud_inst.counter\[24\] 0.01463f
C34486 _697_/a_741_93# net140 0.00211f
C34487 _059_ clkbuf_4_14_0_clk/a_27_118# 0.00658f
C34488 net36 fanout36/a_40_152# 0.0012f
C34489 _023_ net148 0
C34490 _645_/a_1840_334# _644_/a_843_236# 0
C34491 _245_ _424_/a_244_140# 0
C34492 net75 _021_ 0
C34493 _673_/a_1785_429# VPWR 0
C34494 _677_/a_38_114# _498_/a_165_412# 0
C34495 hold156/a_438_182# FILLER_12_42/a_32_246# 0.00985f
C34496 hold138/a_56_118# _636_/a_324_432# 0
C34497 tx_inst.data_reg\[6\] net3 0
C34498 _050_ hold51/a_326_118# 0
C34499 _640_/a_38_114# VPWR 0.00868f
C34500 _058_ _156_ 0.00372f
C34501 hold156/a_326_118# net97 0.0014f
C34502 fanout27/a_40_152# clknet_4_6_0_clk 0.00687f
C34503 _098_ _685_/a_2002_114# 0
C34504 hold119/a_438_182# net30 0.00322f
C34505 hold119/a_326_118# _266_ 0
C34506 _674_/a_2250_412# net60 0.00268f
C34507 _674_/a_1840_334# _181_ 0.00634f
C34508 _691_/a_1583_191# net103 0
C34509 net104 clknet_4_8_0_clk 0.02307f
C34510 _180_ clknet_0_clk 0.0303f
C34511 baud_inst.counter\[19\] net101 0
C34512 FILLER_26_229/a_32_246# clknet_4_15_0_clk 0
C34513 _120_ net168 0
C34514 net43 _200_ 0.3042f
C34515 baud_inst.counter\[13\] _684_/a_1489_191# 0.00203f
C34516 hold119/a_326_118# _167_ 0.00313f
C34517 hold68/a_438_182# _113_ 0
C34518 _294_ clknet_4_8_0_clk 0.00348f
C34519 tx_inst.data_reg\[4\] _656_/a_132_114# 0
C34520 _678_/a_612_127# _036_ 0.00171f
C34521 _269_ _636_/a_1840_334# 0.00624f
C34522 _463_/a_120_432# _264_ 0.00639f
C34523 _642_/a_843_236# hold176/a_438_182# 0
C34524 _644_/a_324_432# _256_ 0
C34525 _658_/a_38_114# FILLER_0_128/a_40_246# 0
C34526 _657_/a_132_114# tx_inst.data_reg\[1\] 0
C34527 net94 _352_/a_46_156# 0
C34528 _677_/a_1840_334# FILLER_10_110/a_40_246# 0
C34529 net37 FILLER_18_169/a_40_246# 0.00102f
C34530 rx_inst.data_reg\[1\] FILLER_28_176/a_32_246# 0
C34531 _632_/a_612_127# net30 0.01284f
C34532 _673_/a_324_432# net60 0.02103f
C34533 hold181/a_56_118# net135 0.00812f
C34534 hold130/a_56_118# FILLER_14_70/a_40_246# 0.00345f
C34535 _143_ net137 0.03295f
C34536 _468_/a_22_110# _270_ 0.02108f
C34537 _145_ input10/a_40_152# 0
C34538 hold109/a_438_182# _684_/a_298_337# 0
C34539 baud_inst.counter\[21\] FILLER_22_43/a_40_246# 0.00247f
C34540 net55 FILLER_0_163/a_32_246# 0.00149f
C34541 _065_ _071_ 0.00639f
C34542 _144_ net41 0.02576f
C34543 net168 _664_/a_741_93# 0.01517f
C34544 net172 _664_/a_843_236# 0
C34545 _651_/a_843_236# _084_ 0
C34546 _220_ _400_/a_192_429# 0.00415f
C34547 net156 _689_/a_1840_334# 0
C34548 FILLER_17_94/a_40_246# baud_inst.counter\[24\] 0
C34549 _184_ net29 0.10822f
C34550 net81 _457_/a_120_432# 0.00141f
C34551 _050_ _457_/a_22_110# 0
C34552 FILLER_16_203/a_32_246# _157_ 0
C34553 _536_/a_192_429# _302_ 0.00974f
C34554 net74 rx_data[4] 0.40187f
C34555 net44 baud_inst.counter\[24\] 0.00804f
C34556 _166_ net169 0.12876f
C34557 output22/a_40_152# net23 0.0107f
C34558 net161 _522_/a_209_168# 0
C34559 _688_/a_550_127# net160 0
C34560 _097_ VPWR 0.13886f
C34561 fanout40/a_40_152# net101 0
C34562 net53 net100 0.03994f
C34563 tx_inst.bit_index\[2\] _400_/a_155_160# 0
C34564 hold87/a_326_118# _515_/a_76_160# 0
C34565 net66 _266_ 0.00602f
C34566 hold86/a_56_118# _672_/a_843_236# 0
C34567 _636_/a_1583_191# _156_ 0
C34568 _703_/a_612_127# _702_/a_741_93# 0
C34569 net129 _358_/a_166_436# 0
C34570 _155_ clkbuf_4_14_0_clk/a_27_118# 0.0067f
C34571 baud_inst.counter\[20\] clknet_4_10_0_clk 0.04947f
C34572 _360_/a_1377_160# _341_/a_1377_160# 0
C34573 tx_inst.bit_index\[1\] _341_/a_1453_124# 0
C34574 net21 net172 0
C34575 _676_/a_681_505# baud_inst.counter\[4\] 0
C34576 _266_ _648_/a_1583_191# 0.00774f
C34577 net30 _648_/a_1840_334# 0.03412f
C34578 _055_ net47 0.01659f
C34579 _251_ _236_ 0.02581f
C34580 _217_ _172_ 0
C34581 output14/a_40_152# net14 0.02148f
C34582 _427_/a_248_122# _161_ 0
C34583 _679_/a_324_432# net152 0
C34584 _494_/a_279_412# _280_ 0.00113f
C34585 _099_ _669_/a_550_127# 0
C34586 clkbuf_4_10_0_clk/a_27_118# baud_inst.counter\[25\] 0
C34587 _662_/a_612_127# net179 0.00204f
C34588 clknet_0_clk _382_/a_382_118# 0.00663f
C34589 hold174/a_326_118# net169 0.00202f
C34590 hold174/a_56_118# _007_ 0.00227f
C34591 hold167/a_438_182# clknet_4_9_0_clk 0.05766f
C34592 _180_ _182_ 0.87206f
C34593 _539_/a_45_160# _307_ 0.00605f
C34594 _443_/a_252_412# _254_ 0.00282f
C34595 _443_/a_150_412# _256_ 0.00177f
C34596 _021_ _693_/a_550_127# 0
C34597 _534_/a_46_156# net149 0
C34598 _282_ _683_/a_843_236# 0
C34599 _637_/a_38_114# clknet_4_15_0_clk 0.00583f
C34600 _392_/a_285_118# _214_ 0.00122f
C34601 _486_/a_494_160# net29 0
C34602 net6 input8/a_40_152# 0.08951f
C34603 input6/a_40_152# net8 0
C34604 _067_ FILLER_0_163/a_32_246# 0
C34605 _154_ _648_/a_741_93# 0
C34606 clknet_0_clk net140 0.015f
C34607 net156 _690_/a_2250_412# 0
C34608 _307_ _108_ 0
C34609 net12 _638_/a_2250_412# 0.06303f
C34610 hold144/a_56_118# _258_ 0.00216f
C34611 _697_/a_2250_412# baud_inst.counter\[25\] 0.00223f
C34612 hold106/a_56_118# _701_/a_1489_191# 0
C34613 clknet_4_3_0_clk clkbuf_4_0_0_clk/a_27_118# 0
C34614 FILLER_9_72/a_32_246# net29 0.0023f
C34615 hold85/a_438_182# VPWR 0.00483f
C34616 VPWR hold70/a_326_118# 0.00593f
C34617 _640_/a_2250_412# net24 0.00292f
C34618 fanout27/a_40_152# net29 0.01897f
C34619 _187_ baud_inst.counter\[13\] 0.00571f
C34620 FILLER_15_67/a_40_246# net29 0
C34621 hold103/a_326_118# _528_/a_81_118# 0
C34622 clknet_0_clk baud_inst.counter\[11\] 0.04176f
C34623 net37 VPWR 1.26251f
C34624 _497_/a_170_412# net152 0
C34625 _098_ _686_/a_843_236# 0
C34626 output14/a_40_152# _637_/a_741_93# 0
C34627 net14 _637_/a_298_337# 0
C34628 net2 _439_/a_252_412# 0
C34629 hold140/a_438_182# clknet_4_9_0_clk 0
C34630 hold120/a_56_118# _695_/a_741_93# 0
C34631 hold55/a_326_118# net21 0.00564f
C34632 net44 FILLER_15_42/a_40_246# 0
C34633 _189_ _290_ 0.00118f
C34634 net132 net49 0.26712f
C34635 _404_/a_46_156# net62 0.00717f
C34636 rx_inst.state\[2\] _205_ 0.00734f
C34637 hold110/a_56_118# _291_ 0.00216f
C34638 _671_/a_1489_191# rx_inst.state\[4\] 0
C34639 rx_inst.bit_index\[2\] _244_ 0.19675f
C34640 FILLER_8_70/a_32_246# net108 0
C34641 _160_ _632_/a_132_114# 0
C34642 net79 VPWR 0.78038f
C34643 hold150/a_438_182# _159_ 0
C34644 baud_inst.counter\[27\] net100 0
C34645 _657_/a_2250_412# VPWR 0.01041f
C34646 _192_ _196_ 0.00142f
C34647 _176_ _197_ 0.01653f
C34648 _056_ VPWR 0.22486f
C34649 _661_/a_843_236# tx_inst.data_reg\[1\] 0
C34650 net37 _239_ 0.01156f
C34651 _303_ _692_/a_741_93# 0
C34652 _688_/a_1583_191# clknet_4_2_0_clk 0.00467f
C34653 hold77/a_326_118# clknet_0_clk 0
C34654 hold141/a_438_182# baud_inst.counter\[25\] 0.00794f
C34655 _504_/a_474_130# _287_ 0.00332f
C34656 _504_/a_380_412# _038_ 0.02549f
C34657 _705_/a_132_114# net43 0
C34658 VPWR _650_/a_298_337# 0.00718f
C34659 _046_ _632_/a_1840_334# 0
C34660 _436_/a_244_140# _247_ 0
C34661 _436_/a_244_412# _137_ 0
C34662 hold164/a_438_182# _020_ 0.04457f
C34663 _136_ _433_/a_244_412# 0.00605f
C34664 tx_inst.data_reg\[6\] _150_ 0.0064f
C34665 _488_/a_209_168# _673_/a_741_93# 0
C34666 FILLER_7_176/a_32_246# _274_ 0.00109f
C34667 clknet_4_8_0_clk net113 0
C34668 _636_/a_2250_412# net118 0
C34669 net144 net37 0
C34670 _138_ _648_/a_298_337# 0.00284f
C34671 _643_/a_2250_412# _632_/a_298_337# 0
C34672 _044_ hold131/a_326_118# 0.00225f
C34673 _674_/a_132_114# _087_ 0
C34674 net34 _403_/a_22_110# 0
C34675 net26 _204_ 0.00676f
C34676 _376_/a_76_160# net172 0.02467f
C34677 _676_/a_2250_412# clknet_4_9_0_clk 0
C34678 _670_/a_843_236# VPWR 0.00359f
C34679 _232_ _648_/a_298_337# 0
C34680 _662_/a_741_93# clk 0.00393f
C34681 _378_/a_59_156# net7 0.00358f
C34682 hold108/a_56_118# _189_ 0
C34683 net62 _666_/a_38_114# 0
C34684 clkload0/Y net39 0.00137f
C34685 _081_ _153_ 0
C34686 clknet_4_10_0_clk _701_/a_298_337# 0.00457f
C34687 net55 _375_/a_170_412# 0
C34688 _182_ baud_inst.counter\[11\] 0.56419f
C34689 _127_ hold70/a_326_118# 0.0194f
C34690 _315_ net107 0
C34691 _379_/a_46_156# tx_inst.data_reg\[0\] 0.00728f
C34692 _244_ _243_ 0.15258f
C34693 clk _217_ 0
C34694 net55 _213_ 0.98181f
C34695 _676_/a_298_337# _280_ 0
C34696 FILLER_24_218/a_40_246# hold126/a_56_118# 0.00102f
C34697 _675_/a_1785_429# clknet_4_0_0_clk 0.00143f
C34698 net49 hold107/a_56_118# 0.00318f
C34699 hold61/a_438_182# net61 0.00688f
C34700 _031_ _313_ 0.33077f
C34701 hold159/a_326_118# net155 0
C34702 _041_ _651_/a_550_127# 0
C34703 FILLER_15_127/a_32_246# net29 0.00147f
C34704 hold124/a_56_118# net47 0.0091f
C34705 _134_ VPWR 0.10832f
C34706 clkbuf_0_clk/a_116_82# _667_/a_298_337# 0
C34707 _528_/a_175_118# baud_inst.counter\[16\] 0
C34708 clknet_4_12_0_clk hold139/a_326_118# 0.00489f
C34709 baud_inst.counter\[28\] _115_ 0.10545f
C34710 net147 net46 0.20692f
C34711 net4 _066_ 0
C34712 clknet_0_clk _669_/a_1840_334# 0
C34713 hold176/a_438_182# FILLER_19_118/a_32_246# 0.00985f
C34714 net54 _706_/a_681_505# 0
C34715 hold87/a_56_118# _025_ 0.00171f
C34716 _378_/a_59_156# net155 0.00146f
C34717 _378_/a_382_118# _206_ 0.04531f
C34718 _705_/a_843_236# net21 0.0019f
C34719 VPWR net116 0.06044f
C34720 _234_ FILLER_18_158/a_40_246# 0
C34721 net94 _679_/a_298_337# 0.01429f
C34722 _652_/a_298_337# _142_ 0.01535f
C34723 _642_/a_1583_191# rx_inst.state\[2\] 0.00338f
C34724 hold178/a_326_118# net39 0.01374f
C34725 net42 _652_/a_298_337# 0.0613f
C34726 clknet_4_4_0_clk _198_ 0
C34727 _062_ hold57/a_56_118# 0
C34728 net48 FILLER_16_221/a_32_246# 0.00163f
C34729 VPWR FILLER_2_183/a_32_246# 0.09506f
C34730 clknet_4_5_0_clk _706_/a_1840_334# 0
C34731 _294_ _687_/a_324_432# 0
C34732 _068_ _339_/a_382_118# 0
C34733 tx_inst.data_reg\[3\] _339_/a_1453_124# 0.00256f
C34734 hold85/a_438_182# _266_ 0.00256f
C34735 net30 hold70/a_438_182# 0.01212f
C34736 _266_ hold70/a_326_118# 0
C34737 _635_/a_132_114# _266_ 0
C34738 net163 net164 0.00324f
C34739 baud_inst.counter\[28\] hold67/a_56_118# 0.00122f
C34740 FILLER_13_89/a_40_246# _685_/a_741_93# 0.0029f
C34741 hold118/a_438_182# _650_/a_2250_412# 0.00887f
C34742 _553_/a_170_412# VPWR 0
C34743 clkbuf_4_11_0_clk/a_27_118# _703_/a_843_236# 0
C34744 _663_/a_132_114# clknet_4_6_0_clk 0
C34745 _513_/a_155_160# net40 0
C34746 net37 _266_ 0.01621f
C34747 _698_/a_741_93# _051_ 0
C34748 net49 _238_ 0
C34749 _173_ net184 0.01927f
C34750 hold152/a_326_118# _676_/a_1583_191# 0
C34751 hold152/a_56_118# _676_/a_1840_334# 0
C34752 _644_/a_324_432# net132 0.00682f
C34753 _488_/a_209_168# net95 0
C34754 _093_ hold116/a_56_118# 0
C34755 _177_ _112_ 0.00821f
C34756 _677_/a_1583_191# baud_inst.counter\[4\] 0
C34757 _677_/a_1840_334# net152 0.03928f
C34758 clkbuf_4_10_0_clk/a_27_118# baud_inst.counter\[24\] 0
C34759 hold171/a_326_118# net55 0.00614f
C34760 VPWR _682_/a_132_114# 0
C34761 hold124/a_56_118# hold126/a_438_182# 0
C34762 rx_inst.bit_index\[2\] clknet_4_14_0_clk 0.04139f
C34763 net37 _167_ 1.19883f
C34764 hold116/a_326_118# _183_ 0.00912f
C34765 hold116/a_438_182# baud_inst.counter\[10\] 0.02544f
C34766 net35 _420_/a_248_122# 0.00115f
C34767 _638_/a_1583_191# _632_/a_2250_412# 0
C34768 _638_/a_2250_412# _632_/a_1583_191# 0
C34769 _638_/a_1840_334# _632_/a_1840_334# 0.00131f
C34770 hold53/a_438_182# _263_ 0.00126f
C34771 _017_ _530_/a_155_412# 0
C34772 hold102/a_326_118# _302_ 0
C34773 clknet_4_11_0_clk _702_/a_1489_191# 0
C34774 net120 _692_/a_298_337# 0
C34775 baud_inst.counter\[28\] _701_/a_38_114# 0.00356f
C34776 clknet_4_12_0_clk hold175/a_56_118# 0
C34777 net9 _380_/a_285_412# 0
C34778 tx_inst.bit_index\[1\] hold145/a_326_118# 0
C34779 net102 _690_/a_741_93# 0
C34780 net37 _647_/a_741_93# 0
C34781 _404_/a_268_412# _223_ 0
C34782 _246_ _224_ 0.03566f
C34783 net118 _157_ 0
C34784 VPWR net90 0.03559f
C34785 _697_/a_2250_412# baud_inst.counter\[24\] 0
C34786 _661_/a_1583_191# VPWR 0.0069f
C34787 net37 _225_ 0
C34788 _645_/a_38_114# net132 0.0011f
C34789 _645_/a_324_432# _055_ 0.01337f
C34790 VPWR _702_/a_324_432# 0
C34791 net108 _183_ 0.09128f
C34792 _677_/a_38_114# _035_ 0.04473f
C34793 net97 baud_inst.counter\[10\] 0.01106f
C34794 rx_inst.data_reg\[4\] _636_/a_843_236# 0
C34795 net138 _636_/a_741_93# 0.00206f
C34796 hold80/a_326_118# net19 0
C34797 _640_/a_1840_334# VPWR 0.00749f
C34798 VPWR _275_ 0.29513f
C34799 net49 _694_/a_324_432# 0.05526f
C34800 FILLER_0_35/a_40_246# _085_ 0.00355f
C34801 _650_/a_324_432# _000_ 0.02125f
C34802 _650_/a_298_337# _266_ 0
C34803 _650_/a_38_114# net30 0.0449f
C34804 hold131/a_438_182# _272_ 0
C34805 tx_data[2] net165 0
C34806 hold68/a_326_118# _551_/a_76_160# 0
C34807 hold76/a_326_118# clknet_4_10_0_clk 0
C34808 fanout31/a_40_152# _223_ 0.00548f
C34809 hold53/a_56_118# _242_ 0
C34810 net53 _425_/a_46_156# 0
C34811 _345_/a_150_412# baud_inst.counter\[20\] 0.00372f
C34812 _679_/a_843_236# net38 0
C34813 hold124/a_56_118# net70 0
C34814 net93 _036_ 0.20101f
C34815 FILLER_12_106/a_40_246# _685_/a_2250_412# 0
C34816 _268_ _264_ 0.13069f
C34817 _657_/a_1489_191# tx_inst.data_reg\[1\] 0.01155f
C34818 _285_ baud_inst.counter\[6\] 0.03285f
C34819 net92 _185_ 0.47372f
C34820 fanout34/a_40_152# _141_ 0.01005f
C34821 _227_ _450_/a_398_96# 0
C34822 net133 _702_/a_298_337# 0
C34823 _389_/a_46_156# _213_ 0.04504f
C34824 _673_/a_1840_334# _181_ 0
C34825 _673_/a_2250_412# net60 0.00425f
C34826 FILLER_8_236/a_40_246# _665_/a_1583_191# 0
C34827 _464_/a_22_110# rx_inst.data_reg\[5\] 0
C34828 clknet_4_14_0_clk _243_ 0.06098f
C34829 net92 clknet_4_0_0_clk 0
C34830 FILLER_10_78/a_32_246# net108 0
C34831 _431_/a_81_118# net25 0.04101f
C34832 _473_/a_22_110# _264_ 0.00496f
C34833 net10 net8 0
C34834 _392_/a_496_118# _144_ 0.0013f
C34835 _651_/a_2250_412# _166_ 0.01777f
C34836 _671_/a_1840_334# _153_ 0
C34837 hold87/a_56_118# FILLER_17_79/a_40_246# 0.00786f
C34838 _276_ tx_inst.state\[2\] 0
C34839 _217_ _653_/a_1840_334# 0
C34840 net154 net108 0
C34841 hold141/a_438_182# baud_inst.counter\[24\] 0.00173f
C34842 hold141/a_56_118# _309_ 0.02391f
C34843 net168 _664_/a_1785_429# 0.003f
C34844 _200_ _664_/a_2250_412# 0.00563f
C34845 _142_ net183 0.04571f
C34846 _355_/a_354_412# net88 0
C34847 hold156/a_326_118# baud_inst.counter\[17\] 0.0087f
C34848 hold170/a_56_118# _392_/a_59_156# 0
C34849 net42 net183 0.00137f
C34850 fanout31/a_40_152# _240_ 0
C34851 baud_inst.counter\[22\] hold103/a_438_182# 0
C34852 _680_/a_324_432# hold136/a_326_118# 0
C34853 _680_/a_741_93# hold136/a_56_118# 0
C34854 _363_/a_120_432# _173_ 0.00191f
C34855 hold116/a_326_118# net115 0
C34856 output23/a_40_152# _704_/a_324_432# 0
C34857 _636_/a_741_93# _047_ 0.00936f
C34858 hold149/a_326_118# _693_/a_612_127# 0
C34859 net161 _296_ 0.00786f
C34860 hold170/a_326_118# _071_ 0
C34861 hold110/a_56_118# baud_inst.counter\[4\] 0
C34862 hold86/a_438_182# _672_/a_2250_412# 0
C34863 net6 clknet_0_clk 0
C34864 _636_/a_2002_114# _156_ 0
C34865 net59 _702_/a_741_93# 0
C34866 net58 net67 1.20655f
C34867 _059_ _154_ 0
C34868 _277_ _671_/a_298_337# 0.01112f
C34869 net28 _671_/a_38_114# 0
C34870 tx_inst.bit_index\[1\] _341_/a_1377_160# 0
C34871 _676_/a_1489_191# net152 0
C34872 net48 _137_ 0.0665f
C34873 clknet_4_13_0_clk clkbuf_4_13_0_clk/a_27_118# 0.00636f
C34874 net108 net115 0.01856f
C34875 _013_ hold129/a_326_118# 0
C34876 _116_ _703_/a_324_432# 0.02895f
C34877 FILLER_21_194/a_32_246# _054_ 0
C34878 _679_/a_1583_191# _282_ 0
C34879 _194_ hold174/a_438_182# 0.0011f
C34880 _046_ _635_/a_843_236# 0
C34881 _073_ net179 1.85042f
C34882 net42 _663_/a_324_432# 0.0495f
C34883 _046_ hold85/a_56_118# 0.00435f
C34884 hold102/a_438_182# hold158/a_326_118# 0
C34885 hold102/a_326_118# hold158/a_438_182# 0
C34886 hold172/a_56_118# _705_/a_324_432# 0
C34887 _226_ _642_/a_1583_191# 0.0034f
C34888 _637_/a_1840_334# clknet_4_15_0_clk 0.00236f
C34889 FILLER_0_35/a_40_246# _675_/a_1489_191# 0
C34890 net54 _367_/a_170_412# 0
C34891 _681_/a_324_432# net117 0.01099f
C34892 hold89/a_438_182# net89 0
C34893 _313_ net46 0.02845f
C34894 _677_/a_324_432# _280_ 0.01283f
C34895 _292_ _291_ 0.23753f
C34896 FILLER_24_229/a_32_246# net71 0
C34897 net36 net49 0.08804f
C34898 net142 net99 0
C34899 tx_data[0] tx_data[6] 0.14465f
C34900 _101_ clknet_4_2_0_clk 0.07168f
C34901 hold106/a_438_182# net107 0
C34902 hold118/a_56_118# _639_/a_843_236# 0
C34903 clknet_4_5_0_clk net172 0.05313f
C34904 _283_ _677_/a_843_236# 0.00854f
C34905 _080_ clknet_4_6_0_clk 0.00118f
C34906 _642_/a_324_432# _669_/a_843_236# 0
C34907 _642_/a_741_93# _669_/a_741_93# 0
C34908 hold103/a_56_118# net103 0
C34909 _276_ _197_ 0.07827f
C34910 _284_ _281_ 0.00234f
C34911 hold68/a_326_118# _700_/a_741_93# 0.00632f
C34912 hold68/a_438_182# _700_/a_324_432# 0
C34913 _287_ _349_/a_350_122# 0
C34914 _419_/a_154_118# net24 0
C34915 _672_/a_741_93# VPWR 0.01682f
C34916 net14 _637_/a_1583_191# 0.00327f
C34917 net2 _251_ 0
C34918 _071_ VPWR 0.17139f
C34919 _275_ FILLER_7_234/a_32_246# 0
C34920 fanout43/a_40_152# net29 0
C34921 net45 _694_/a_550_127# 0
C34922 net20 tx_busy 0.03557f
C34923 net173 clknet_4_4_0_clk 0
C34924 baud_inst.counter\[15\] _309_ 0
C34925 _658_/a_324_432# _212_ 0
C34926 _658_/a_741_93# net5 0
C34927 baud_inst.counter\[28\] hold105/a_56_118# 0
C34928 _653_/a_843_236# _220_ 0
C34929 _653_/a_741_93# _142_ 0.00667f
C34930 _223_ _168_ 0
C34931 _271_ hold83/a_438_182# 0.00338f
C34932 _124_ hold83/a_326_118# 0.03776f
C34933 hold131/a_56_118# _472_/a_120_432# 0
C34934 net34 net54 0.03436f
C34935 net42 _653_/a_741_93# 0
C34936 _064_ _653_/a_324_432# 0.03f
C34937 _217_ hold169/a_56_118# 0.0062f
C34938 _181_ _086_ 0.04204f
C34939 hold88/a_56_118# _297_ 0.02998f
C34940 _047_ hold81/a_326_118# 0
C34941 _192_ _365_/a_155_412# 0.00763f
C34942 VPWR FILLER_0_154/a_40_246# 0.1207f
C34943 _059_ hold125/a_438_182# 0.01323f
C34944 _155_ _154_ 0
C34945 net8 _389_/a_268_412# 0
C34946 _678_/a_2250_412# clkbuf_4_1_0_clk/a_27_118# 0.00165f
C34947 _658_/a_38_114# net38 0
C34948 _429_/a_244_412# _244_ 0
C34949 _649_/a_298_337# net127 0
C34950 _661_/a_612_127# tx_inst.data_reg\[1\] 0
C34951 _288_ FILLER_8_19/a_40_246# 0.00653f
C34952 _099_ _685_/a_324_432# 0
C34953 net46 _685_/a_741_93# 0.00161f
C34954 net96 net97 0
C34955 _201_ _166_ 0
C34956 rx_inst.state\[3\] _669_/a_1489_191# 0
C34957 hold120/a_326_118# net107 0
C34958 VPWR _650_/a_1583_191# 0.00642f
C34959 _698_/a_324_432# _698_/a_741_93# 0
C34960 _250_ _137_ 0.47562f
C34961 _049_ hold70/a_56_118# 0
C34962 _019_ _673_/a_324_432# 0
C34963 clknet_4_3_0_clk net181 0
C34964 net96 net86 0.00168f
C34965 _173_ _341_/a_71_118# 0
C34966 _640_/a_298_337# net45 0.02827f
C34967 net34 _364_/a_257_140# 0.00516f
C34968 _174_ _364_/a_155_412# 0.03341f
C34969 _119_ _664_/a_1840_334# 0
C34970 _240_ _168_ 0.01243f
C34971 _138_ _648_/a_1583_191# 0
C34972 net125 _648_/a_132_114# 0
C34973 fanout41/a_40_152# clknet_0_clk 0.01166f
C34974 _460_/a_22_110# _265_ 0.00651f
C34975 hold101/a_56_118# baud_inst.counter\[18\] 0.01623f
C34976 _460_/a_120_432# _129_ 0.00213f
C34977 net15 _467_/a_120_432# 0
C34978 _634_/a_843_236# _124_ 0
C34979 _112_ VPWR 0.17211f
C34980 _110_ _180_ 0
C34981 _230_ _439_/a_150_412# 0
C34982 _662_/a_1785_429# clk 0
C34983 _670_/a_612_127# VPWR 0
C34984 _636_/a_324_432# net80 0
C34985 _229_ _249_ 0.01208f
C34986 net32 _435_/a_268_436# 0.00435f
C34987 hold167/a_56_118# _191_ 0.01015f
C34988 _206_ tx_data[4] 0.00506f
C34989 baud_inst.counter\[22\] net49 0.03959f
C34990 clknet_4_10_0_clk _701_/a_1583_191# 0
C34991 _097_ _163_ 0.02598f
C34992 FILLER_12_173/a_32_246# rx_inst.state\[4\] 0
C34993 hold130/a_326_118# _180_ 0.00188f
C34994 VPWR hold84/a_326_118# 0.00595f
C34995 FILLER_21_31/a_40_246# VPWR 0.13153f
C34996 _641_/a_38_114# net100 0.00189f
C34997 _048_ _633_/a_843_236# 0
C34998 clknet_4_8_0_clk baud_inst.counter\[29\] 0
C34999 _660_/a_38_114# net55 0.00351f
C35000 _098_ net153 0
C35001 fanout49/a_40_152# net46 0.00145f
C35002 FILLER_3_207/a_40_246# _119_ 0
C35003 clkbuf_4_12_0_clk/a_27_118# FILLER_18_169/a_40_246# 0.00286f
C35004 _009_ _508_/a_209_168# 0.01939f
C35005 clk _667_/a_843_236# 0.01078f
C35006 _041_ clknet_4_6_0_clk 0.01362f
C35007 net103 baud_inst.counter\[16\] 0.09875f
C35008 _285_ FILLER_5_74/a_32_246# 0.00599f
C35009 hold88/a_438_182# VPWR 0.00452f
C35010 _280_ _683_/a_1583_191# 0
C35011 _162_ _683_/a_2250_412# 0
C35012 net67 _027_ 0
C35013 _544_/a_46_156# _025_ 0.00337f
C35014 net94 _679_/a_1583_191# 0.0258f
C35015 _285_ _679_/a_843_236# 0.01849f
C35016 _652_/a_1583_191# _142_ 0.01539f
C35017 _642_/a_2002_114# rx_inst.state\[2\] 0
C35018 hold143/a_56_118# _122_ 0.00102f
C35019 _155_ hold125/a_438_182# 0.00166f
C35020 net42 _652_/a_1583_191# 0.00305f
C35021 _227_ net24 0
C35022 net37 _428_/a_252_412# 0
C35023 hold120/a_56_118# net120 0
C35024 net179 net41 0.05531f
C35025 _508_/a_177_436# clknet_4_2_0_clk 0
C35026 _068_ _339_/a_810_118# 0
C35027 tx_inst.data_reg\[3\] _339_/a_1377_160# 0
C35028 hold130/a_438_182# _292_ 0.01277f
C35029 net76 _302_ 0.01589f
C35030 fanout37/a_40_152# net30 0.01382f
C35031 clkbuf_4_11_0_clk/a_27_118# baud_inst.counter\[26\] 0
C35032 fanout41/a_40_152# _386_/a_59_156# 0
C35033 hold122/a_326_118# _667_/a_324_432# 0
C35034 _697_/a_681_505# net46 0
C35035 _663_/a_1489_191# clknet_4_6_0_clk 0
C35036 _684_/a_38_114# net40 0.00862f
C35037 hold177/a_438_182# _297_ 0
C35038 tx_inst.bit_index\[1\] _195_ 0
C35039 net44 _307_ 0.03278f
C35040 _644_/a_1583_191# rx_inst.data_reg\[1\] 0.00151f
C35041 _541_/a_380_412# _296_ 0
C35042 _032_ _702_/a_741_93# 0
C35043 net48 net111 0.0022f
C35044 VPWR _682_/a_1489_191# 0.00111f
C35045 _277_ _205_ 0
C35046 net49 _444_/a_142_412# 0.00506f
C35047 net40 _066_ 0.20202f
C35048 _017_ _018_ 0.00179f
C35049 _546_/a_341_118# baud_inst.counter\[24\] 0
C35050 _676_/a_324_432# clkbuf_4_3_0_clk/a_27_118# 0
C35051 baud_inst.counter\[28\] _701_/a_1840_334# 0.01195f
C35052 FILLER_19_228/a_40_246# net64 0
C35053 input8/a_40_152# net8 0.00138f
C35054 tx_data[6] _208_ 0
C35055 _017_ _690_/a_612_127# 0.00113f
C35056 clknet_4_14_0_clk _429_/a_244_412# 0.00676f
C35057 net2 _668_/a_132_114# 0
C35058 net80 hold81/a_56_118# 0
C35059 _110_ net140 0.00408f
C35060 VPWR _454_/a_257_140# 0
C35061 _661_/a_2002_114# VPWR 0
C35062 _645_/a_2250_412# _055_ 0
C35063 VPWR _702_/a_2250_412# 0.00887f
C35064 _116_ clkload2/Y 0
C35065 hold115/a_56_118# baud_inst.counter\[10\] 0.00103f
C35066 _707_/a_1583_191# hold80/a_56_118# 0
C35067 _488_/a_474_130# net40 0
C35068 _488_/a_380_412# _086_ 0.0295f
C35069 FILLER_15_162/a_40_246# _224_ 0.00264f
C35070 _060_ _139_ 0
C35071 _495_/a_154_118# net115 0
C35072 net82 hold83/a_326_118# 0.00922f
C35073 _650_/a_1840_334# net30 0.00664f
C35074 _650_/a_1583_191# _266_ 0.04666f
C35075 _022_ hold148/a_56_118# 0.0074f
C35076 net120 hold148/a_438_182# 0.01605f
C35077 net184 FILLER_4_172/a_32_246# 0.00145f
C35078 _676_/a_1583_191# _191_ 0.00926f
C35079 clknet_0_clk _666_/a_741_93# 0.00273f
C35080 hold68/a_56_118# _314_ 0
C35081 _021_ _303_ 0.01871f
C35082 clkbuf_4_12_0_clk/a_27_118# VPWR 0.05173f
C35083 _552_/a_257_140# _313_ 0.00143f
C35084 hold155/a_56_118# net55 0.00145f
C35085 baud_inst.counter\[24\] _686_/a_843_236# 0
C35086 _679_/a_612_127# net38 0
C35087 _669_/a_843_236# clknet_4_9_0_clk 0.00699f
C35088 _098_ _280_ 0
C35089 tx_inst.data_reg\[4\] tx_inst.data_reg\[2\] 0.58044f
C35090 _292_ baud_inst.counter\[4\] 0
C35091 net44 _690_/a_298_337# 0
C35092 _132_ hold176/a_438_182# 0.00122f
C35093 clknet_4_12_0_clk hold176/a_326_118# 0.05825f
C35094 rx_inst.bit_index\[2\] hold176/a_56_118# 0
C35095 net32 _438_/a_248_122# 0.00469f
C35096 _179_ FILLER_22_86/a_32_246# 0
C35097 hold143/a_56_118# rx_inst.data_reg\[4\] 0
C35098 baud_inst.counter\[26\] _547_/a_81_118# 0.02228f
C35099 _639_/a_298_337# VPWR 0.00218f
C35100 hold119/a_56_118# net139 0
C35101 tx_inst.data_reg\[3\] tx_inst.data_reg\[1\] 0.04914f
C35102 hold153/a_56_118# net39 0
C35103 _041_ net29 0.00533f
C35104 net32 FILLER_18_169/a_40_246# 0
C35105 baud_inst.counter\[30\] _346_/a_150_412# 0
C35106 net79 _488_/a_209_168# 0.04856f
C35107 _680_/a_612_127# net136 0.01781f
C35108 FILLER_12_89/a_40_246# hold153/a_56_118# 0
C35109 clknet_0_clk _287_ 0
C35110 _665_/a_843_236# tx_inst.state\[3\] 0.00865f
C35111 net82 _634_/a_843_236# 0.00207f
C35112 _544_/a_46_156# FILLER_17_79/a_40_246# 0.00582f
C35113 rx_inst.state\[3\] net62 0.00105f
C35114 net30 hold84/a_438_182# 0.00172f
C35115 hold122/a_326_118# _142_ 0
C35116 hold149/a_326_118# fanout46/a_40_152# 0
C35117 net42 hold122/a_326_118# 0.0133f
C35118 net44 _697_/a_38_114# 0
C35119 net48 net150 0.05323f
C35120 _680_/a_843_236# net136 0.00424f
C35121 hold149/a_326_118# net149 0
C35122 net156 _688_/a_38_114# 0.02189f
C35123 hold156/a_56_118# _688_/a_1583_191# 0.00278f
C35124 FILLER_0_130/a_32_246# VPWR 0.06235f
C35125 net48 _047_ 0.02609f
C35126 _060_ _648_/a_38_114# 0
C35127 baud_inst.counter\[1\] _672_/a_1489_191# 0
C35128 _057_ _259_ 0
C35129 net28 _671_/a_1840_334# 0
C35130 FILLER_14_185/a_32_246# clknet_4_6_0_clk 0
C35131 _701_/a_38_114# FILLER_25_36/a_32_246# 0
C35132 _661_/a_324_432# _384_/a_382_118# 0
C35133 net55 FILLER_0_128/a_40_246# 0.00491f
C35134 _661_/a_741_93# _384_/a_59_156# 0.00164f
C35135 _173_ hold145/a_56_118# 0
C35136 net37 _232_ 0.11028f
C35137 hold155/a_438_182# net6 0
C35138 tx_inst.data_reg\[7\] _339_/a_886_118# 0.03399f
C35139 rx_data[1] clknet_4_14_0_clk 0.00412f
C35140 _693_/a_741_93# VPWR 0.02342f
C35141 _046_ _635_/a_612_127# 0.00226f
C35142 FILLER_5_213/a_32_246# _200_ 0
C35143 FILLER_13_102/a_32_246# _083_ 0.00153f
C35144 _255_ _253_ 0
C35145 hold165/a_56_118# _656_/a_324_432# 0
C35146 _342_/a_170_412# tx_inst.data_reg\[0\] 0
C35147 net79 FILLER_0_56/a_32_246# 0.01676f
C35148 _510_/a_350_122# net135 0
C35149 _510_/a_248_122# _287_ 0
C35150 _681_/a_1583_191# baud_inst.counter\[9\] 0.00872f
C35151 _190_ net130 0
C35152 _697_/a_298_337# clknet_0_clk 0.00379f
C35153 output14/a_40_152# hold82/a_438_182# 0
C35154 _206_ _202_ 0.21013f
C35155 _666_/a_1583_191# _666_/a_2250_412# 0
C35156 net23 _707_/a_741_93# 0
C35157 tx_done _707_/a_324_432# 0
C35158 _057_ _157_ 0.02375f
C35159 _294_ _515_/a_76_160# 0.0548f
C35160 hold118/a_438_182# _639_/a_2250_412# 0
C35161 _674_/a_843_236# _033_ 0
C35162 hold60/a_438_182# net86 0
C35163 _283_ _677_/a_612_127# 0
C35164 _098_ _191_ 0.00583f
C35165 net26 VPWR 1.97112f
C35166 FILLER_24_229/a_32_246# _273_ 0.02697f
C35167 net35 rx_inst.bit_index\[1\] 0.14945f
C35168 tx_inst.bit_index\[0\] _001_ 0.01829f
C35169 _234_ _671_/a_843_236# 0
C35170 _287_ _182_ 1.82562f
C35171 net14 _637_/a_2002_114# 0
C35172 _672_/a_1785_429# VPWR 0
C35173 net168 _196_ 0
C35174 net32 VPWR 0.69819f
C35175 _536_/a_341_118# _021_ 0.00131f
C35176 net34 clkbuf_4_4_0_clk/a_27_118# 0.01728f
C35177 net20 _704_/a_741_93# 0
C35178 _118_ hold50/a_326_118# 0.0096f
C35179 VPWR hold94/a_56_118# 0.05515f
C35180 _499_/a_209_168# _352_/a_46_156# 0
C35181 net147 _692_/a_324_432# 0
C35182 _304_ _692_/a_38_114# 0
C35183 _242_ net24 1.04896f
C35184 baud_inst.counter\[12\] fanout29/a_40_152# 0.00398f
C35185 _637_/a_324_432# hold82/a_56_118# 0
C35186 _139_ _649_/a_741_93# 0
C35187 _653_/a_1785_429# _142_ 0
C35188 _385_/a_46_156# _209_ 0.00261f
C35189 hold131/a_56_118# _123_ 0.00425f
C35190 _535_/a_350_122# VPWR 0
C35191 hold135/a_438_182# net86 0.00557f
C35192 baud_inst.counter\[10\] net38 0
C35193 clkbuf_4_8_0_clk/a_27_118# _296_ 0.05379f
C35194 net22 _704_/a_1583_191# 0
C35195 FILLER_15_17/a_40_246# _296_ 0.00304f
C35196 _659_/a_298_337# clknet_4_4_0_clk 0
C35197 VPWR hold62/a_326_118# 0.00707f
C35198 _691_/a_298_337# hold104/a_438_182# 0
C35199 _691_/a_38_114# hold104/a_326_118# 0
C35200 _691_/a_324_432# hold104/a_56_118# 0
C35201 net47 _123_ 0.02241f
C35202 _180_ _347_/a_248_122# 0
C35203 clkbuf_4_12_0_clk/a_27_118# _167_ 0.07052f
C35204 _215_ _666_/a_324_432# 0
C35205 _639_/a_38_114# net30 0.00135f
C35206 _672_/a_38_114# _181_ 0.00169f
C35207 _672_/a_324_432# net60 0.01634f
C35208 _677_/a_843_236# clkbuf_4_3_0_clk/a_27_118# 0
C35209 net31 _205_ 0
C35210 rx_inst.state\[2\] _450_/a_127_436# 0.00364f
C35211 clkbuf_4_10_0_clk/a_27_118# _307_ 0
C35212 net22 net43 0
C35213 hold161/a_326_118# hold158/a_438_182# 0
C35214 net122 fanout43/a_40_152# 0.00139f
C35215 net28 _374_/a_244_412# 0
C35216 _637_/a_298_337# _048_ 0.00664f
C35217 net32 _239_ 0.12987f
C35218 hold121/a_326_118# baud_inst.counter\[23\] 0
C35219 _109_ _696_/a_132_114# 0
C35220 _640_/a_1583_191# net45 0
C35221 _640_/a_132_114# _111_ 0
C35222 _174_ _197_ 0.00764f
C35223 _199_ net172 0.08576f
C35224 hold56/a_56_118# _274_ 0.00283f
C35225 _024_ _540_/a_45_160# 0
C35226 clkbuf_4_12_0_clk/a_27_118# _225_ 0.00114f
C35227 _232_ _134_ 0.05631f
C35228 net41 _653_/a_298_337# 0
C35229 rx_done net19 0
C35230 _178_ _693_/a_1840_334# 0
C35231 _080_ fanout42/a_40_152# 0.09027f
C35232 rx_data[3] net84 0
C35233 _634_/a_612_127# _124_ 0
C35234 net55 _387_/a_46_156# 0.00981f
C35235 _659_/a_38_114# _149_ 0.04714f
C35236 _659_/a_741_93# net137 0
C35237 net44 _517_/a_177_436# 0
C35238 _045_ hold77/a_56_118# 0
C35239 _420_/a_146_122# _238_ 0
C35240 _126_ _650_/a_843_236# 0
C35241 _257_ net25 0.21752f
C35242 net108 baud_inst.counter\[5\] 0.00104f
C35243 _707_/a_843_236# net22 0
C35244 fanout25/a_40_152# clknet_0_clk 0.0029f
C35245 _649_/a_38_114# _648_/a_741_93# 0
C35246 _649_/a_324_432# _648_/a_324_432# 0
C35247 _660_/a_1840_334# net55 0
C35248 _358_/a_166_436# _189_ 0
C35249 _358_/a_72_436# _190_ 0.04259f
C35250 clkbuf_4_0_0_clk/a_27_118# clknet_0_clk 0.01848f
C35251 _302_ _690_/a_298_337# 0.00196f
C35252 VPWR _388_/a_59_156# 0.00417f
C35253 FILLER_11_134/a_32_246# net43 0
C35254 _246_ _230_ 0
C35255 baud_inst.counter\[20\] VPWR 1.17046f
C35256 clk _667_/a_612_127# 0.01847f
C35257 hold114/a_56_118# clknet_0_clk 0
C35258 net101 baud_inst.counter\[16\] 0.14012f
C35259 net47 _648_/a_2250_412# 0.00134f
C35260 _680_/a_1785_429# clknet_4_0_0_clk 0.00189f
C35261 hold114/a_326_118# hold114/a_438_182# 0
C35262 hold102/a_438_182# baud_inst.counter\[17\] 0.0198f
C35263 net179 _392_/a_496_118# 0.00128f
C35264 _517_/a_209_168# clknet_0_clk 0
C35265 _270_ rx_data[4] 0
C35266 _125_ net16 0.11725f
C35267 net94 _679_/a_2002_114# 0
C35268 net92 _679_/a_1489_191# 0.00655f
C35269 _652_/a_2002_114# _142_ 0
C35270 clknet_4_12_0_clk _229_ 0
C35271 _076_ _664_/a_298_337# 0.00598f
C35272 net42 _652_/a_2002_114# 0
C35273 hold102/a_56_118# _688_/a_38_114# 0
C35274 _009_ VPWR 0.1293f
C35275 _680_/a_741_93# clknet_4_0_0_clk 0.05226f
C35276 _286_ _683_/a_1489_191# 0
C35277 hold113/a_56_118# FILLER_22_86/a_32_246# 0.00404f
C35278 _706_/a_681_505# VPWR 0
C35279 net137 FILLER_6_98/a_40_246# 0
C35280 net54 _705_/a_1840_334# 0
C35281 net26 _266_ 0.02256f
C35282 FILLER_6_23/a_32_246# VPWR 0.07076f
C35283 clknet_4_13_0_clk net51 0
C35284 net42 hold169/a_438_182# 0.01136f
C35285 hold100/a_438_182# _111_ 0
C35286 _684_/a_1840_334# net40 0.00214f
C35287 _642_/a_298_337# net46 0
C35288 _059_ net49 0.05686f
C35289 hold182/a_326_118# _089_ 0
C35290 _294_ net91 0
C35291 _045_ _633_/a_741_93# 0.00119f
C35292 _360_/a_1453_124# _379_/a_46_156# 0.00128f
C35293 net58 _702_/a_550_127# 0
C35294 _143_ _659_/a_324_432# 0
C35295 net26 _167_ 0.02423f
C35296 _113_ _700_/a_741_93# 0.00164f
C35297 _080_ net122 0.04667f
C35298 fanout24/a_40_152# net25 0.02828f
C35299 hold173/a_56_118# _216_ 0.00299f
C35300 _233_ _671_/a_843_236# 0
C35301 net49 _159_ 0.32732f
C35302 hold158/a_56_118# _689_/a_38_114# 0.00129f
C35303 hold158/a_326_118# _689_/a_298_337# 0
C35304 FILLER_25_198/a_32_246# VPWR 0.0815f
C35305 _169_ _667_/a_843_236# 0.06564f
C35306 net124 net47 0.26766f
C35307 net32 _167_ 0.03985f
C35308 _662_/a_298_337# _206_ 0
C35309 hold96/a_56_118# _286_ 0.02408f
C35310 net102 _103_ 0.00453f
C35311 net46 _686_/a_298_337# 0.01302f
C35312 net48 _633_/a_132_114# 0
C35313 net2 _668_/a_1489_191# 0.00146f
C35314 _083_ clkbuf_0_clk/a_116_82# 0.00139f
C35315 rx_inst.bit_index\[1\] _254_ 0
C35316 _062_ clk 0.00627f
C35317 _041_ fanout42/a_40_152# 0
C35318 net111 net143 0.00145f
C35319 _707_/a_1840_334# net80 0
C35320 clkbuf_4_0_0_clk/a_27_118# _182_ 0.02567f
C35321 fanout41/a_40_152# net43 0.02743f
C35322 net177 _097_ 0.00948f
C35323 _225_ net32 0.14072f
C35324 _261_ _131_ 0.0097f
C35325 _646_/a_1840_334# _156_ 0
C35326 _180_ _703_/a_298_337# 0
C35327 hold156/a_56_118# _101_ 0
C35328 _098_ hold91/a_438_182# 0.00352f
C35329 clknet_0_clk _685_/a_681_505# 0
C35330 _650_/a_2002_114# _266_ 0
C35331 hold175/a_438_182# VPWR 0.00341f
C35332 clknet_0_clk _666_/a_1785_429# 0.00115f
C35333 _676_/a_2002_114# _191_ 0
C35334 _691_/a_1840_334# hold163/a_438_182# 0
C35335 _651_/a_843_236# clknet_4_6_0_clk 0.03704f
C35336 net145 _206_ 0.04594f
C35337 net96 net38 0.01071f
C35338 clkbuf_4_5_0_clk/a_27_118# clknet_0_clk 0.04828f
C35339 _676_/a_38_114# VPWR 0
C35340 _483_/a_22_110# net51 0
C35341 _669_/a_612_127# clknet_4_9_0_clk 0.0025f
C35342 hold127/a_438_182# net127 0.01163f
C35343 clknet_4_14_0_clk _418_/a_46_156# 0
C35344 _170_ _252_ 0.12647f
C35345 baud_inst.counter\[27\] net113 0.00331f
C35346 _639_/a_1583_191# VPWR 0.00438f
C35347 _155_ hold126/a_326_118# 0.00167f
C35348 FILLER_21_194/a_32_246# _257_ 0
C35349 net15 _635_/a_843_236# 0
C35350 output15/a_40_152# _635_/a_1583_191# 0
C35351 FILLER_17_162/a_32_246# clknet_0_clk 0
C35352 VPWR _683_/a_38_114# 0
C35353 baud_inst.counter\[26\] hold140/a_438_182# 0.00327f
C35354 _551_/a_76_160# hold114/a_326_118# 0.00124f
C35355 tx_inst.data_reg\[0\] net168 0
C35356 net82 _634_/a_612_127# 0
C35357 _155_ net49 0.14303f
C35358 _675_/a_1583_191# _504_/a_209_168# 0
C35359 _526_/a_146_122# _299_ 0
C35360 VPWR FILLER_25_150/a_32_246# 0.09266f
C35361 _640_/a_843_236# net49 0
C35362 VPWR _701_/a_298_337# 0.00245f
C35363 clknet_4_12_0_clk net65 0
C35364 _183_ _162_ 0
C35365 _432_/a_146_122# _241_ 0
C35366 net40 _681_/a_38_114# 0.00147f
C35367 net50 VPWR 0.26081f
C35368 _224_ FILLER_17_160/a_40_246# 0.00399f
C35369 net44 _697_/a_1840_334# 0.03253f
C35370 net23 _704_/a_1489_191# 0
C35371 _447_/a_277_118# _223_ 0.00333f
C35372 FILLER_2_46/a_40_246# net135 0
C35373 _349_/a_350_122# net181 0
C35374 _349_/a_248_122# net86 0.00407f
C35375 _356_/a_248_122# net40 0
C35376 net179 _706_/a_843_236# 0.00253f
C35377 net55 FILLER_7_210/a_40_246# 0
C35378 _283_ _183_ 0.00234f
C35379 net156 _688_/a_1840_334# 0.00497f
C35380 _672_/a_741_93# FILLER_0_56/a_32_246# 0
C35381 _395_/a_146_122# clknet_0_clk 0
C35382 _064_ tx_inst.bit_index\[1\] 0.02391f
C35383 _519_/a_379_118# _163_ 0.0011f
C35384 hold63/a_56_118# net166 0
C35385 _060_ _648_/a_1840_334# 0
C35386 hold88/a_438_182# _163_ 0
C35387 net59 _115_ 0
C35388 FILLER_2_79/a_40_246# net40 0.00255f
C35389 _094_ FILLER_6_21/a_40_246# 0.00484f
C35390 clknet_4_15_0_clk hold72/a_438_182# 0.00948f
C35391 net122 _041_ 0.36122f
C35392 rx_inst.state\[2\] net175 0.28018f
C35393 clknet_4_1_0_clk _384_/a_382_118# 0.00132f
C35394 fanout30/a_40_152# _061_ 0
C35395 FILLER_24_156/a_32_246# _255_ 0
C35396 _254_ FILLER_22_152/a_32_246# 0
C35397 net174 _217_ 0
C35398 _678_/a_843_236# hold92/a_56_118# 0
C35399 _678_/a_741_93# hold92/a_326_118# 0
C35400 _678_/a_324_432# hold92/a_438_182# 0
C35401 _550_/a_209_168# _701_/a_843_236# 0
C35402 _693_/a_1785_429# VPWR 0.00166f
C35403 _118_ hold55/a_56_118# 0.00417f
C35404 _644_/a_324_432# _159_ 0.05726f
C35405 _291_ net135 0.00439f
C35406 clknet_4_8_0_clk _548_/a_76_160# 0
C35407 _360_/a_886_118# net41 0.00617f
C35408 _681_/a_2002_114# baud_inst.counter\[9\] 0
C35409 FILLER_16_154/a_32_246# fanout25/a_40_152# 0
C35410 _697_/a_1583_191# clknet_0_clk 0.01179f
C35411 net76 FILLER_22_32/a_40_246# 0.02251f
C35412 net154 _162_ 0
C35413 tx_busy _704_/a_38_114# 0
C35414 VPWR FILLER_5_181/a_32_246# 0.07545f
C35415 hold120/a_438_182# net46 0.00524f
C35416 _283_ FILLER_10_78/a_32_246# 0
C35417 FILLER_2_81/a_32_246# _181_ 0
C35418 hold108/a_56_118# clknet_0_clk 0.01873f
C35419 hold69/a_56_118# VPWR 0.00636f
C35420 hold140/a_56_118# hold99/a_56_118# 0
C35421 output23/a_40_152# _707_/a_1489_191# 0
C35422 _132_ baud_inst.counter\[25\] 0.00217f
C35423 _513_/a_192_429# clknet_4_2_0_clk 0.00319f
C35424 hold118/a_326_118# _050_ 0.00124f
C35425 _283_ net154 0.00153f
C35426 _053_ _669_/a_741_93# 0
C35427 _132_ _669_/a_324_432# 0.00153f
C35428 _312_ _546_/a_192_429# 0
C35429 baud_inst.counter\[6\] VPWR 0.16488f
C35430 net43 _666_/a_741_93# 0
C35431 clk _670_/a_2250_412# 0
C35432 _645_/a_38_114# _159_ 0
C35433 VPWR _367_/a_170_412# 0
C35434 _234_ _671_/a_612_127# 0
C35435 net168 _365_/a_155_412# 0.0027f
C35436 _351_/a_46_156# _282_ 0
C35437 _351_/a_268_412# baud_inst.counter\[4\] 0.00265f
C35438 clknet_4_11_0_clk net99 0.00136f
C35439 rx_done _704_/a_2250_412# 0.00704f
C35440 net55 _654_/a_741_93# 0.02076f
C35441 _651_/a_298_337# _142_ 0
C35442 _651_/a_38_114# _220_ 0.02459f
C35443 _486_/a_358_436# net26 0.00334f
C35444 _499_/a_474_130# baud_inst.counter\[6\] 0
C35445 _499_/a_177_436# _185_ 0.00241f
C35446 hold156/a_326_118# _508_/a_209_168# 0
C35447 net42 _651_/a_298_337# 0.00109f
C35448 _663_/a_741_93# net27 0
C35449 _227_ _486_/a_115_308# 0
C35450 _637_/a_843_236# hold72/a_56_118# 0
C35451 _637_/a_741_93# hold72/a_326_118# 0
C35452 net55 _664_/a_1583_191# 0
C35453 net67 net49 0.00869f
C35454 FILLER_6_205/a_40_246# _664_/a_1840_334# 0
C35455 net39 _513_/a_341_118# 0.00502f
C35456 _080_ _667_/a_550_127# 0
C35457 _671_/a_38_114# _223_ 0
C35458 output22/a_40_152# _707_/a_324_432# 0
C35459 _286_ _506_/a_257_140# 0
C35460 baud_inst.counter\[6\] hold93/a_326_118# 0
C35461 net16 _129_ 0
C35462 rx_data[4] _265_ 0.00223f
C35463 _179_ _180_ 0.03958f
C35464 hold76/a_326_118# VPWR 0.00673f
C35465 hold141/a_56_118# clknet_0_clk 0
C35466 _659_/a_1583_191# clknet_4_4_0_clk 0.02666f
C35467 hold128/a_326_118# hold90/a_326_118# 0
C35468 _691_/a_741_93# net104 0
C35469 _201_ FILLER_5_192/a_40_246# 0
C35470 _215_ _666_/a_2250_412# 0.00245f
C35471 _639_/a_1583_191# _266_ 0
C35472 _639_/a_1840_334# net30 0
C35473 _188_ _301_ 0
C35474 _672_/a_1840_334# _181_ 0.00583f
C35475 net42 _166_ 0.0772f
C35476 rx_inst.state\[2\] _161_ 0.12429f
C35477 hold78/a_56_118# output13/a_40_152# 0.00117f
C35478 _637_/a_132_114# net72 0
C35479 net34 VPWR 0.71202f
C35480 _313_ _700_/a_132_114# 0
C35481 net48 clknet_4_15_0_clk 0.01016f
C35482 _524_/a_248_122# _296_ 0
C35483 hold175/a_438_182# _225_ 0
C35484 hold175/a_326_118# _260_ 0
C35485 tx_inst.bit_index\[2\] _007_ 0
C35486 _707_/a_38_114# _121_ 0.04645f
C35487 _059_ _649_/a_38_114# 0
C35488 _286_ _010_ 0
C35489 net20 _707_/a_1583_191# 0.00502f
C35490 _118_ _705_/a_741_93# 0.0128f
C35491 FILLER_3_21/a_40_246# net38 0.02783f
C35492 baud_inst.counter\[22\] _699_/a_741_93# 0
C35493 _691_/a_324_432# _020_ 0.00407f
C35494 _691_/a_843_236# net163 0.04785f
C35495 net83 _124_ 0.56267f
C35496 hold108/a_56_118# _182_ 0.0061f
C35497 net44 _013_ 0
C35498 _646_/a_843_236# net111 0
C35499 baud_inst.counter\[14\] FILLER_17_94/a_40_246# 0.00174f
C35500 net18 hold70/a_326_118# 0
C35501 net131 _159_ 0.2121f
C35502 tx_busy hold51/a_56_118# 0
C35503 _293_ FILLER_13_89/a_40_246# 0.01132f
C35504 baud_inst.counter\[12\] _186_ 0
C35505 net48 _158_ 0.05753f
C35506 hold178/a_56_118# _292_ 0.00306f
C35507 clknet_4_7_0_clk _668_/a_1840_334# 0
C35508 rx_inst.data_reg\[1\] net77 0
C35509 FILLER_5_164/a_40_246# hold173/a_326_118# 0
C35510 _205_ net62 0.29228f
C35511 net44 baud_inst.counter\[14\] 0.07156f
C35512 output19/a_40_152# FILLER_18_210/a_32_246# 0
C35513 _677_/a_741_93# VPWR 0.00902f
C35514 _530_/a_155_412# _018_ 0.00946f
C35515 _649_/a_843_236# _648_/a_1583_191# 0
C35516 _649_/a_741_93# _648_/a_1840_334# 0
C35517 net55 net38 0.0443f
C35518 _198_ _120_ 0.00564f
C35519 tx_inst.data_reg\[3\] _653_/a_324_432# 0
C35520 hold167/a_326_118# VPWR 0.00156f
C35521 _640_/a_298_337# _051_ 0.02012f
C35522 clkload0/Y _034_ 0.01852f
C35523 _164_ _690_/a_132_114# 0
C35524 _018_ _690_/a_843_236# 0.0041f
C35525 clknet_4_3_0_clk _162_ 0
C35526 FILLER_12_128/a_40_246# _670_/a_1840_334# 0
C35527 clk net63 0.05036f
C35528 net49 _427_/a_248_122# 0
C35529 hold179/a_56_118# _200_ 0
C35530 hold179/a_438_182# net172 0
C35531 net92 baud_inst.counter\[7\] 0
C35532 _284_ _677_/a_38_114# 0
C35533 _283_ clknet_4_3_0_clk 0.40007f
C35534 _226_ net175 0.00734f
C35535 _691_/a_132_114# _104_ 0
C35536 net110 hold178/a_326_118# 0
C35537 hold74/a_56_118# _264_ 0.0081f
C35538 _646_/a_741_93# _057_ 0.00147f
C35539 _198_ _664_/a_741_93# 0
C35540 _184_ clknet_4_2_0_clk 0
C35541 rx_data[7] _240_ 0
C35542 _170_ _428_/a_354_412# 0
C35543 baud_inst.counter\[15\] clknet_0_clk 0.00811f
C35544 hold69/a_326_118# net30 0.00526f
C35545 _504_/a_380_412# net38 0
C35546 _706_/a_550_127# VPWR 0
C35547 _517_/a_380_412# _013_ 0
C35548 net75 _106_ 0.00113f
C35549 _069_ tx_data[2] 0.00125f
C35550 hold140/a_326_118# VPWR 0.00754f
C35551 hold60/a_326_118# _085_ 0
C35552 FILLER_16_203/a_32_246# net30 0
C35553 _045_ _633_/a_1785_429# 0
C35554 net124 _649_/a_324_432# 0
C35555 _360_/a_1377_160# _379_/a_46_156# 0
C35556 _660_/a_550_127# tx_inst.data_reg\[2\] 0
C35557 hold129/a_56_118# _191_ 0.00274f
C35558 net131 _155_ 0.00296f
C35559 _032_ _115_ 0
C35560 net45 _693_/a_324_432# 0
C35561 net108 clknet_0_clk 0.04538f
C35562 _517_/a_380_412# baud_inst.counter\[14\] 0.0031f
C35563 _517_/a_474_130# baud_inst.counter\[15\] 0
C35564 hold178/a_438_182# _096_ 0
C35565 hold56/a_438_182# VPWR 0.00535f
C35566 net166 clknet_0_clk 0.00253f
C35567 baud_inst.counter\[24\] _540_/a_45_160# 0.0011f
C35568 clkbuf_4_12_0_clk/a_27_118# _232_ 0.00103f
C35569 _705_/a_38_114# VPWR 0
C35570 _116_ net58 0.00184f
C35571 clknet_0_clk net181 0.03461f
C35572 _169_ _667_/a_612_127# 0.00599f
C35573 _022_ clknet_4_10_0_clk 0.02129f
C35574 net39 _186_ 0.0867f
C35575 clknet_0_clk _386_/a_285_118# 0
C35576 _099_ _686_/a_132_114# 0
C35577 net46 _686_/a_1583_191# 0.00132f
C35578 _697_/a_298_337# _110_ 0.02443f
C35579 net55 _383_/a_268_412# 0
C35580 net2 rx_inst.state\[1\] 0.00586f
C35581 _470_/a_22_110# _124_ 0
C35582 net148 _304_ 0.02475f
C35583 hold67/a_438_182# net58 0
C35584 _341_/a_1453_124# tx_inst.bit_index\[2\] 0.02938f
C35585 _132_ baud_inst.counter\[24\] 0
C35586 _638_/a_843_236# _264_ 0.00548f
C35587 hold135/a_438_182# net38 0.05669f
C35588 net87 clknet_4_8_0_clk 0.26003f
C35589 hold132/a_438_182# _252_ 0
C35590 hold113/a_326_118# net99 0.0071f
C35591 rx_data[0] _632_/a_843_236# 0
C35592 clknet_0_clk _685_/a_550_127# 0
C35593 _671_/a_132_114# _168_ 0
C35594 _671_/a_1583_191# net62 0
C35595 hold161/a_438_182# baud_inst.counter\[17\] 0
C35596 _651_/a_612_127# clknet_4_6_0_clk 0.00214f
C35597 _097_ _188_ 0
C35598 _296_ _684_/a_741_93# 0.00113f
C35599 _128_ _637_/a_843_236# 0
C35600 _510_/a_146_122# net97 0
C35601 _676_/a_1840_334# VPWR 0
C35602 _270_ _635_/a_324_432# 0.00245f
C35603 FILLER_5_74/a_32_246# VPWR 0.07167f
C35604 rx_inst.bit_index\[0\] _236_ 0
C35605 _679_/a_843_236# VPWR 0.00279f
C35606 _226_ _161_ 0.01406f
C35607 _389_/a_46_156# net38 0
C35608 net94 hold181/a_326_118# 0
C35609 hold166/a_438_182# net166 0.00247f
C35610 net73 net30 0.04025f
C35611 hold147/a_326_118# net49 0.02317f
C35612 _073_ _665_/a_38_114# 0.00672f
C35613 _195_ _651_/a_1489_191# 0
C35614 VPWR _683_/a_1840_334# 0.00156f
C35615 _078_ clkbuf_4_7_0_clk/a_27_118# 0
C35616 hold172/a_326_118# net55 0.00566f
C35617 _240_ _636_/a_1840_334# 0
C35618 _314_ hold114/a_56_118# 0
C35619 FILLER_2_110/a_32_246# net55 0
C35620 baud_inst.counter\[30\] hold68/a_326_118# 0
C35621 net82 net83 0.01527f
C35622 _675_/a_1583_191# _287_ 0
C35623 _679_/a_1583_191# _499_/a_209_168# 0
C35624 _651_/a_324_432# _667_/a_1583_191# 0
C35625 _265_ _668_/a_843_236# 0.00169f
C35626 _471_/a_22_110# _648_/a_741_93# 0
C35627 _640_/a_612_127# net49 0
C35628 VPWR _701_/a_1583_191# 0.00851f
C35629 net108 _182_ 0.22203f
C35630 _652_/a_612_127# FILLER_11_123/a_40_246# 0
C35631 hold164/a_326_118# _304_ 0
C35632 baud_inst.counter\[8\] _282_ 0.00149f
C35633 _516_/a_165_412# _186_ 0
C35634 _645_/a_843_236# _056_ 0
C35635 net52 FILLER_25_141/a_32_246# 0
C35636 _182_ net181 0.01359f
C35637 _275_ _665_/a_298_337# 0.00304f
C35638 hold74/a_56_118# _639_/a_2250_412# 0
C35639 hold74/a_438_182# _639_/a_1583_191# 0
C35640 hold74/a_326_118# _639_/a_1840_334# 0
C35641 _082_ _642_/a_324_432# 0.00101f
C35642 net44 _642_/a_741_93# 0
C35643 net179 _706_/a_612_127# 0.00152f
C35644 _519_/a_81_118# _684_/a_1840_334# 0
C35645 baud_inst.counter\[12\] _684_/a_324_432# 0
C35646 _294_ clkbuf_4_8_0_clk/a_27_118# 0.00212f
C35647 _206_ tx_data[0] 0.02792f
C35648 hold88/a_56_118# _684_/a_1583_191# 0
C35649 _170_ net125 0
C35650 VPWR _474_/a_22_110# 0
C35651 FILLER_17_94/a_40_246# _686_/a_741_93# 0.0024f
C35652 _072_ _384_/a_59_156# 0.0014f
C35653 _661_/a_1840_334# net171 0
C35654 hold113/a_56_118# _180_ 0.00935f
C35655 _538_/a_81_118# baud_inst.counter\[22\] 0.02644f
C35656 _025_ net29 0
C35657 net44 _686_/a_741_93# 0.00439f
C35658 _232_ net32 0.2307f
C35659 _170_ _133_ 0.50559f
C35660 clknet_4_10_0_clk _108_ 0.0018f
C35661 _377_/a_46_156# _655_/a_1583_191# 0
C35662 net10 _655_/a_324_432# 0
C35663 net55 _655_/a_741_93# 0.0049f
C35664 _644_/a_2250_412# _159_ 0
C35665 _546_/a_435_412# clknet_0_clk 0
C35666 net156 _520_/a_155_412# 0
C35667 _432_/a_350_122# _248_ -0
C35668 _311_ _308_ 0
C35669 hold115/a_438_182# _287_ 0
C35670 _284_ _497_/a_170_412# 0.00167f
C35671 clknet_4_8_0_clk _312_ 0.17156f
C35672 baud_inst.counter\[27\] _695_/a_1583_191# 0
C35673 _685_/a_324_432# net130 0
C35674 _685_/a_38_114# clknet_4_9_0_clk 0.00279f
C35675 _690_/a_2250_412# baud_inst.counter\[15\] 0
C35676 _697_/a_2002_114# clknet_0_clk 0
C35677 VPWR FILLER_0_117/a_32_246# 0.06458f
C35678 net156 net178 0.0938f
C35679 _374_/a_142_412# net62 0.00249f
C35680 _231_ _423_/a_165_412# 0
C35681 _227_ _423_/a_279_412# 0.001f
C35682 _156_ _647_/a_298_337# 0
C35683 hold141/a_326_118# hold141/a_438_182# -0
C35684 net173 hold173/a_438_182# 0.01944f
C35685 tx_busy _704_/a_1840_334# 0.00888f
C35686 _684_/a_324_432# net88 0
C35687 hold63/a_438_182# _205_ 0.00857f
C35688 _642_/a_324_432# clknet_0_clk 0.00682f
C35689 net36 net25 0.07804f
C35690 FILLER_16_221/a_32_246# VPWR 0.06962f
C35691 FILLER_22_133/a_40_246# rx_inst.bit_index\[0\] 0.00292f
C35692 baud_inst.counter\[20\] FILLER_22_43/a_40_246# 0
C35693 _089_ _493_/a_139_160# 0.00174f
C35694 _689_/a_324_432# net158 0.00896f
C35695 _671_/a_324_432# clknet_0_clk 0.01094f
C35696 _178_ _695_/a_741_93# 0
C35697 _132_ _669_/a_2250_412# 0.00113f
C35698 hold64/a_326_118# net12 0.00524f
C35699 net43 _666_/a_1785_429# 0
C35700 _645_/a_1840_334# _159_ 0.01134f
C35701 _645_/a_843_236# _134_ 0
C35702 _640_/a_324_432# _698_/a_298_337# 0
C35703 _640_/a_298_337# _698_/a_324_432# 0
C35704 _704_/a_612_127# _121_ 0
C35705 tx_inst.bit_index\[1\] _657_/a_1489_191# 0
C35706 clknet_0_clk _686_/a_324_432# 0.01271f
C35707 VPWR hold180/a_438_182# 0.00409f
C35708 fanout32/a_40_152# _140_ 0
C35709 _229_ _449_/a_27_156# 0.00803f
C35710 _302_ _692_/a_681_505# 0
C35711 net55 _654_/a_1785_429# 0.00213f
C35712 FILLER_21_165/a_40_246# VPWR 0.16922f
C35713 _036_ _185_ 0
C35714 tx _487_/a_248_122# 0
C35715 net42 _651_/a_1583_191# 0
C35716 net35 _432_/a_146_122# 0
C35717 baud_inst.counter\[13\] _670_/a_324_432# 0.01505f
C35718 hold56/a_326_118# net57 0
C35719 net39 _684_/a_324_432# 0
C35720 _551_/a_170_160# net105 0
C35721 FILLER_24_229/a_32_246# _154_ 0
C35722 FILLER_19_149/a_40_246# net175 0.00208f
C35723 _062_ _084_ 0
C35724 net177 _519_/a_379_118# 0.00135f
C35725 _372_/a_120_432# rx_inst.state\[4\] 0
C35726 _639_/a_38_114# hold73/a_56_118# 0
C35727 _639_/a_298_337# hold73/a_326_118# 0
C35728 net89 _301_ 0
C35729 _659_/a_2002_114# clknet_4_4_0_clk 0.00112f
C35730 _139_ _238_ 0.09822f
C35731 hold148/a_56_118# _302_ 0.01284f
C35732 _210_ _209_ 0
C35733 clkbuf_4_5_0_clk/a_27_118# _664_/a_324_432# 0
C35734 _078_ _216_ 0.00939f
C35735 net177 hold88/a_438_182# 0
C35736 _170_ _409_/a_73_118# 0
C35737 _632_/a_38_114# rx_inst.data_reg\[6\] 0
C35738 _639_/a_2002_114# _266_ 0
C35739 _690_/a_38_114# baud_inst.counter\[17\] 0.00364f
C35740 net32 _442_/a_248_122# 0.0042f
C35741 _658_/a_38_114# VPWR 0.0042f
C35742 net154 clkbuf_4_3_0_clk/a_27_118# 0.00246f
C35743 hold156/a_326_118# VPWR 0.01112f
C35744 _039_ _681_/a_843_236# 0
C35745 _044_ _472_/a_22_110# 0
C35746 hold184/a_326_118# _172_ 0
C35747 _670_/a_2250_412# _169_ 0
C35748 _248_ _170_ 0.10487f
C35749 _175_ FILLER_4_183/a_40_246# 0
C35750 _412_/a_22_110# net49 0.00219f
C35751 _170_ fanout43/a_40_152# 0.00117f
C35752 hold113/a_56_118# net140 0
C35753 _163_ _683_/a_38_114# 0
C35754 _707_/a_1840_334# _121_ 0
C35755 hold177/a_438_182# _684_/a_1583_191# 0.00237f
C35756 hold177/a_56_118# _684_/a_2250_412# 0
C35757 fanout32/a_40_152# net49 0
C35758 _439_/a_354_412# _251_ 0.00332f
C35759 _118_ _705_/a_1785_429# 0
C35760 baud_inst.counter\[26\] FILLER_19_75/a_40_246# 0
C35761 _641_/a_843_236# hold176/a_438_182# 0
C35762 baud_inst.counter\[21\] _694_/a_741_93# 0.02609f
C35763 hold53/a_56_118# net52 0.00216f
C35764 hold102/a_326_118# _101_ 0
C35765 _691_/a_612_127# net163 0.00733f
C35766 VPWR FILLER_15_0/a_40_246# 0.1279f
C35767 hold112/a_438_182# _223_ 0
C35768 _656_/a_1583_191# tx_inst.data_reg\[0\] 0
C35769 _153_ _000_ 0.05064f
C35770 net118 net30 0.0073f
C35771 _697_/a_741_93# clknet_4_9_0_clk 0.02974f
C35772 net55 net54 0.06252f
C35773 _704_/a_741_93# hold51/a_56_118# 0
C35774 tx_inst.bit_index\[2\] hold145/a_326_118# 0.00193f
C35775 FILLER_17_79/a_40_246# net29 0
C35776 net67 hold59/a_438_182# 0.01075f
C35777 clknet_4_4_0_clk _664_/a_550_127# 0
C35778 _643_/a_843_236# _264_ 0.00956f
C35779 _349_/a_248_122# net38 0
C35780 clknet_4_14_0_clk _224_ 0.02049f
C35781 net94 baud_inst.counter\[8\] 0.1452f
C35782 _528_/a_81_118# _528_/a_379_118# -0
C35783 _230_ _441_/a_154_118# 0
C35784 FILLER_19_132/a_40_246# net25 0
C35785 _266_ _474_/a_22_110# 0.00904f
C35786 input4/a_40_152# net4 0.00956f
C35787 hold159/a_326_118# _070_ 0
C35788 _501_/a_154_118# baud_inst.counter\[8\] 0.00182f
C35789 _530_/a_257_140# _103_ 0
C35790 _164_ _690_/a_1489_191# 0
C35791 _177_ _311_ 0.00252f
C35792 _089_ _670_/a_843_236# 0
C35793 _690_/a_681_505# _103_ 0
C35794 _690_/a_741_93# clknet_4_8_0_clk 0.03003f
C35795 net41 _148_ 0
C35796 _686_/a_741_93# _685_/a_1583_191# 0
C35797 _686_/a_324_432# _685_/a_1840_334# 0
C35798 _316_ net113 0
C35799 _357_/a_150_412# VPWR 0
C35800 net87 _687_/a_324_432# 0.00433f
C35801 FILLER_25_198/a_32_246# _138_ 0
C35802 hold74/a_56_118# _269_ 0
C35803 hold74/a_326_118# net73 0
C35804 _044_ _648_/a_741_93# 0
C35805 net99 _541_/a_209_168# 0
C35806 _284_ _677_/a_1840_334# 0
C35807 rx_inst.state\[2\] FILLER_18_148/a_40_246# 0.00134f
C35808 VPWR _137_ 0.11814f
C35809 _083_ hold128/a_438_182# 0
C35810 _206_ _208_ 0.27091f
C35811 _170_ _245_ 0.14451f
C35812 FILLER_7_40/a_32_246# hold115/a_56_118# 0.00404f
C35813 net56 _666_/a_324_432# 0
C35814 hold51/a_326_118# net19 0.00838f
C35815 rx_inst.state\[3\] _205_ 0.02573f
C35816 _556_/a_192_429# baud_inst.counter\[29\] 0
C35817 _661_/a_298_337# tx_inst.data_reg\[7\] 0
C35818 _515_/a_76_160# _190_ 0.01837f
C35819 net150 FILLER_29_179/a_40_246# 0.02251f
C35820 FILLER_12_166/a_40_246# _671_/a_38_114# 0
C35821 net9 _388_/a_382_118# 0
C35822 FILLER_10_14/a_40_246# FILLER_8_14/a_32_246# 0
C35823 net56 FILLER_9_169/a_32_246# 0.03768f
C35824 baud_inst.counter\[5\] _162_ 0.13348f
C35825 net156 baud_inst.counter\[19\] 0
C35826 _636_/a_2250_412# clknet_0_clk 0
C35827 _155_ _649_/a_1840_334# 0
C35828 _661_/a_38_114# net7 0
C35829 clknet_4_5_0_clk tx_inst.data_reg\[2\] 0
C35830 _082_ clknet_4_9_0_clk 0.04541f
C35831 hold163/a_326_118# net49 0.05626f
C35832 _656_/a_741_93# VPWR 0.02681f
C35833 _680_/a_741_93# _093_ 0
C35834 _495_/a_154_118# _182_ 0
C35835 net44 baud_inst.counter\[17\] 0.0013f
C35836 net121 _107_ 0.00566f
C35837 net55 _368_/a_155_412# 0.02365f
C35838 net116 _505_/a_170_160# 0
C35839 _283_ baud_inst.counter\[5\] 0
C35840 _705_/a_1840_334# VPWR 0.0023f
C35841 _680_/a_843_236# _183_ 0
C35842 _169_ net63 0
C35843 _534_/a_268_412# _302_ 0
C35844 _099_ _686_/a_1489_191# 0
C35845 _697_/a_1583_191# _110_ 0
C35846 _697_/a_132_114# net142 0
C35847 hold159/a_438_182# clknet_4_1_0_clk 0
C35848 clknet_4_3_0_clk clkbuf_4_3_0_clk/a_27_118# 0.05506f
C35849 FILLER_21_165/a_40_246# _167_ 0.01427f
C35850 hold99/a_56_118# baud_inst.counter\[25\] 0.00347f
C35851 hold99/a_438_182# net99 0.02911f
C35852 _699_/a_612_127# net114 0.00603f
C35853 net12 _632_/a_741_93# 0
C35854 hold64/a_326_118# _632_/a_1583_191# 0.00358f
C35855 net54 _076_ 0
C35856 _341_/a_1377_160# tx_inst.bit_index\[2\] 0.03529f
C35857 clknet_4_4_0_clk _222_ 0
C35858 _638_/a_612_127# _264_ 0.00174f
C35859 _057_ net24 0
C35860 _016_ _522_/a_474_130# 0
C35861 _642_/a_1840_334# _261_ 0
C35862 _642_/a_1583_191# _262_ 0
C35863 _661_/a_38_114# net155 0.00857f
C35864 _225_ hold180/a_438_182# 0
C35865 _248_ hold139/a_438_182# 0.00208f
C35866 net82 output17/a_40_152# 0
C35867 rx_data[0] _632_/a_612_127# 0
C35868 hold138/a_56_118# net30 0.00394f
C35869 hold121/a_56_118# hold147/a_326_118# 0.00135f
C35870 _008_ _033_ 0.13218f
C35871 hold63/a_56_118# _374_/a_244_140# 0
C35872 _206_ _479_/a_22_110# 0.00164f
C35873 net49 net88 0
C35874 _671_/a_1489_191# _168_ 0.01618f
C35875 clknet_0_clk clknet_4_9_0_clk 0.92739f
C35876 _232_ FILLER_25_150/a_32_246# 0.00472f
C35877 _186_ _683_/a_843_236# 0.00565f
C35878 _184_ _683_/a_1583_191# 0.00158f
C35879 _078_ _666_/a_843_236# 0
C35880 net156 fanout40/a_40_152# 0
C35881 net105 hold106/a_326_118# 0.01051f
C35882 hold150/a_438_182# hold78/a_438_182# 0.00174f
C35883 _230_ _427_/a_350_122# 0
C35884 _659_/a_1840_334# clknet_0_clk 0
C35885 _059_ _471_/a_22_110# 0
C35886 net29 baud_inst.counter\[9\] 0.00184f
C35887 _178_ _180_ 0.03448f
C35888 _259_ clknet_0_clk 0
C35889 FILLER_16_176/a_40_246# _247_ 0
C35890 hold143/a_56_118# FILLER_18_210/a_32_246# 0
C35891 hold141/a_326_118# _546_/a_341_118# 0
C35892 _217_ clknet_4_6_0_clk 0.00101f
C35893 _537_/a_192_429# net49 0.00248f
C35894 baud_inst.counter\[13\] _281_ 0
C35895 _377_/a_46_156# _390_/a_382_118# 0.00257f
C35896 tx_inst.data_reg\[7\] _653_/a_1583_191# 0
C35897 _129_ _668_/a_1785_429# 0
C35898 hold167/a_56_118# FILLER_15_127/a_32_246# 0.00404f
C35899 rx_data[7] hold51/a_56_118# 0
C35900 _269_ _647_/a_1840_334# 0
C35901 _109_ FILLER_19_75/a_40_246# 0.00484f
C35902 FILLER_20_65/a_32_246# _309_ 0
C35903 FILLER_26_141/a_40_246# FILLER_25_141/a_32_246# 0
C35904 FILLER_8_171/a_32_246# _217_ 0
C35905 fanout25/a_40_152# _249_ 0.00808f
C35906 baud_inst.counter\[3\] hold60/a_326_118# 0
C35907 _195_ _219_ 0.08136f
C35908 _217_ _218_ 0.13493f
C35909 _012_ _186_ 0
C35910 _645_/a_612_127# _056_ 0
C35911 _006_ _665_/a_132_114# 0
C35912 _275_ _665_/a_1583_191# 0
C35913 hold109/a_438_182# net29 0
C35914 net74 _639_/a_1785_429# 0
C35915 _442_/a_146_122# _242_ 0.00123f
C35916 fanout45/a_40_152# _693_/a_38_114# 0
C35917 _244_ FILLER_23_158/a_40_246# 0
C35918 clknet_0_clk _157_ 0.10674f
C35919 net179 _119_ 0.01208f
C35920 hold166/a_438_182# clknet_4_9_0_clk 0
C35921 _432_/a_248_122# clknet_0_clk 0
C35922 _703_/a_324_432# net46 0
C35923 hold96/a_438_182# VPWR 0.00363f
C35924 FILLER_9_72/a_32_246# _683_/a_1583_191# 0
C35925 baud_inst.counter\[12\] _684_/a_2250_412# 0.01383f
C35926 net12 FILLER_21_229/a_32_246# 0
C35927 _699_/a_324_432# _165_ 0.00221f
C35928 rx_inst.bit_index\[0\] net2 0
C35929 _001_ _666_/a_38_114# 0
C35930 net49 _425_/a_268_412# 0
C35931 _661_/a_1489_191# _148_ 0.01268f
C35932 hold108/a_56_118# net152 0
C35933 _170_ _041_ 0
C35934 net44 _686_/a_1785_429# 0
C35935 baud_inst.counter\[21\] _306_ 0
C35936 net55 _655_/a_1785_429# 0.00317f
C35937 _207_ _655_/a_1840_334# 0
C35938 FILLER_8_35/a_32_246# _681_/a_1840_334# 0
C35939 _167_ _137_ 0.02137f
C35940 rx_inst.data_reg\[3\] clknet_4_13_0_clk 0
C35941 _026_ clknet_0_clk 0.00455f
C35942 _288_ _502_/a_165_412# 0
C35943 net156 _297_ 0
C35944 rx_inst.state\[2\] _641_/a_1583_191# 0.00139f
C35945 baud_inst.counter\[26\] _309_ 0
C35946 FILLER_12_46/a_32_246# net39 0.00734f
C35947 baud_inst.counter\[12\] hold128/a_56_118# 0
C35948 _685_/a_1840_334# clknet_4_9_0_clk 0.00169f
C35949 _636_/a_843_236# hold81/a_326_118# 0
C35950 _231_ _241_ 0.00156f
C35951 _636_/a_741_93# hold81/a_438_182# 0
C35952 _226_ FILLER_18_148/a_40_246# 0.00107f
C35953 _156_ _647_/a_1583_191# 0.00616f
C35954 net31 net175 0
C35955 FILLER_7_40/a_32_246# net38 0
C35956 rx _639_/a_132_114# 0
C35957 _642_/a_2250_412# clknet_0_clk 0.00273f
C35958 _549_/a_257_140# baud_inst.counter\[29\] 0
C35959 _663_/a_38_114# net168 0
C35960 rx_data[7] _457_/a_120_432# 0.00124f
C35961 _427_/a_146_122# _254_ 0
C35962 _704_/a_843_236# net43 0
C35963 _671_/a_2250_412# clknet_0_clk 0.00175f
C35964 hold139/a_438_182# net139 0.01094f
C35965 FILLER_7_121/a_40_246# clknet_4_4_0_clk 0
C35966 net184 _176_ 0
C35967 _536_/a_435_412# VPWR 0
C35968 _278_ baud_inst.counter\[4\] 0.0044f
C35969 tx_inst.bit_index\[1\] tx_inst.data_reg\[3\] 0.01881f
C35970 clknet_0_clk _686_/a_2250_412# 0
C35971 net111 VPWR 0.19617f
C35972 hold130/a_56_118# _013_ 0
C35973 _245_ _237_ 0.00122f
C35974 net55 _065_ 0.04707f
C35975 rx_inst.data_reg\[3\] net65 0
C35976 VPWR _311_ 0.07693f
C35977 hold74/a_438_182# FILLER_16_221/a_32_246# 0.00492f
C35978 _075_ net27 0
C35979 VPWR _669_/a_741_93# 0.01536f
C35980 tx_data[4] tx_data[7] 0.96541f
C35981 _486_/a_358_436# hold180/a_438_182# 0
C35982 net72 hold72/a_56_118# 0.00255f
C35983 _048_ hold72/a_326_118# 0.00802f
C35984 _244_ _649_/a_298_337# 0
C35985 _180_ _297_ 0
C35986 _538_/a_379_118# _301_ 0
C35987 _448_/a_244_412# FILLER_20_177/a_32_246# 0
C35988 _673_/a_38_114# net29 0
C35989 _707_/a_843_236# _704_/a_843_236# 0.0035f
C35990 FILLER_26_151/a_32_246# _161_ 0
C35991 net105 _314_ 0.0795f
C35992 _040_ FILLER_2_237/a_40_246# 0.0243f
C35993 VPWR baud_inst.counter\[10\] 0.17343f
C35994 _638_/a_38_114# net65 0.00334f
C35995 _302_ baud_inst.counter\[17\] 0
C35996 baud_inst.counter\[14\] _686_/a_843_236# 0.01878f
C35997 FILLER_23_186/a_40_246# net24 0.00107f
C35998 net138 VPWR 0.07893f
C35999 _170_ _255_ 0.0546f
C36000 _206_ _657_/a_612_127# 0
C36001 hold97/a_56_118# _512_/a_165_412# 0
C36002 _235_ rx_inst.state\[4\] 0
C36003 _690_/a_1840_334# baud_inst.counter\[17\] 0.00508f
C36004 hold77/a_326_118# net13 0.00432f
C36005 _273_ clkbuf_4_15_0_clk/a_27_118# 0.00301f
C36006 _658_/a_1840_334# VPWR 0.0034f
C36007 _707_/a_38_114# net43 0.00269f
C36008 _644_/a_38_114# clknet_4_14_0_clk 0.00413f
C36009 _286_ _287_ 0.51404f
C36010 net37 _416_/a_350_122# 0.00405f
C36011 net69 _049_ 0
C36012 clk _706_/a_1785_429# 0
C36013 hold88/a_56_118# baud_inst.counter\[13\] 0
C36014 _061_ _140_ 0
C36015 _539_/a_45_160# _308_ 0
C36016 _307_ _540_/a_45_160# 0.02289f
C36017 tx_inst.data_reg\[1\] _382_/a_59_156# 0
C36018 _171_ _665_/a_38_114# 0
C36019 _499_/a_380_412# _183_ 0.001f
C36020 _283_ _496_/a_170_412# 0
C36021 tx_inst.bit_index\[2\] _195_ 0.86663f
C36022 _206_ tx_data[7] 0
C36023 _077_ _478_/a_27_156# 0
C36024 _523_/a_257_140# clknet_4_2_0_clk 0
C36025 net39 hold128/a_56_118# 0.00429f
C36026 FILLER_17_162/a_32_246# _249_ 0
C36027 _251_ _253_ 0.17909f
C36028 baud_inst.counter\[22\] _694_/a_1583_191# 0.01408f
C36029 clknet_4_14_0_clk FILLER_23_158/a_40_246# 0.00228f
C36030 _410_/a_155_412# clk 0
C36031 _641_/a_1489_191# hold176/a_56_118# 0
C36032 net26 _477_/a_120_432# 0
C36033 hold98/a_326_118# _681_/a_324_432# 0
C36034 baud_inst.counter\[23\] net114 0.00185f
C36035 _656_/a_2002_114# tx_inst.data_reg\[0\] 0
C36036 _697_/a_1785_429# clknet_4_9_0_clk 0
C36037 net31 _161_ 0.29921f
C36038 _183_ hold93/a_56_118# 0
C36039 _431_/a_175_118# net32 0.00444f
C36040 _029_ FILLER_27_46/a_32_246# 0.00115f
C36041 net69 _638_/a_1583_191# 0
C36042 net47 _264_ 0.86201f
C36043 net66 _632_/a_298_337# 0.00286f
C36044 _678_/a_324_432# net40 0.05164f
C36045 net27 _651_/a_38_114# 0
C36046 _668_/a_324_432# _668_/a_843_236# -0
C36047 _358_/a_166_436# _182_ 0
C36048 _044_ _059_ 0
C36049 _643_/a_612_127# _264_ 0
C36050 _376_/a_272_160# clknet_0_clk 0
C36051 _021_ _692_/a_38_114# 0
C36052 net148 _692_/a_741_93# 0
C36053 _682_/a_298_337# net117 0
C36054 _374_/a_244_140# clknet_0_clk 0
C36055 _528_/a_81_118# _301_ 0.0163f
C36056 _091_ _678_/a_38_114# 0.02229f
C36057 _044_ _159_ 0.10631f
C36058 _663_/a_2250_412# hold50/a_438_182# 0.00887f
C36059 _690_/a_1785_429# clknet_4_8_0_clk 0
C36060 net87 _687_/a_2250_412# 0.01106f
C36061 net48 output19/a_40_152# 0.00812f
C36062 net150 VPWR 0.23587f
C36063 _178_ net120 0
C36064 _176_ net169 0
C36065 _045_ _637_/a_1489_191# 0
C36066 _636_/a_324_432# clkbuf_4_13_0_clk/a_27_118# 0
C36067 net71 _637_/a_681_505# 0
C36068 _294_ _684_/a_741_93# 0
C36069 net28 _000_ 0.47043f
C36070 hold87/a_56_118# _696_/a_741_93# 0
C36071 VPWR _047_ 0.15374f
C36072 _646_/a_324_432# _223_ 0
C36073 net173 net56 0
C36074 rx_data[1] _633_/a_741_93# 0
C36075 net13 _633_/a_843_236# 0.0087f
C36076 _228_ _423_/a_165_412# 0.00378f
C36077 _344_/a_150_412# _312_ 0.00147f
C36078 _703_/a_324_432# _313_ 0.00194f
C36079 net108 net152 0.00122f
C36080 _632_/a_1583_191# FILLER_21_229/a_32_246# 0
C36081 net154 hold93/a_56_118# 0
C36082 _140_ _433_/a_142_412# 0
C36083 net44 clknet_4_10_0_clk 0
C36084 _371_/a_170_412# tx_inst.state\[2\] 0
C36085 hold126/a_438_182# _264_ 0.01249f
C36086 net145 _657_/a_843_236# 0
C36087 hold174/a_438_182# net27 0.05961f
C36088 _180_ FILLER_17_96/a_32_246# 0
C36089 _463_/a_22_110# clknet_0_clk 0
C36090 _316_ baud_inst.counter\[29\] 0.03366f
C36091 net44 _687_/a_843_236# 0.00885f
C36092 net28 _647_/a_38_114# 0
C36093 _660_/a_843_236# _654_/a_38_114# 0
C36094 hold55/a_56_118# input2/a_40_152# 0
C36095 clknet_4_6_0_clk _668_/a_132_114# 0
C36096 input4/a_40_152# net40 0.0033f
C36097 tx_data[6] net165 0
C36098 hold161/a_326_118# _101_ 0
C36099 net111 _266_ 0.06469f
C36100 _109_ _309_ 0.00133f
C36101 clknet_4_14_0_clk _649_/a_298_337# 0
C36102 _641_/a_843_236# baud_inst.counter\[25\] 0.00312f
C36103 _675_/a_741_93# FILLER_1_28/a_40_246# 0.00392f
C36104 _656_/a_1785_429# VPWR 0
C36105 baud_inst.counter\[6\] clkbuf_4_1_0_clk/a_27_118# 0.00464f
C36106 hold183/a_326_118# net183 0.00462f
C36107 _646_/a_324_432# _240_ 0.00766f
C36108 net74 _156_ 0.09593f
C36109 hold164/a_438_182# _692_/a_324_432# 0
C36110 clkload2/Y net46 0
C36111 _303_ _106_ 0
C36112 _672_/a_741_93# net61 0
C36113 _672_/a_843_236# _033_ 0.00244f
C36114 tx_inst.bit_index\[2\] _401_/a_22_110# 0
C36115 hold158/a_438_182# baud_inst.counter\[17\] 0
C36116 hold129/a_326_118# VPWR 0.0044f
C36117 _179_ _554_/a_248_122# 0.00186f
C36118 hold177/a_438_182# baud_inst.counter\[13\] 0.00201f
C36119 rx_inst.state\[3\] FILLER_12_117/a_40_246# 0
C36120 _114_ baud_inst.counter\[21\] 0.018f
C36121 _694_/a_1583_191# _694_/a_2250_412# -0
C36122 _694_/a_741_93# _694_/a_1489_191# 0
C36123 _697_/a_1489_191# net142 0
C36124 hold136/a_326_118# _490_/a_45_160# 0.00106f
C36125 _414_/a_279_412# VPWR 0
C36126 _550_/a_380_412# FILLER_28_53/a_32_246# 0
C36127 _642_/a_741_93# _642_/a_843_236# -0
C36128 net12 _632_/a_1785_429# 0
C36129 _310_ net90 0
C36130 clknet_0_clk _687_/a_741_93# 0.00418f
C36131 net70 _264_ 0.00538f
C36132 _132_ _453_/a_170_412# 0
C36133 _642_/a_1489_191# _131_ 0
C36134 _661_/a_2250_412# _206_ 0
C36135 _661_/a_132_114# _151_ 0
C36136 _072_ _378_/a_59_156# 0
C36137 _206_ clknet_4_1_0_clk 0.2462f
C36138 _655_/a_324_432# clknet_0_clk 0.00227f
C36139 hold101/a_56_118# net160 0
C36140 net121 hold147/a_438_182# 0.00195f
C36141 _040_ _074_ 0
C36142 hold124/a_56_118# net124 0
C36143 _046_ clknet_4_13_0_clk 0.07007f
C36144 _388_/a_382_118# net171 0
C36145 _184_ _683_/a_2002_114# 0
C36146 _353_/a_146_122# baud_inst.counter\[11\] 0
C36147 net52 net24 1.97062f
C36148 _128_ net72 0
C36149 _674_/a_132_114# _030_ 0
C36150 _671_/a_741_93# _671_/a_843_236# -0
C36151 net48 _636_/a_843_236# 0
C36152 FILLER_19_149/a_40_246# FILLER_18_148/a_40_246# 0
C36153 _230_ _244_ 0.01371f
C36154 _695_/a_550_127# VPWR -0
C36155 net73 hold73/a_56_118# 0
C36156 _180_ net162 0.0022f
C36157 _162_ clknet_0_clk 0.0367f
C36158 rx_inst.data_reg\[4\] _647_/a_843_236# 0
C36159 net12 net66 0
C36160 baud_inst.counter\[5\] clkbuf_4_3_0_clk/a_27_118# 0.02594f
C36161 net96 VPWR 0.17345f
C36162 _660_/a_843_236# _660_/a_1489_191# 0
C36163 hold115/a_438_182# net181 0
C36164 _226_ _405_/a_27_156# 0
C36165 _040_ _665_/a_1489_191# 0.00177f
C36166 _283_ clknet_0_clk 0.05228f
C36167 _410_/a_155_412# net2 0
C36168 rx_inst.bit_index\[1\] fanout28/a_40_152# 0
C36169 _305_ net49 0.02045f
C36170 _240_ _473_/a_22_110# 0.00139f
C36171 _658_/a_550_127# tx_inst.data_reg\[1\] 0
C36172 hold137/a_326_118# _142_ 0
C36173 _057_ _647_/a_324_432# 0
C36174 _663_/a_1489_191# net146 0
C36175 _097_ hold109/a_326_118# 0.00174f
C36176 tx_inst.data_reg\[7\] _653_/a_2002_114# 0
C36177 _064_ hold137/a_56_118# 0
C36178 clknet_4_6_0_clk _667_/a_843_236# 0.00207f
C36179 rx_inst.state\[3\] hold123/a_326_118# 0
C36180 _278_ hold123/a_56_118# 0.00108f
C36181 hold102/a_438_182# VPWR 0.00807f
C36182 hold65/a_56_118# hold72/a_56_118# 0
C36183 _255_ _237_ 0
C36184 tx_inst.bit_index\[1\] hold184/a_56_118# 0.00424f
C36185 _484_/a_154_118# _191_ 0.00107f
C36186 _692_/a_298_337# net164 0.00101f
C36187 _116_ net49 0.0524f
C36188 _153_ _417_/a_22_110# 0.0017f
C36189 net44 _053_ 0.11038f
C36190 _339_/a_295_385# clknet_4_4_0_clk 0.00719f
C36191 _006_ _665_/a_1489_191# 0
C36192 clknet_4_3_0_clk hold93/a_56_118# 0
C36193 output21/a_40_152# _705_/a_741_93# 0
C36194 net74 _050_ 0
C36195 _440_/a_142_412# VPWR 0
C36196 baud_inst.counter\[1\] hold181/a_326_118# 0.00186f
C36197 _284_ baud_inst.counter\[11\] 0
C36198 _680_/a_1840_334# _289_ 0
C36199 _078_ _395_/a_248_122# 0
C36200 _266_ _047_ 0
C36201 net31 clkbuf_4_14_0_clk/a_27_118# 0.00205f
C36202 rx_data[3] FILLER_19_228/a_40_246# 0
C36203 _179_ hold114/a_56_118# 0.00286f
C36204 baud_inst.counter\[31\] hold114/a_438_182# 0
C36205 net179 net33 0
C36206 _700_/a_38_114# net134 0.01074f
C36207 _398_/a_358_436# VPWR -0.00104f
C36208 _125_ _650_/a_2250_412# 0
C36209 _635_/a_741_93# _632_/a_741_93# 0.00141f
C36210 _635_/a_843_236# _632_/a_324_432# 0
C36211 tx_inst.data_reg\[7\] _148_ 0.09853f
C36212 _307_ _687_/a_550_127# 0
C36213 _499_/a_209_168# _351_/a_46_156# 0
C36214 net87 _515_/a_76_160# 0
C36215 net92 _510_/a_350_122# 0
C36216 _536_/a_341_118# _106_ 0
C36217 hold140/a_56_118# net176 0.00804f
C36218 rx_inst.state\[2\] _641_/a_2002_114# 0
C36219 clknet_4_12_0_clk fanout25/a_40_152# 0
C36220 _158_ FILLER_29_179/a_40_246# 0
C36221 _170_ _649_/a_681_505# 0
C36222 FILLER_21_165/a_40_246# _232_ 0.00161f
C36223 _685_/a_38_114# hold91/a_56_118# 0
C36224 _685_/a_298_337# hold91/a_326_118# 0.00245f
C36225 net49 _701_/a_741_93# 0.01047f
C36226 _500_/a_257_140# net86 0
C36227 _156_ _647_/a_2002_114# 0.0015f
C36228 _130_ _161_ 0
C36229 clknet_4_7_0_clk net26 0
C36230 _162_ _182_ 0.31794f
C36231 net48 hold81/a_438_182# 0
C36232 hold68/a_438_182# VPWR 0.00507f
C36233 hold121/a_438_182# _693_/a_843_236# 0
C36234 net146 _665_/a_38_114# 0
C36235 _704_/a_612_127# net43 0
C36236 _309_ _541_/a_474_130# 0.0014f
C36237 net48 _436_/a_244_140# 0
C36238 net140 net162 0
C36239 hold66/a_56_118# _635_/a_324_432# 0
C36240 _283_ _182_ 1.02311f
C36241 FILLER_11_32/a_32_246# _688_/a_843_236# 0
C36242 _002_ _224_ 0
C36243 clknet_4_13_0_clk _043_ 0
C36244 _393_/a_170_412# _166_ 0
C36245 _689_/a_2250_412# _688_/a_843_236# 0
C36246 _022_ VPWR 0.05873f
C36247 _206_ _392_/a_382_118# 0.03011f
C36248 _680_/a_1583_191# hold135/a_56_118# 0
C36249 _680_/a_324_432# baud_inst.counter\[8\] 0
C36250 hold71/a_438_182# rx_inst.data_reg\[5\] 0
C36251 _464_/a_120_432# clknet_4_15_0_clk 0
C36252 _302_ clknet_4_10_0_clk 0.2185f
C36253 _049_ _122_ 0
C36254 hold132/a_438_182# _255_ 0.00146f
C36255 hold155/a_326_118# net38 0.00195f
C36256 _691_/a_38_114# net102 0
C36257 _230_ clknet_4_14_0_clk 3.16743f
C36258 net49 _693_/a_1489_191# 0.01772f
C36259 baud_inst.counter\[13\] _494_/a_165_412# 0
C36260 _360_/a_1023_118# net34 0
C36261 hold113/a_438_182# net46 0.04456f
C36262 hold52/a_438_182# clknet_4_14_0_clk 0.00658f
C36263 net49 _020_ 0.00317f
C36264 _306_ _301_ 0.08963f
C36265 hold68/a_56_118# net133 0.01117f
C36266 VPWR _633_/a_132_114# 0
C36267 _031_ _550_/a_177_436# 0.00176f
C36268 clkbuf_4_10_0_clk/a_27_118# clknet_4_10_0_clk 0.01218f
C36269 hold170/a_326_118# net55 0.01755f
C36270 _040_ _201_ 0
C36271 _707_/a_1840_334# _704_/a_1583_191# 0
C36272 _707_/a_1583_191# _704_/a_1840_334# 0
C36273 hold142/a_56_118# _696_/a_1583_191# 0
C36274 _206_ net27 0.0806f
C36275 baud_inst.counter\[14\] _686_/a_612_127# 0.01647f
C36276 _489_/a_494_160# net136 0
C36277 net11 tx_inst.state\[3\] 0.05936f
C36278 hold89/a_56_118# _295_ 0
C36279 net155 _068_ 0
C36280 _206_ _147_ 0.02136f
C36281 net29 hold95/a_326_118# 0.02115f
C36282 hold97/a_438_182# net109 0
C36283 hold97/a_56_118# _010_ 0.09469f
C36284 hold97/a_326_118# _292_ 0.01328f
C36285 _644_/a_1840_334# clknet_4_14_0_clk 0.00538f
C36286 hold134/a_56_118# _115_ 0.00598f
C36287 _043_ net65 0.03237f
C36288 _039_ net117 0.08552f
C36289 _288_ baud_inst.counter\[9\] 0.01321f
C36290 _295_ _187_ 0.05806f
C36291 _201_ _006_ 0
C36292 net136 _681_/a_843_236# 0
C36293 net42 _667_/a_298_337# 0
C36294 hold166/a_56_118# _191_ 0
C36295 _264_ _649_/a_324_432# 0.01692f
C36296 tx_done VPWR 0.1215f
C36297 net176 hold176/a_438_182# 0.00134f
C36298 baud_inst.counter\[28\] _551_/a_170_160# 0
C36299 baud_inst.counter\[22\] _694_/a_2002_114# 0
C36300 baud_inst.counter\[21\] _107_ 0.01437f
C36301 _673_/a_324_432# _086_ 0.02924f
C36302 net98 _681_/a_843_236# 0
C36303 _110_ clknet_4_9_0_clk 0.13404f
C36304 _123_ _648_/a_324_432# 0
C36305 clk _656_/a_38_114# 0.03765f
C36306 _646_/a_741_93# clknet_0_clk 0.0155f
C36307 VPWR FILLER_3_21/a_40_246# 0.15953f
C36308 hold69/a_56_118# net18 0.03772f
C36309 hold69/a_438_182# net70 0
C36310 hold89/a_438_182# _014_ 0.00992f
C36311 net74 hold138/a_438_182# 0
C36312 _645_/a_1583_191# clknet_4_14_0_clk 0.04959f
C36313 _644_/a_843_236# _242_ 0
C36314 _485_/a_120_432# _667_/a_38_114# 0
C36315 net27 _651_/a_1840_334# 0.02431f
C36316 net79 _674_/a_1583_191# 0.00117f
C36317 net112 _264_ 0
C36318 net100 _698_/a_132_114# 0
C36319 tx_inst.data_reg\[6\] _656_/a_1489_191# 0.02002f
C36320 _707_/a_1489_191# net19 0
C36321 hold130/a_438_182# net130 0.01094f
C36322 net30 net80 0.00468f
C36323 net2 hold180/a_56_118# 0
C36324 hold97/a_438_182# net110 0.0013f
C36325 _703_/a_843_236# clknet_0_clk 0
C36326 tx _200_ 0.00236f
C36327 hold109/a_438_182# _288_ 0
C36328 _436_/a_244_140# _250_ 0.00143f
C36329 net173 _196_ 0
C36330 net159 _209_ 0.62297f
C36331 net55 VPWR 1.57695f
C36332 hold182/a_438_182# _670_/a_298_337# 0.00102f
C36333 hold182/a_326_118# _670_/a_38_114# 0
C36334 _103_ clknet_4_8_0_clk 0.05039f
C36335 _539_/a_45_160# VPWR 0.05468f
C36336 _633_/a_2250_412# FILLER_28_204/a_32_246# 0.01061f
C36337 hold65/a_56_118# _128_ 0
C36338 hold65/a_326_118# _267_ 0.00446f
C36339 hold145/a_438_182# net41 0
C36340 _686_/a_681_505# clknet_4_9_0_clk 0
C36341 clknet_4_12_0_clk FILLER_17_162/a_32_246# 0
C36342 _045_ net17 0
C36343 _112_ _699_/a_132_114# 0
C36344 _194_ net27 0.16537f
C36345 _671_/a_2250_412# net43 0
C36346 _059_ _648_/a_38_114# 0.00319f
C36347 net79 _673_/a_298_337# 0.00299f
C36348 _636_/a_2250_412# clkbuf_4_13_0_clk/a_27_118# 0
C36349 net45 _701_/a_1489_191# 0.01788f
C36350 _151_ FILLER_0_109/a_32_246# 0.00132f
C36351 _696_/a_741_93# _544_/a_46_156# 0
C36352 _108_ VPWR 0.23081f
C36353 _228_ _241_ 0.11232f
C36354 baud_inst.counter\[27\] _312_ 0.04576f
C36355 _159_ _648_/a_38_114# 0
C36356 _360_/a_382_118# _656_/a_843_236# 0
C36357 _360_/a_1453_124# _656_/a_1583_191# 0
C36358 FILLER_18_65/a_40_246# _308_ 0
C36359 _155_ _139_ 0
C36360 net34 _477_/a_120_432# 0
C36361 _140_ _156_ 0.00269f
C36362 _002_ _409_/a_269_412# 0
C36363 FILLER_25_198/a_32_246# _649_/a_843_236# 0
C36364 net44 _687_/a_612_127# 0.00772f
C36365 _170_ hold127/a_56_118# 0.06391f
C36366 _380_/a_559_412# _208_ 0.00714f
C36367 _380_/a_285_118# net170 0
C36368 _206_ _706_/a_298_337# 0
C36369 VPWR _504_/a_380_412# 0
C36370 _191_ fanout26/a_40_152# 0.02688f
C36371 net49 hold105/a_438_182# 0.00142f
C36372 hold173/a_56_118# _403_/a_22_110# 0
C36373 _254_ _425_/a_46_156# 0
C36374 net105 net134 0
C36375 hold74/a_438_182# _047_ 0
C36376 _640_/a_741_93# FILLER_22_118/a_32_246# 0
C36377 net41 FILLER_4_108/a_40_246# 0.01378f
C36378 hold183/a_438_182# hold122/a_56_118# 0
C36379 hold183/a_326_118# hold122/a_326_118# 0
C36380 hold183/a_56_118# hold122/a_438_182# 0
C36381 _104_ FILLER_17_22/a_40_246# 0
C36382 VPWR hold60/a_438_182# 0.00769f
C36383 _641_/a_612_127# baud_inst.counter\[25\] 0.00922f
C36384 _067_ VPWR 0.34243f
C36385 _646_/a_2250_412# _240_ 0.00322f
C36386 _086_ net29 0.00282f
C36387 hold164/a_56_118# _692_/a_612_127# 0
C36388 _672_/a_612_127# _033_ 0.00358f
C36389 _246_ net37 0.01809f
C36390 hold169/a_326_118# net168 0.00951f
C36391 hold154/a_56_118# net39 0
C36392 _518_/a_45_160# _297_ 0
C36393 _694_/a_132_114# _107_ 0
C36394 FILLER_12_89/a_40_246# hold154/a_56_118# 0.0034f
C36395 _514_/a_155_412# _293_ 0.03869f
C36396 _248_ _247_ 0.0323f
C36397 _633_/a_1583_191# net30 0.00229f
C36398 _091_ net29 0
C36399 _053_ _697_/a_2250_412# 0.00487f
C36400 clknet_4_12_0_clk _697_/a_1583_191# 0
C36401 baud_inst.counter\[28\] _700_/a_843_236# 0.00253f
C36402 _166_ hold50/a_438_182# 0
C36403 net28 _405_/a_229_118# 0
C36404 hold135/a_438_182# VPWR 0.00385f
C36405 _129_ _650_/a_2250_412# 0.00186f
C36406 _374_/a_142_412# _205_ 0.00156f
C36407 clknet_0_clk hold91/a_56_118# 0.00143f
C36408 hold121/a_326_118# net75 0
C36409 hold121/a_56_118# _305_ 0.00909f
C36410 net124 _648_/a_324_432# 0.00519f
C36411 _155_ _648_/a_38_114# 0.00148f
C36412 hold127/a_438_182# _244_ 0
C36413 net37 _258_ 0
C36414 hold147/a_326_118# _694_/a_298_337# 0
C36415 _656_/a_843_236# net9 0.05858f
C36416 _076_ VPWR 0.28039f
C36417 net156 _684_/a_298_337# 0.01856f
C36418 rx_inst.state\[2\] net49 0.09473f
C36419 _341_/a_308_118# net41 0
C36420 _660_/a_324_432# net54 0.0365f
C36421 _660_/a_298_337# _214_ 0.03049f
C36422 _674_/a_1489_191# _030_ 0
C36423 hold130/a_438_182# _358_/a_72_436# 0
C36424 hold113/a_438_182# _313_ 0
C36425 net45 baud_inst.counter\[25\] 0.00118f
C36426 _374_/a_244_140# net43 0.00147f
C36427 _198_ _365_/a_155_412# 0.00207f
C36428 FILLER_13_100/a_40_246# hold128/a_56_118# 0.00786f
C36429 net27 _202_ 0.00431f
C36430 FILLER_8_189/a_40_246# _166_ 0
C36431 _241_ _153_ 0
C36432 baud_inst.counter\[15\] _687_/a_132_114# 0
C36433 _157_ clkbuf_4_13_0_clk/a_27_118# 0.00139f
C36434 _641_/a_1583_191# _455_/a_155_412# 0
C36435 clknet_0_clk _450_/a_398_96# 0
C36436 VPWR clknet_4_15_0_clk 0.44661f
C36437 _040_ tx_inst.state\[3\] 0.03849f
C36438 _229_ net2 0.04291f
C36439 VPWR _389_/a_46_156# 0.00352f
C36440 _089_ _676_/a_38_114# 0.00568f
C36441 net44 _308_ 0.00436f
C36442 baud_inst.counter\[28\] hold106/a_326_118# 0.00249f
C36443 tx_inst.state\[1\] net146 0
C36444 _207_ net159 0
C36445 clknet_4_7_0_clk net50 0.10872f
C36446 baud_inst.counter\[7\] _036_ 0.00782f
C36447 net55 FILLER_7_234/a_32_246# 0
C36448 clknet_4_6_0_clk _667_/a_612_127# 0
C36449 clknet_4_11_0_clk _700_/a_298_337# 0
C36450 net48 hold143/a_56_118# 0
C36451 _193_ hold184/a_326_118# 0
C36452 rx _705_/a_1583_191# 0.00168f
C36453 net148 _021_ 0.38877f
C36454 _489_/a_358_436# clknet_4_0_0_clk 0.01707f
C36455 fanout34/a_40_152# _651_/a_324_432# 0
C36456 _692_/a_1583_191# net164 0
C36457 clknet_0_clk tx_inst.state\[2\] 0.00511f
C36458 hold117/a_56_118# net38 0
C36459 hold172/a_56_118# net43 0.01264f
C36460 _339_/a_500_118# clknet_4_4_0_clk 0.00374f
C36461 _158_ VPWR 0.43692f
C36462 rx_inst.data_reg\[0\] net64 0.08044f
C36463 clknet_4_0_0_clk _681_/a_741_93# 0.03044f
C36464 clkbuf_0_clk/a_116_82# _669_/a_843_236# 0
C36465 _011_ _180_ 0
C36466 _689_/a_132_114# _101_ 0
C36467 _643_/a_1840_334# net65 0.00364f
C36468 _643_/a_1583_191# _122_ 0
C36469 hold78/a_326_118# net47 0.01919f
C36470 _233_ FILLER_16_176/a_40_246# 0
C36471 _678_/a_843_236# clknet_4_1_0_clk 0.02473f
C36472 _170_ _424_/a_244_412# 0.03106f
C36473 net32 _424_/a_142_412# 0
C36474 _680_/a_1840_334# net135 0
C36475 _680_/a_1583_191# _287_ 0
C36476 _339_/a_1453_124# FILLER_7_146/a_32_246# 0
C36477 _143_ VPWR 0.18998f
C36478 net145 clknet_4_1_0_clk 0.86782f
C36479 net58 _031_ 0.00296f
C36480 _114_ _694_/a_1489_191# 0
C36481 hold148/a_326_118# clknet_4_10_0_clk 0.03758f
C36482 net3 net170 0.3493f
C36483 _078_ tx_inst.state\[4\] 0.00151f
C36484 _004_ _372_/a_120_432# 0
C36485 _541_/a_177_436# net46 0
C36486 clkbuf_4_3_0_clk/a_27_118# clknet_0_clk 0.10237f
C36487 net92 _291_ 0.00263f
C36488 _358_/a_72_436# baud_inst.counter\[4\] 0
C36489 baud_inst.counter\[18\] net88 0
C36490 baud_inst.counter\[26\] _697_/a_741_93# 0
C36491 net28 _417_/a_22_110# 0
C36492 _286_ net108 0.01265f
C36493 hold153/a_438_182# baud_inst.counter\[5\] 0.01625f
C36494 clkbuf_4_6_0_clk/a_27_118# _651_/a_2250_412# 0
C36495 _685_/a_324_432# net91 0
C36496 baud_inst.counter\[5\] hold93/a_56_118# 0
C36497 net2 clknet_4_13_0_clk 0.00304f
C36498 _411_/a_494_160# rx_inst.state\[2\] 0.00129f
C36499 _247_ net139 0
C36500 _468_/a_120_432# _269_ 0.0027f
C36501 _116_ hold59/a_438_182# 0.00183f
C36502 _286_ net181 0
C36503 net182 _670_/a_324_432# 0
C36504 clknet_4_14_0_clk _471_/a_120_432# 0.00296f
C36505 _637_/a_324_432# VPWR 0
C36506 net121 _693_/a_1583_191# 0
C36507 net109 _684_/a_324_432# 0
C36508 _292_ _684_/a_38_114# 0
C36509 _062_ clknet_4_6_0_clk 0.11177f
C36510 net166 net51 0.18357f
C36511 hold121/a_438_182# net163 0
C36512 _125_ _264_ 0
C36513 _549_/a_155_412# net46 0
C36514 hold161/a_438_182# VPWR 0.00715f
C36515 hold164/a_326_118# _021_ 0
C36516 FILLER_1_67/a_40_246# _181_ 0.00322f
C36517 _689_/a_324_432# net161 0
C36518 net158 _688_/a_324_432# 0
C36519 _675_/a_132_114# net38 0
C36520 _680_/a_2250_412# baud_inst.counter\[8\] 0.02695f
C36521 _127_ clknet_4_15_0_clk 0.50719f
C36522 net82 FILLER_29_198/a_40_246# 0
C36523 _429_/a_142_412# net78 0
C36524 FILLER_15_89/a_32_246# net90 0.01391f
C36525 _262_ net175 0.10627f
C36526 FILLER_0_103/a_32_246# _381_/a_46_156# 0.0073f
C36527 net184 _174_ 0.4867f
C36528 hold97/a_326_118# _289_ 0
C36529 hold143/a_326_118# _157_ 0
C36530 _031_ _028_ 0
C36531 clknet_4_8_0_clk _687_/a_298_337# 0.01249f
C36532 _224_ _434_/a_354_412# 0
C36533 VPWR _633_/a_1489_191# 0.00154f
C36534 net31 _154_ 0.00497f
C36535 _650_/a_324_432# _668_/a_741_93# 0
C36536 _650_/a_741_93# _668_/a_324_432# 0
C36537 net26 _651_/a_1785_429# 0
C36538 _265_ _639_/a_741_93# 0.01651f
C36539 _129_ _639_/a_324_432# 0.00226f
C36540 _390_/a_496_118# _213_ 0.00259f
C36541 FILLER_20_65/a_32_246# clknet_0_clk 0
C36542 hold137/a_326_118# _070_ 0
C36543 clkbuf_4_3_0_clk/a_27_118# _182_ 0.0042f
C36544 clknet_4_3_0_clk _652_/a_324_432# 0.02605f
C36545 _168_ _458_/a_165_412# 0.00268f
C36546 baud_inst.counter\[18\] _529_/a_45_160# 0
C36547 _266_ clknet_4_15_0_clk 0.68031f
C36548 _674_/a_1840_334# _672_/a_324_432# 0
C36549 _674_/a_1583_191# _672_/a_741_93# 0.00172f
C36550 _226_ net49 0.04037f
C36551 _646_/a_38_114# _058_ 0
C36552 hold184/a_326_118# net174 0
C36553 hold115/a_326_118# net38 0
C36554 net42 _667_/a_1583_191# 0
C36555 _690_/a_741_93# net161 0
C36556 net32 _416_/a_350_122# 0.00168f
C36557 net156 baud_inst.counter\[16\] 0.39422f
C36558 fanout32/a_40_152# net25 0
C36559 _264_ _649_/a_2250_412# 0
C36560 clknet_4_0_0_clk _490_/a_139_160# 0
C36561 net172 _665_/a_843_236# 0
C36562 _200_ _665_/a_324_432# 0.0444f
C36563 baud_inst.counter\[28\] _314_ 0.0416f
C36564 net79 hold79/a_438_182# 0.02841f
C36565 _662_/a_741_93# net41 0
C36566 _230_ hold176/a_56_118# 0
C36567 clk _656_/a_1840_334# 0.00482f
C36568 _166_ net172 0.01425f
C36569 _646_/a_1785_429# clknet_0_clk 0
C36570 net31 _405_/a_27_156# 0
C36571 _550_/a_177_436# _313_ 0.00131f
C36572 _645_/a_2002_114# clknet_4_14_0_clk 0
C36573 net45 baud_inst.counter\[24\] 0
C36574 net179 _369_/a_248_122# 0.00218f
C36575 _003_ _667_/a_38_114# 0.00271f
C36576 net122 _667_/a_843_236# 0.01312f
C36577 net37 _667_/a_741_93# 0.00124f
C36578 clknet_0_clk _435_/a_166_436# 0
C36579 _158_ _266_ 0.09564f
C36580 _154_ clkbuf_4_15_0_clk/a_27_118# 0.0132f
C36581 net100 _698_/a_1489_191# 0.00328f
C36582 _707_/a_38_114# net51 0.02954f
C36583 _127_ _637_/a_324_432# 0
C36584 tx_inst.data_reg\[6\] tx_inst.data_reg\[2\] 0.79593f
C36585 net123 _373_/a_170_412# 0
C36586 FILLER_15_173/a_40_246# _140_ 0.02005f
C36587 baud_inst.counter\[26\] clknet_0_clk 0.08987f
C36588 _658_/a_2250_412# net9 0
C36589 _157_ _249_ 0
C36590 _145_ _213_ 0
C36591 VPWR _349_/a_248_122# 0
C36592 _526_/a_146_122# net101 0.00518f
C36593 _177_ hold114/a_438_182# 0
C36594 baud_inst.counter\[21\] hold147/a_438_182# 0
C36595 hold174/a_56_118# net168 0
C36596 net34 _651_/a_741_93# 0.00191f
C36597 _339_/a_382_118# clknet_0_clk 0.01534f
C36598 VPWR _685_/a_298_337# 0.0014f
C36599 _686_/a_550_127# clknet_4_9_0_clk 0
C36600 _444_/a_244_412# _134_ 0
C36601 net31 fanout36/a_40_152# 0.01343f
C36602 VPWR _666_/a_681_505# 0
C36603 _059_ _648_/a_1840_334# 0
C36604 net79 _673_/a_1583_191# 0
C36605 _677_/a_741_93# _089_ 0.00112f
C36606 output22/a_40_152# VPWR 0.01735f
C36607 _262_ _161_ 0.01683f
C36608 _062_ net29 0.00162f
C36609 VPWR _689_/a_298_337# 0.00478f
C36610 net13 net78 0
C36611 hold158/a_326_118# _101_ 0.01079f
C36612 hold111/a_326_118# VPWR 0.00685f
C36613 _696_/a_843_236# _025_ 0.02863f
C36614 fanout30/a_40_152# net62 0
C36615 FILLER_17_199/a_40_246# _647_/a_843_236# 0
C36616 _178_ hold114/a_56_118# 0
C36617 FILLER_3_207/a_40_246# _664_/a_1583_191# 0.00247f
C36618 _360_/a_1377_160# _656_/a_1583_191# 0
C36619 tx_inst.bit_index\[1\] _656_/a_298_337# 0
C36620 _363_/a_22_110# net34 0.02657f
C36621 _031_ _027_ 0
C36622 hold55/a_326_118# _665_/a_843_236# 0
C36623 hold55/a_438_182# _665_/a_741_93# 0
C36624 net34 _007_ 0.00199f
C36625 clknet_0_clk net24 0.01881f
C36626 clkbuf_4_10_0_clk/a_27_118# _308_ 0
C36627 _637_/a_324_432# _266_ 0
C36628 _637_/a_741_93# net30 0
C36629 net145 _147_ 0.01576f
C36630 FILLER_12_171/a_40_246# FILLER_12_173/a_32_246# 0.0524f
C36631 net15 clknet_4_13_0_clk -0
C36632 hold55/a_326_118# _166_ 0
C36633 net57 _216_ 0
C36634 _281_ net29 0.21119f
C36635 _135_ net48 0
C36636 _097_ net40 0.03722f
C36637 clknet_4_6_0_clk rx_inst.state\[1\] 0.00508f
C36638 _658_/a_324_432# net171 0
C36639 net170 _150_ 0.00777f
C36640 _660_/a_38_114# _144_ 0
C36641 clknet_4_5_0_clk _654_/a_298_337# 0.00175f
C36642 _658_/a_298_337# _148_ 0
C36643 _660_/a_324_432# _065_ 0
C36644 net51 _671_/a_324_432# 0.00106f
C36645 net58 net46 0
C36646 _141_ net43 0
C36647 hold173/a_438_182# _222_ 0
C36648 hold173/a_326_118# _141_ 0
C36649 _256_ _242_ 0
C36650 _226_ _411_/a_494_160# 0
C36651 clknet_4_5_0_clk _664_/a_843_236# 0.01324f
C36652 _175_ hold174/a_438_182# 0
C36653 tx_inst.state\[1\] _705_/a_298_337# 0.00108f
C36654 clknet_4_7_0_clk _705_/a_38_114# 0.00145f
C36655 net16 _650_/a_2250_412# 0
C36656 rx_data[4] _650_/a_1840_334# 0
C36657 net176 baud_inst.counter\[25\] 0.14537f
C36658 rx_inst.state\[3\] _161_ 0
C36659 _124_ rx_inst.data_reg\[5\] 0.0024f
C36660 FILLER_4_183/a_40_246# clknet_4_4_0_clk 0.00392f
C36661 hold164/a_56_118# net164 0
C36662 hold183/a_438_182# tx_inst.bit_index\[1\] 0.00104f
C36663 net31 _372_/a_22_110# 0
C36664 baud_inst.counter\[3\] net86 0
C36665 hold136/a_438_182# _674_/a_741_93# 0
C36666 _690_/a_38_114# VPWR 0.00425f
C36667 _633_/a_2002_114# net30 0
C36668 net49 _434_/a_252_412# 0
C36669 FILLER_18_65/a_40_246# VPWR 0.15122f
C36670 net37 FILLER_15_162/a_40_246# 0
C36671 _642_/a_843_236# _053_ 0
C36672 _642_/a_741_93# _132_ 0.02214f
C36673 _642_/a_324_432# clknet_4_12_0_clk 0.00763f
C36674 _549_/a_257_140# _312_ 0
C36675 clknet_4_11_0_clk _546_/a_192_429# 0
C36676 clknet_4_5_0_clk net21 0.69446f
C36677 baud_inst.counter\[30\] _700_/a_2250_412# 0.00325f
C36678 _160_ clkbuf_4_15_0_clk/a_27_118# 0
C36679 tx_inst.data_reg\[7\] _151_ 0
C36680 _181_ _504_/a_209_168# 0.01515f
C36681 net152 _162_ 0
C36682 rx_inst.data_reg\[1\] _170_ 0
C36683 clkbuf_4_11_0_clk/a_27_118# _698_/a_1583_191# 0.004f
C36684 net182 _281_ 0.01055f
C36685 _662_/a_298_337# _706_/a_298_337# 0
C36686 _223_ _000_ 0.00108f
C36687 net60 hold60/a_326_118# 0.01939f
C36688 _181_ hold60/a_56_118# 0.05404f
C36689 net121 _023_ 0.3697f
C36690 _155_ _648_/a_1840_334# 0
C36691 net124 _648_/a_2250_412# 0.01383f
C36692 net94 _282_ 0
C36693 net92 baud_inst.counter\[4\] 0.00242f
C36694 _283_ net152 1.9218f
C36695 _697_/a_324_432# VPWR 0
C36696 hold56/a_438_182# _651_/a_741_93# 0.0011f
C36697 hold56/a_326_118# _651_/a_843_236# 0.00222f
C36698 _485_/a_120_432# _003_ -0
C36699 _105_ _104_ 0
C36700 net6 _181_ 0
C36701 FILLER_21_175/a_32_246# _257_ 0.00151f
C36702 VPWR FILLER_8_21/a_32_246# 0.07084f
C36703 _177_ _551_/a_76_160# 0
C36704 fanout24/a_40_152# _242_ 0
C36705 _013_ hold91/a_438_182# 0.00211f
C36706 net35 _228_ 0
C36707 _223_ _647_/a_38_114# 0
C36708 _643_/a_741_93# clkbuf_4_15_0_clk/a_27_118# 0.004f
C36709 _641_/a_1583_191# _130_ 0
C36710 _641_/a_2250_412# net52 0
C36711 net38 _085_ 0.04958f
C36712 FILLER_21_192/a_40_246# _160_ 0.0047f
C36713 FILLER_21_96/a_40_246# baud_inst.counter\[25\] 0
C36714 _216_ _400_/a_341_118# 0.01204f
C36715 net33 rx 0
C36716 hold121/a_56_118# _695_/a_38_114# 0.00684f
C36717 hold135/a_56_118# _181_ 0
C36718 _283_ _498_/a_165_412# 0.00209f
C36719 _089_ _676_/a_1840_334# -0
C36720 baud_inst.counter\[14\] hold91/a_438_182# 0
C36721 _129_ _264_ 0
C36722 net87 clkbuf_4_8_0_clk/a_27_118# 0.00537f
C36723 FILLER_22_118/a_32_246# net100 0
C36724 tx_inst.bit_index\[0\] _166_ 0.13955f
C36725 hold56/a_438_182# _007_ 0
C36726 hold58/a_56_118# _703_/a_324_432# 0
C36727 _240_ _000_ 0
C36728 net79 net40 0.02305f
C36729 clknet_4_11_0_clk _700_/a_1583_191# 0.02087f
C36730 _230_ _002_ 0
C36731 hold102/a_56_118# baud_inst.counter\[16\] 0.00181f
C36732 net34 _341_/a_1453_124# 0.00288f
C36733 fanout39/a_40_152# _689_/a_298_337# 0
C36734 _670_/a_2250_412# net29 0.00147f
C36735 _047_ hold73/a_326_118# 0.01048f
C36736 tx _705_/a_1489_191# 0
C36737 hold118/a_326_118# net19 0.00252f
C36738 _655_/a_550_127# net181 0
C36739 _657_/a_298_337# net41 0.02034f
C36740 clknet_4_0_0_clk _681_/a_1785_429# 0.00162f
C36741 _483_/a_22_110# _169_ 0.00243f
C36742 _643_/a_741_93# FILLER_21_192/a_40_246# 0.0029f
C36743 _689_/a_1489_191# _101_ 0
C36744 _189_ _684_/a_843_236# 0.04155f
C36745 _177_ clkbuf_4_10_0_clk/a_27_118# 0.06126f
C36746 _691_/a_324_432# _690_/a_843_236# 0
C36747 _691_/a_741_93# _690_/a_741_93# 0.00126f
C36748 _240_ _647_/a_38_114# 0.00212f
C36749 net71 _267_ 0.01802f
C36750 hold111/a_326_118# _266_ 0.00497f
C36751 hold111/a_438_182# net30 0.00131f
C36752 _405_/a_27_156# _404_/a_46_156# 0.00249f
C36753 _227_ _408_/a_154_118# 0
C36754 _678_/a_612_127# clknet_4_1_0_clk 0
C36755 _109_ clknet_0_clk 0.00183f
C36756 FILLER_17_94/a_40_246# VPWR 0.13387f
C36757 tx_inst.data_reg\[7\] hold145/a_438_182# 0.0586f
C36758 _339_/a_1377_160# FILLER_7_146/a_32_246# 0
C36759 hold123/a_438_182# baud_inst.counter\[4\] 0.00322f
C36760 _667_/a_741_93# _667_/a_1489_191# 0
C36761 hold150/a_56_118# net78 0
C36762 hold140/a_56_118# _698_/a_324_432# 0
C36763 net173 hold57/a_326_118# 0
C36764 hold88/a_56_118# net29 0
C36765 clk _658_/a_1489_191# 0
C36766 net44 VPWR 1.64517f
C36767 _678_/a_324_432# _090_ 0
C36768 baud_inst.counter\[26\] _697_/a_1785_429# 0
C36769 _277_ _140_ 0.00287f
C36770 _109_ _517_/a_474_130# 0
C36771 baud_inst.counter\[23\] _296_ 0.00317f
C36772 net32 net127 0
C36773 hold171/a_438_182# VPWR 0.00586f
C36774 _685_/a_2250_412# net91 0
C36775 _125_ _269_ 0.04974f
C36776 net178 FILLER_12_42/a_32_246# 0
C36777 _100_ _296_ 0.0919f
C36778 clknet_4_14_0_clk _272_ 0.2156f
C36779 _637_/a_2250_412# VPWR 0.00203f
C36780 _697_/a_298_337# net162 0
C36781 FILLER_7_40/a_32_246# VPWR 0.07814f
C36782 clknet_4_5_0_clk _376_/a_76_160# 0.00163f
C36783 _292_ _684_/a_1840_334# 0
C36784 hold156/a_326_118# _188_ 0
C36785 net156 _356_/a_146_122# 0
C36786 net85 net66 0.00217f
C36787 rx_inst.state\[3\] FILLER_11_142/a_40_246# 0.00538f
C36788 _027_ net46 0.07567f
C36789 _461_/a_22_110# clknet_4_15_0_clk 0
C36790 net116 net40 0
C36791 baud_inst.counter\[17\] _688_/a_1583_191# 0.05655f
C36792 _448_/a_244_412# _223_ 0.00125f
C36793 _675_/a_1489_191# net38 0.02024f
C36794 _706_/a_132_114# _201_ 0
C36795 rx_data[4] _639_/a_38_114# 0
C36796 _118_ _704_/a_38_114# 0
C36797 net58 _313_ 0.00337f
C36798 hold65/a_326_118# net71 0
C36799 net47 _633_/a_38_114# 0
C36800 hold86/a_438_182# net86 0.02141f
C36801 hold157/a_326_118# net160 0.01285f
C36802 hold157/a_56_118# _296_ 0.00885f
C36803 hold114/a_438_182# VPWR 0.00763f
C36804 _482_/a_154_118# _140_ 0
C36805 FILLER_18_158/a_40_246# VPWR 0.12625f
C36806 clknet_4_8_0_clk _687_/a_1583_191# 0.0335f
C36807 net51 _704_/a_612_127# 0
C36808 _517_/a_380_412# VPWR 0
C36809 _270_ _156_ 0.05737f
C36810 clknet_4_1_0_clk _037_ 0.00211f
C36811 _225_ _407_/a_248_122# 0.00433f
C36812 net84 _635_/a_1489_191# 0.00214f
C36813 _657_/a_741_93# _070_ 0
C36814 FILLER_5_207/a_32_246# _664_/a_1840_334# 0
C36815 net97 _508_/a_177_436# 0
C36816 rx_inst.bit_index\[1\] _425_/a_46_156# 0.00727f
C36817 FILLER_0_42/a_32_246# _085_ 0.00406f
C36818 _500_/a_257_140# _285_ 0
C36819 hold153/a_438_182# clknet_0_clk 0
C36820 _667_/a_324_432# FILLER_10_145/a_40_246# 0
C36821 net63 net29 0
C36822 _129_ _639_/a_2250_412# 0.00782f
C36823 _265_ _639_/a_1785_429# 0.00105f
C36824 net167 baud_inst.counter\[13\] 0.00212f
C36825 net40 _682_/a_132_114# 0
C36826 hold99/a_56_118# _697_/a_1840_334# 0
C36827 _488_/a_380_412# net6 0
C36828 net43 tx_inst.state\[2\] 0
C36829 clknet_0_clk hold93/a_56_118# 0.00215f
C36830 rx_data[7] hold118/a_56_118# 0.00277f
C36831 _246_ clkbuf_4_12_0_clk/a_27_118# 0
C36832 clknet_4_3_0_clk _652_/a_2250_412# 0
C36833 FILLER_10_147/a_32_246# FILLER_10_145/a_40_246# 0.0524f
C36834 _527_/a_155_160# net160 0
C36835 _527_/a_435_412# _296_ 0
C36836 _234_ _409_/a_73_118# 0
C36837 _483_/a_22_110# _084_ 0
C36838 _646_/a_1840_334# _058_ 0
C36839 _175_ _206_ 0
C36840 clknet_4_5_0_clk FILLER_2_208/a_40_246# 0
C36841 tx_inst.bit_index\[2\] _379_/a_46_156# 0
C36842 hold54/a_326_118# net33 0.06485f
C36843 hold152/a_56_118# _280_ 0
C36844 net42 _667_/a_2002_114# 0
C36845 _275_ _366_/a_170_412# 0
C36846 _155_ hold70/a_438_182# 0
C36847 _384_/a_382_118# _209_ 0
C36848 net172 _665_/a_612_127# 0
C36849 _248_ _234_ 0
C36850 _217_ _171_ 0
C36851 net98 net117 0
C36852 _460_/a_22_110# net118 0
C36853 hold166/a_326_118# VPWR 0.0084f
C36854 _460_/a_120_432# _153_ 0.00425f
C36855 _144_ _664_/a_298_337# 0
C36856 _053_ FILLER_19_118/a_32_246# 0.00138f
C36857 hold173/a_56_118# clkbuf_4_4_0_clk/a_27_118# 0.00214f
C36858 hold128/a_56_118# _034_ 0.00157f
C36859 net80 hold73/a_56_118# 0
C36860 hold131/a_438_182# net150 0
C36861 _028_ _313_ 0.02402f
C36862 _673_/a_1583_191# _672_/a_741_93# 0.00112f
C36863 _673_/a_741_93# _672_/a_1583_191# 0
C36864 baud_inst.counter\[6\] hold92/a_438_182# 0.0021f
C36865 hold97/a_438_182# baud_inst.counter\[8\] 0
C36866 net122 _667_/a_612_127# 0.00365f
C36867 net123 clknet_4_9_0_clk 0.02209f
C36868 _668_/a_1583_191# rx_inst.state\[1\] 0.00115f
C36869 net37 _667_/a_1785_429# 0
C36870 _664_/a_843_236# _005_ 0
C36871 _664_/a_324_432# tx_inst.state\[2\] 0.00246f
C36872 _170_ FILLER_19_178/a_40_246# 0.00387f
C36873 FILLER_0_161/a_40_246# tx_data[6] 0.003f
C36874 _655_/a_843_236# net38 0
C36875 _652_/a_324_432# baud_inst.counter\[5\] 0.00193f
C36876 _346_/a_354_412# baud_inst.counter\[28\] 0.00285f
C36877 _346_/a_252_412# baud_inst.counter\[31\] 0.00183f
C36878 clknet_4_12_0_clk _259_ 0
C36879 baud_inst.counter\[31\] _347_/a_146_122# 0
C36880 baud_inst.counter\[28\] _347_/a_248_122# 0
C36881 net2 _669_/a_1840_334# 0
C36882 _339_/a_810_118# clknet_0_clk 0
C36883 _143_ _652_/a_741_93# 0
C36884 VPWR _685_/a_1583_191# 0.0066f
C36885 hold124/a_56_118# _264_ 0
C36886 _206_ net165 0.0103f
C36887 _390_/a_59_156# _385_/a_46_156# 0
C36888 net50 _203_ 0
C36889 _009_ hold109/a_326_118# 0
C36890 hold87/a_56_118# _180_ 0.01258f
C36891 _657_/a_843_236# clknet_4_1_0_clk 0.01977f
C36892 VPWR _689_/a_1583_191# 0.03521f
C36893 _405_/a_27_156# net62 0.00528f
C36894 _499_/a_380_412# _182_ 0
C36895 _696_/a_1489_191# net141 0.00691f
C36896 _442_/a_146_122# net52 0
C36897 _552_/a_257_140# _028_ 0
C36898 _315_ _550_/a_380_412# 0
C36899 _360_/a_589_385# _067_ 0
C36900 tx_inst.bit_index\[1\] _656_/a_1583_191# 0
C36901 _360_/a_805_385# tx_inst.data_reg\[2\] 0
C36902 _194_ _175_ 0
C36903 _507_/a_170_412# _039_ 0.00169f
C36904 hold153/a_438_182# _182_ 0
C36905 net42 _083_ 0
C36906 hold74/a_56_118# _240_ 0
C36907 _646_/a_681_505# net48 0
C36908 _551_/a_76_160# VPWR 0.0099f
C36909 baud_inst.counter\[20\] _694_/a_741_93# 0.00485f
C36910 _182_ hold93/a_56_118# 0
C36911 net54 _664_/a_1840_334# 0
C36912 net60 _349_/a_146_122# 0.00489f
C36913 _142_ FILLER_10_145/a_40_246# 0.00196f
C36914 hold109/a_438_182# clknet_4_2_0_clk 0.00995f
C36915 net84 hold84/a_326_118# 0.00765f
C36916 clknet_4_11_0_clk hold58/a_326_118# 0.04608f
C36917 clknet_4_12_0_clk _157_ 0.15795f
C36918 baud_inst.counter\[19\] baud_inst.counter\[15\] 0
C36919 clknet_4_5_0_clk _654_/a_1583_191# 0.00319f
C36920 _660_/a_132_114# tx_inst.data_reg\[0\] 0
C36921 _660_/a_1840_334# _144_ 0.01843f
C36922 _660_/a_2250_412# _065_ 0.05461f
C36923 net42 FILLER_10_145/a_40_246# 0.00932f
C36924 net23 rx 0.01874f
C36925 net51 _671_/a_2250_412# 0
C36926 net36 _227_ 0
C36927 _641_/a_324_432# clknet_0_clk 0.01029f
C36928 _493_/a_45_160# _281_ 0.00102f
C36929 hold118/a_326_118# _636_/a_1583_191# 0
C36930 hold118/a_56_118# _636_/a_1840_334# 0
C36931 clknet_4_5_0_clk _664_/a_612_127# 0.02069f
C36932 clknet_4_7_0_clk _705_/a_1840_334# 0
C36933 hold140/a_56_118# _025_ 0
C36934 _062_ net122 0
C36935 FILLER_15_17/a_40_246# _690_/a_741_93# 0.00392f
C36936 net30 clknet_0_clk 0.01729f
C36937 clknet_4_11_0_clk clknet_4_8_0_clk 0
C36938 hold170/a_56_118# _660_/a_741_93# 0.00212f
C36939 hold170/a_326_118# _660_/a_324_432# 0
C36940 _197_ _664_/a_324_432# 0
C36941 net151 FILLER_25_141/a_32_246# 0
C36942 _302_ VPWR 0.80703f
C36943 _074_ _706_/a_1489_191# 0
C36944 _039_ _682_/a_324_432# 0
C36945 net116 _682_/a_741_93# 0
C36946 _288_ _682_/a_843_236# 0.00663f
C36947 _690_/a_1840_334# VPWR 0.02688f
C36948 _246_ net32 0.45435f
C36949 _680_/a_1583_191# hold116/a_326_118# 0
C36950 _680_/a_1840_334# hold116/a_56_118# 0
C36951 _117_ FILLER_10_222/a_32_246# 0.00138f
C36952 net106 _694_/a_1489_191# 0
C36953 FILLER_3_207/a_40_246# net54 0.00307f
C36954 net42 fanout37/a_40_152# 0
C36955 _678_/a_324_432# _677_/a_298_337# 0
C36956 net31 _140_ 0
C36957 net16 _465_/a_120_432# 0
C36958 _642_/a_612_127# _053_ 0
C36959 _642_/a_1785_429# _132_ 0
C36960 _642_/a_2250_412# clknet_4_12_0_clk 0.00393f
C36961 clknet_0_clk _647_/a_324_432# 0.00142f
C36962 _691_/a_324_432# _692_/a_324_432# 0
C36963 hold107/a_326_118# _701_/a_298_337# 0
C36964 _027_ _313_ 0.06972f
C36965 clkbuf_4_10_0_clk/a_27_118# VPWR 0.0324f
C36966 _680_/a_2002_114# net181 0
C36967 _181_ _287_ 0.88628f
C36968 net156 _016_ 0.05635f
C36969 net49 FILLER_26_151/a_32_246# 0.00403f
C36970 net35 _434_/a_150_412# 0
C36971 net69 hold71/a_438_182# 0.00358f
C36972 _635_/a_1583_191# _635_/a_2250_412# -0
C36973 hold85/a_438_182# net85 0
C36974 net85 _635_/a_132_114# 0
C36975 _662_/a_741_93# _706_/a_843_236# 0
C36976 _662_/a_843_236# _706_/a_741_93# 0.00237f
C36977 net55 _384_/a_559_412# 0.00228f
C36978 _341_/a_382_118# net168 0
C36979 fanout40/a_40_152# baud_inst.counter\[15\] 0
C36980 net16 _264_ 0.12892f
C36981 _225_ FILLER_18_158/a_40_246# 0
C36982 _138_ _158_ 0.00589f
C36983 _697_/a_2250_412# VPWR 0.00548f
C36984 clknet_4_14_0_clk _648_/a_298_337# 0.04735f
C36985 _680_/a_1583_191# net181 0
C36986 _114_ _112_ 0
C36987 rx_inst.data_reg\[0\] _638_/a_324_432# 0
C36988 tx_inst.bit_index\[0\] _651_/a_1583_191# 0.00868f
C36989 FILLER_7_82/a_32_246# VPWR 0.07834f
C36990 baud_inst.counter\[21\] _693_/a_1583_191# 0.00162f
C36991 net27 _220_ 0
C36992 hold108/a_438_182# VPWR 0.00419f
C36993 _103_ FILLER_17_0/a_40_246# 0.00355f
C36994 _232_ _158_ 0.02053f
C36995 _659_/a_1840_334# _339_/a_71_118# 0
C36996 clknet_4_4_0_clk _653_/a_843_236# 0.00602f
C36997 _035_ _162_ 0.00113f
C36998 output20/a_40_152# rx 0.00407f
C36999 net20 input2/a_40_152# 0.00407f
C37000 hold182/a_438_182# net39 0.00475f
C37001 _269_ _129_ 0.00372f
C37002 FILLER_19_178/a_40_246# hold139/a_438_182# 0
C37003 _339_/a_382_118# net43 0.0022f
C37004 tx_inst.data_reg\[4\] tx_inst.data_reg\[6\] 0.61656f
C37005 _233_ _248_ 0
C37006 _054_ FILLER_23_186/a_40_246# 0.00131f
C37007 net31 net49 0.12487f
C37008 _660_/a_324_432# VPWR 0.0196f
C37009 _283_ _035_ 0.12325f
C37010 _048_ FILLER_27_210/a_40_246# 0
C37011 tx_inst.bit_index\[2\] tx_inst.data_reg\[3\] 0.00662f
C37012 _083_ _670_/a_298_337# 0.02411f
C37013 clknet_4_11_0_clk _700_/a_2002_114# 0
C37014 _394_/a_120_432# net168 0
C37015 _394_/a_22_110# net172 0
C37016 net2 net22 0.00255f
C37017 _494_/a_165_412# net29 0.00339f
C37018 _374_/a_244_140# net51 0
C37019 net21 _199_ 0
C37020 net34 _341_/a_1377_160# 0.00426f
C37021 baud_inst.counter\[28\] _703_/a_298_337# 0.00248f
C37022 net79 _672_/a_298_337# 0.00216f
C37023 net152 clkbuf_4_3_0_clk/a_27_118# 0
C37024 VPWR _700_/a_741_93# 0.01401f
C37025 _661_/a_324_432# clknet_4_1_0_clk 0.039f
C37026 _673_/a_550_127# clknet_4_1_0_clk 0
C37027 tx net22 0.03812f
C37028 _097_ _519_/a_81_118# 0
C37029 _145_ net86 0
C37030 _657_/a_1583_191# net41 0.00291f
C37031 _518_/a_45_160# baud_inst.counter\[16\] 0
C37032 net26 FILLER_15_116/a_40_246# 0
C37033 _691_/a_324_432# _018_ 0
C37034 _691_/a_843_236# _164_ 0
C37035 net55 clkbuf_4_1_0_clk/a_27_118# 0
C37036 baud_inst.counter\[17\] _101_ 0.03932f
C37037 _189_ _684_/a_612_127# 0.00715f
C37038 _240_ _647_/a_1840_334# 0.00437f
C37039 _489_/a_358_436# _093_ 0
C37040 _270_ hold138/a_438_182# 0
C37041 hold141/a_438_182# VPWR 0.00369f
C37042 _224_ _404_/a_268_412# 0.00106f
C37043 _230_ _434_/a_354_412# 0.00325f
C37044 FILLER_8_238/a_32_246# tx_inst.state\[3\] 0
C37045 FILLER_16_70/a_40_246# _180_ 0.00113f
C37046 _667_/a_681_505# net63 0
C37047 VPWR hold82/a_326_118# 0.0042f
C37048 output19/a_40_152# VPWR 0.00483f
C37049 _267_ _273_ 0.01875f
C37050 _093_ _681_/a_741_93# 0.00198f
C37051 net56 _222_ 0.03642f
C37052 baud_inst.counter\[15\] _297_ 0
C37053 _678_/a_2250_412# _090_ 0
C37054 _041_ _234_ 0
C37055 baud_inst.counter\[26\] _110_ 0
C37056 _657_/a_681_505# _068_ 0
C37057 hold158/a_438_182# VPWR 0.00632f
C37058 net37 _670_/a_1840_334# 0
C37059 _017_ net49 0
C37060 net133 _700_/a_38_114# 0.06495f
C37061 net120 fanout45/a_40_152# 0
C37062 rx_inst.data_reg\[0\] net126 0.00314f
C37063 _378_/a_59_156# _381_/a_46_156# 0
C37064 net182 _494_/a_165_412# 0
C37065 fanout31/a_40_152# _224_ 0.05332f
C37066 hold106/a_56_118# VPWR 0.00616f
C37067 net49 _440_/a_550_140# 0
C37068 clknet_4_4_0_clk _652_/a_1840_334# 0
C37069 net156 baud_inst.counter\[13\] 0.02798f
C37070 _644_/a_324_432# FILLER_26_151/a_32_246# 0
C37071 _659_/a_1489_191# tx_inst.data_reg\[5\] 0
C37072 net131 _633_/a_324_432# 0.00172f
C37073 _645_/a_843_236# net150 0
C37074 _638_/a_1489_191# clknet_4_15_0_clk 0.00326f
C37075 baud_inst.counter\[17\] _688_/a_2002_114# 0
C37076 _170_ _444_/a_244_140# 0
C37077 baud_inst.counter\[3\] net38 0.00455f
C37078 hold168/a_438_182# _076_ 0.00134f
C37079 _042_ FILLER_2_237/a_40_246# 0.00263f
C37080 _092_ FILLER_8_70/a_32_246# 0
C37081 hold161/a_56_118# baud_inst.counter\[16\] 0.00693f
C37082 _113_ net45 0.16323f
C37083 hold54/a_56_118# net55 0
C37084 _143_ _653_/a_132_114# 0
C37085 _216_ _653_/a_1583_191# 0.00131f
C37086 net47 _633_/a_1840_334# 0
C37087 hold113/a_326_118# clknet_4_8_0_clk 0
C37088 hold165/a_56_118# net54 0
C37089 net45 FILLER_25_25/a_40_246# 0.02865f
C37090 hold65/a_326_118# _273_ 0.00422f
C37091 hold155/a_326_118# VPWR 0.00316f
C37092 clknet_4_8_0_clk _687_/a_2002_114# 0
C37093 _545_/a_350_122# _310_ 0
C37094 FILLER_8_171/a_32_246# hold184/a_326_118# 0
C37095 hold63/a_56_118# clkbuf_0_clk/a_116_82# 0
C37096 baud_inst.counter\[20\] _306_ 0
C37097 FILLER_13_102/a_32_246# clknet_0_clk 0
C37098 _668_/a_38_114# rx_inst.state\[4\] 0.03871f
C37099 hold184/a_438_182# _217_ 0
C37100 hold184/a_326_118# _218_ 0
C37101 _641_/a_1583_191# _262_ 0.00943f
C37102 FILLER_8_35/a_32_246# net116 0.00195f
C37103 net108 _353_/a_146_122# 0
C37104 _061_ _668_/a_324_432# 0
C37105 _031_ net49 0.0014f
C37106 net36 _242_ 0.00565f
C37107 FILLER_13_137/a_32_246# net37 0.00302f
C37108 _265_ _050_ 0.21527f
C37109 _526_/a_350_122# _015_ 0
C37110 hold144/a_438_182# _223_ 0.00333f
C37111 _283_ _286_ 0
C37112 net67 _702_/a_741_93# 0.02995f
C37113 _223_ _417_/a_22_110# 0.00106f
C37114 hold141/a_56_118# net162 0
C37115 net155 _658_/a_324_432# 0
C37116 _206_ _658_/a_741_93# 0
C37117 _180_ baud_inst.counter\[13\] 0.02496f
C37118 _674_/a_681_505# clknet_4_0_0_clk 0.00115f
C37119 baud_inst.counter\[2\] _672_/a_843_236# 0
C37120 _376_/a_76_160# _199_ 0
C37121 _060_ FILLER_23_186/a_40_246# 0.02695f
C37122 _042_ FILLER_1_237/a_40_246# 0
C37123 hold102/a_438_182# net157 0
C37124 net44 _691_/a_550_127# 0
C37125 _636_/a_843_236# VPWR 0.0024f
C37126 _632_/a_681_505# _264_ 0
C37127 _654_/a_38_114# tx_inst.data_reg\[0\] 0
C37128 _654_/a_843_236# _065_ 0.00345f
C37129 net173 _360_/a_1453_124# 0
C37130 _095_ net117 0
C37131 _129_ _153_ 0.05234f
C37132 net122 net63 0.05441f
C37133 _664_/a_2250_412# tx_inst.state\[2\] 0.0169f
C37134 _183_ _505_/a_76_160# 0.02005f
C37135 net87 _684_/a_741_93# 0
C37136 _643_/a_843_236# _240_ 0
C37137 FILLER_20_106/a_32_246# clknet_0_clk 0.00101f
C37138 _678_/a_132_114# baud_inst.counter\[6\] 0
C37139 _486_/a_115_308# hold166/a_438_182# 0.00727f
C37140 net12 hold69/a_56_118# 0.06317f
C37141 hold144/a_438_182# _240_ 0
C37142 _422_/a_248_122# _140_ 0
C37143 _230_ FILLER_17_131/a_32_246# 0
C37144 _240_ _417_/a_22_110# 0.00409f
C37145 baud_inst.counter\[31\] baud_inst.counter\[30\] 0.12599f
C37146 baud_inst.counter\[28\] _179_ 0.0276f
C37147 hold66/a_326_118# _264_ 0.00185f
C37148 _663_/a_324_432# _666_/a_1840_334# 0
C37149 _663_/a_741_93# _666_/a_1583_191# 0.00408f
C37150 _686_/a_132_114# net91 0
C37151 baud_inst.counter\[23\] net75 0.12595f
C37152 baud_inst.counter\[21\] _023_ 0.0793f
C37153 output19/a_40_152# _266_ 0.00141f
C37154 _024_ _543_/a_248_122# 0
C37155 _032_ _551_/a_170_160# 0
C37156 _264_ _648_/a_324_432# 0.03399f
C37157 hold148/a_326_118# VPWR 0.00405f
C37158 _657_/a_612_127# clknet_4_1_0_clk 0
C37159 net42 clkbuf_4_6_0_clk/a_27_118# 0.02384f
C37160 VPWR _689_/a_2002_114# 0.00129f
C37161 _180_ _544_/a_46_156# 0.00715f
C37162 FILLER_16_166/a_32_246# net25 0
C37163 _659_/a_741_93# VPWR 0.01221f
C37164 net27 _479_/a_22_110# 0.02072f
C37165 hold173/a_56_118# VPWR 0.03283f
C37166 _360_/a_308_118# tx_inst.data_reg\[2\] 0
C37167 _360_/a_500_118# clknet_4_4_0_clk 0
C37168 net34 _195_ 0.31685f
C37169 _233_ _041_ 0
C37170 clknet_4_1_0_clk tx_data[7] 0
C37171 _663_/a_1489_191# clkbuf_4_7_0_clk/a_27_118# 0
C37172 FILLER_13_102/a_32_246# _685_/a_1840_334# 0
C37173 _048_ net30 0.00165f
C37174 _301_ _014_ 0
C37175 baud_inst.counter\[15\] net162 0
C37176 _110_ _109_ 0
C37177 _641_/a_2250_412# clknet_0_clk 0.00299f
C37178 _698_/a_324_432# baud_inst.counter\[25\] 0
C37179 _698_/a_843_236# net99 0
C37180 hold184/a_56_118# tx_inst.bit_index\[2\] 0.02909f
C37181 clknet_4_5_0_clk _005_ 0.0614f
C37182 VPWR hold81/a_438_182# 0.002f
C37183 _634_/a_324_432# clknet_4_15_0_clk 0.04652f
C37184 tx_inst.data_reg\[1\] _385_/a_46_156# 0
C37185 VPWR _664_/a_38_114# 0.02616f
C37186 _092_ _183_ 0
C37187 _222_ _476_/a_248_122# 0
C37188 _058_ _647_/a_298_337# 0.01207f
C37189 _707_/a_741_93# VPWR 0.00623f
C37190 _114_ _535_/a_350_122# 0
C37191 net55 _665_/a_298_337# 0.01105f
C37192 VPWR _436_/a_244_140# 0
C37193 baud_inst.counter\[22\] _701_/a_38_114# 0.00929f
C37194 hold86/a_326_118# _085_ 0
C37195 hold86/a_438_182# net38 0.00181f
C37196 _074_ _042_ 0
C37197 _288_ _682_/a_612_127# 0
C37198 baud_inst.counter\[13\] baud_inst.counter\[11\] 0
C37199 _292_ FILLER_9_70/a_40_246# 0
C37200 FILLER_15_162/a_40_246# net26 0.0029f
C37201 net105 net133 0.00489f
C37202 net115 _505_/a_76_160# 0.00788f
C37203 _553_/a_170_412# net106 0
C37204 _678_/a_1583_191# _677_/a_324_432# 0
C37205 net42 _276_ 0
C37206 rx_data[4] net73 0.00726f
C37207 net16 _269_ 0.61614f
C37208 _691_/a_298_337# _692_/a_612_127# 0
C37209 _691_/a_843_236# _692_/a_1583_191# 0
C37210 _053_ _132_ 0.11163f
C37211 clknet_0_clk _647_/a_2250_412# 0.00294f
C37212 _691_/a_741_93# _692_/a_1840_334# 0
C37213 _536_/a_192_429# _105_ 0
C37214 _158_ _634_/a_324_432# 0
C37215 VPWR FILLER_6_98/a_40_246# 0.16079f
C37216 hold154/a_56_118# _034_ 0
C37217 FILLER_15_162/a_40_246# net32 0.02118f
C37218 net14 _634_/a_38_114# 0
C37219 output14/a_40_152# _634_/a_843_236# 0
C37220 _345_/a_252_412# clknet_4_10_0_clk 0
C37221 clkbuf_4_15_0_clk/a_27_118# _649_/a_38_114# 0
C37222 _112_ _165_ 0.00183f
C37223 _662_/a_1583_191# _706_/a_1583_191# 0.00198f
C37224 VPWR _546_/a_341_118# 0
C37225 _699_/a_843_236# baud_inst.counter\[29\] 0
C37226 _082_ clkbuf_0_clk/a_116_82# 0
C37227 _042_ _665_/a_1489_191# 0
C37228 _636_/a_843_236# _266_ 0
C37229 clknet_4_14_0_clk _648_/a_1583_191# 0
C37230 rx_inst.state\[2\] net25 0.07389f
C37231 VPWR _387_/a_268_412# 0
C37232 hold171/a_56_118# clk 0
C37233 _672_/a_2250_412# _086_ 0
C37234 _682_/a_741_93# _682_/a_1489_191# 0
C37235 _682_/a_1583_191# _682_/a_2250_412# -0
C37236 tx_inst.bit_index\[0\] _651_/a_2002_114# 0
C37237 hold56/a_56_118# clknet_4_6_0_clk 0.0025f
C37238 _642_/a_843_236# VPWR 0.00553f
C37239 hold151/a_326_118# _161_ 0
C37240 _305_ _694_/a_1583_191# 0
C37241 hold162/a_438_182# baud_inst.counter\[25\] 0
C37242 net33 _665_/a_1840_334# 0.02441f
C37243 _058_ fanout30/a_40_152# 0
C37244 _168_ _235_ 0
C37245 net62 _140_ 0
C37246 clknet_4_4_0_clk _653_/a_612_127# 0.0025f
C37247 _294_ _100_ 0
C37248 _444_/a_142_412# _242_ 0
C37249 hold130/a_56_118# VPWR 0.01553f
C37250 _314_ net59 0
C37251 net40 hold94/a_56_118# 0
C37252 _339_/a_810_118# net43 0
C37253 _671_/a_843_236# VPWR 0.01092f
C37254 _529_/a_139_160# _301_ 0.00409f
C37255 net147 net49 0.17551f
C37256 _705_/a_324_432# tx_inst.state\[3\] 0
C37257 net42 hold62/a_438_182# 0
C37258 hold131/a_438_182# _158_ 0.00664f
C37259 net49 net46 0.3021f
C37260 _660_/a_2250_412# VPWR 0.00462f
C37261 hold56/a_438_182# _195_ 0
C37262 hold56/a_326_118# _217_ 0
C37263 net34 _401_/a_22_110# 0.00562f
C37264 hold182/a_438_182# _676_/a_843_236# 0
C37265 net75 FILLER_21_33/a_32_246# 0.0013f
C37266 _637_/a_38_114# _634_/a_741_93# 0
C37267 _637_/a_324_432# _634_/a_324_432# 0
C37268 _646_/a_1489_191# _157_ 0.01825f
C37269 _083_ _670_/a_1583_191# 0
C37270 _187_ FILLER_15_42/a_40_246# 0.00341f
C37271 VPWR _686_/a_843_236# 0.00106f
C37272 baud_inst.counter\[20\] _114_ 0.06789f
C37273 net65 _649_/a_1489_191# 0.00112f
C37274 _249_ _435_/a_166_436# 0.00202f
C37275 rx_data[2] net47 0
C37276 _341_/a_71_118# _658_/a_2250_412# 0
C37277 clkbuf_0_clk/a_116_82# clknet_0_clk 0.00906f
C37278 rx_inst.bit_index\[2\] _426_/a_154_118# 0
C37279 _652_/a_324_432# _182_ 0
C37280 net39 _682_/a_298_337# 0.00318f
C37281 _092_ net115 0
C37282 baud_inst.counter\[28\] _703_/a_1583_191# 0
C37283 baud_inst.counter\[30\] _703_/a_681_505# 0
C37284 net3 _388_/a_382_118# 0
C37285 _008_ _672_/a_132_114# 0
C37286 net79 _672_/a_1583_191# 0.01301f
C37287 _661_/a_38_114# _072_ 0.00654f
C37288 hold97/a_56_118# hold116/a_326_118# 0.00352f
C37289 hold97/a_326_118# hold116/a_56_118# 0.00352f
C37290 FILLER_15_185/a_32_246# net119 0.02803f
C37291 _177_ _347_/a_146_122# 0
C37292 hold117/a_56_118# VPWR 0.0334f
C37293 _097_ net128 0
C37294 FILLER_19_77/a_32_246# _541_/a_209_168# 0
C37295 _657_/a_2002_114# net41 0
C37296 tx_inst.data_reg\[4\] _360_/a_805_385# 0
C37297 net37 _650_/a_612_127# 0
C37298 _687_/a_1583_191# _687_/a_2250_412# 0
C37299 net49 net62 0.00332f
C37300 _691_/a_741_93# _103_ 0.00179f
C37301 _691_/a_38_114# clknet_4_8_0_clk 0
C37302 FILLER_21_147/a_40_246# clknet_0_clk 0.00107f
C37303 hold99/a_326_118# clknet_4_9_0_clk 0
C37304 hold179/a_56_118# _654_/a_324_432# 0
C37305 net37 _244_ 0.0301f
C37306 _640_/a_38_114# clknet_4_14_0_clk 0.00107f
C37307 net94 _680_/a_324_432# 0
C37308 clknet_4_8_0_clk _541_/a_209_168# 0.03906f
C37309 _044_ hold78/a_438_182# 0.00452f
C37310 _694_/a_1840_334# _701_/a_324_432# 0
C37311 _699_/a_612_127# _701_/a_2250_412# 0
C37312 _646_/a_741_93# clknet_4_12_0_clk 0.07195f
C37313 hold169/a_326_118# _666_/a_324_432# 0
C37314 hold169/a_438_182# _666_/a_38_114# 0
C37315 _093_ _681_/a_1785_429# 0
C37316 FILLER_28_176/a_32_246# net78 0.02949f
C37317 hold76/a_438_182# baud_inst.counter\[22\] 0.00387f
C37318 hold159/a_438_182# _209_ 0.02104f
C37319 _221_ clknet_0_clk 0
C37320 clknet_4_5_0_clk _199_ 0.07442f
C37321 _657_/a_550_127# _068_ 0
C37322 _657_/a_2250_412# tx_inst.data_reg\[3\] 0.00373f
C37323 _430_/a_170_412# _229_ 0
C37324 rx_inst.bit_index\[1\] _228_ -0
C37325 _635_/a_38_114# _264_ 0
C37326 _378_/a_382_118# _209_ 0.03214f
C37327 net163 _527_/a_155_160# 0
C37328 _423_/a_279_412# clknet_0_clk 0
C37329 hold133/a_56_118# _700_/a_1583_191# 0.00317f
C37330 _178_ _026_ 0
C37331 hold135/a_326_118# FILLER_6_54/a_32_246# 0
C37332 _659_/a_1583_191# tx_inst.data_reg\[1\] 0.03495f
C37333 FILLER_4_100/a_40_246# clknet_0_clk 0.00162f
C37334 _057_ _257_ 0.00226f
C37335 _679_/a_2250_412# _678_/a_38_114# 0
C37336 _522_/a_209_168# _296_ 0.04366f
C37337 fanout26/a_40_152# FILLER_15_127/a_32_246# 0.00624f
C37338 hold166/a_438_182# clkbuf_0_clk/a_116_82# 0.00286f
C37339 _231_ fanout28/a_40_152# 0.00154f
C37340 clknet_4_11_0_clk _703_/a_741_93# 0.06172f
C37341 hold119/a_438_182# _061_ 0.00433f
C37342 hold119/a_326_118# net119 0.02189f
C37343 _426_/a_154_118# _243_ 0
C37344 FILLER_26_88/a_40_246# _702_/a_1583_191# 0
C37345 _462_/a_120_432# net126 0
C37346 _107_ _693_/a_741_93# 0.0041f
C37347 _663_/a_843_236# clknet_0_clk 0.02744f
C37348 net18 clknet_4_15_0_clk 0.0886f
C37349 _499_/a_209_168# _282_ 0.01683f
C37350 _499_/a_380_412# net152 0.00488f
C37351 _643_/a_681_505# clknet_0_clk 0
C37352 _167_ _436_/a_244_140# 0
C37353 output16/a_40_152# clknet_4_13_0_clk 0
C37354 VPWR FILLER_22_32/a_40_246# 0.13892f
C37355 _487_/a_146_122# _275_ 0
C37356 _675_/a_132_114# VPWR 0
C37357 _143_ _653_/a_1489_191# 0.00316f
C37358 hold153/a_438_182# net152 0
C37359 hold153/a_326_118# baud_inst.counter\[4\] 0.00402f
C37360 hold56/a_56_118# net29 0
C37361 _687_/a_741_93# _520_/a_155_412# 0
C37362 _132_ _451_/a_155_412# 0
C37363 FILLER_18_160/a_32_246# net32 0.00379f
C37364 fanout33/a_40_152# _202_ 0
C37365 _688_/a_324_432# net161 0.01169f
C37366 _680_/a_1489_191# net38 0.0102f
C37367 net152 hold93/a_56_118# 0.0064f
C37368 _009_ net40 0
C37369 _241_ _223_ 0.01947f
C37370 _092_ clknet_4_3_0_clk 0.01906f
C37371 _104_ net103 0
C37372 _698_/a_741_93# net140 0
C37373 _641_/a_38_114# net142 0
C37374 _311_ _310_ 0.00831f
C37375 baud_inst.counter\[25\] _025_ 0.01764f
C37376 _642_/a_843_236# _641_/a_741_93# 0
C37377 _642_/a_741_93# _641_/a_843_236# 0
C37378 _660_/a_1840_334# net179 0.00368f
C37379 net45 net1 0.00634f
C37380 _650_/a_324_432# _456_/a_155_412# 0
C37381 _641_/a_1489_191# _131_ 0
C37382 net47 _223_ 0.00384f
C37383 _641_/a_2002_114# _262_ 0
C37384 rx_data[4] net118 0
C37385 net16 _153_ 0.00191f
C37386 _002_ net180 0
C37387 _068_ _070_ 0.61342f
C37388 hold159/a_438_182# _069_ 0
C37389 _680_/a_132_114# net38 0
C37390 _300_ _015_ 0.00548f
C37391 hold128/a_56_118# net46 0.00127f
C37392 _390_/a_496_118# net38 0.00171f
C37393 net67 _702_/a_1785_429# 0.00138f
C37394 _302_ FILLER_22_43/a_40_246# 0
C37395 clknet_4_7_0_clk tx_done 0.00251f
C37396 tx_inst.state\[1\] net23 0.00254f
C37397 _226_ net25 0.32243f
C37398 _699_/a_1583_191# baud_inst.counter\[25\] 0
C37399 _699_/a_2250_412# net99 0
C37400 fanout34/a_40_152# _142_ 0
C37401 _134_ _244_ 0
C37402 _114_ _701_/a_298_337# 0.02164f
C37403 _632_/a_550_127# _264_ 0
C37404 _654_/a_1840_334# tx_inst.data_reg\[0\] 0.00307f
C37405 _654_/a_612_127# _065_ 0
C37406 _241_ _240_ 0
C37407 hold115/a_326_118# VPWR 0.00604f
C37408 hold154/a_438_182# net154 0.00438f
C37409 _679_/a_38_114# net95 0.00617f
C37410 _679_/a_324_432# net29 0.01565f
C37411 FILLER_15_67/a_40_246# _013_ 0
C37412 _642_/a_741_93# _260_ 0
C37413 net18 _637_/a_324_432# 0.00327f
C37414 net70 _637_/a_843_236# 0
C37415 _683_/a_132_114# net29 0
C37416 net42 _676_/a_324_432# 0
C37417 _240_ net47 0
C37418 _673_/a_843_236# baud_inst.counter\[0\] 0
C37419 tx_inst.data_reg\[6\] _654_/a_298_337# 0
C37420 clknet_4_14_0_clk net37 0.01519f
C37421 FILLER_15_67/a_40_246# baud_inst.counter\[14\] 0.00342f
C37422 net2 fanout25/a_40_152# 0
C37423 hold162/a_438_182# baud_inst.counter\[24\] 0.00956f
C37424 hold162/a_56_118# _309_ 0
C37425 _692_/a_1489_191# VPWR 0.00249f
C37426 _379_/a_268_412# net41 0.0011f
C37427 baud_inst.counter\[6\] hold95/a_56_118# 0.00206f
C37428 _678_/a_1489_191# baud_inst.counter\[6\] 0.01382f
C37429 _697_/a_324_432# FILLER_20_95/a_40_246# 0
C37430 clknet_4_7_0_clk net55 0
C37431 net49 _313_ 0.03454f
C37432 hold143/a_56_118# VPWR 0.04473f
C37433 _145_ net38 0.31053f
C37434 rx_inst.state\[3\] _652_/a_1583_191# 0
C37435 net74 _636_/a_298_337# 0.01375f
C37436 _688_/a_1583_191# _508_/a_209_168# 0
C37437 _513_/a_192_429# clkbuf_4_2_0_clk/a_27_118# 0.00267f
C37438 net44 _052_ 0.09493f
C37439 _686_/a_1489_191# net91 0.00119f
C37440 FILLER_19_118/a_32_246# VPWR 0.09555f
C37441 _143_ _063_ 0.00419f
C37442 _032_ _314_ 0
C37443 _378_/a_382_118# _207_ 0.02288f
C37444 _519_/a_81_118# _519_/a_379_118# -0
C37445 _264_ _648_/a_2250_412# 0.00697f
C37446 _643_/a_2250_412# rx_inst.data_reg\[0\] 0
C37447 tx_inst.data_reg\[7\] _657_/a_1583_191# 0.00243f
C37448 _489_/a_115_308# baud_inst.counter\[8\] 0.00292f
C37449 hold88/a_438_182# _519_/a_81_118# 0
C37450 _147_ clknet_4_1_0_clk 0.14765f
C37451 hold160/a_326_118# baud_inst.counter\[18\] 0.00153f
C37452 _181_ net181 0.01985f
C37453 net60 net86 1.09164f
C37454 net30 clkbuf_4_13_0_clk/a_27_118# 0.03629f
C37455 clknet_4_14_0_clk _056_ 0.00689f
C37456 net45 _700_/a_324_432# 0
C37457 net58 hold58/a_56_118# 0
C37458 net54 _144_ 0.01224f
C37459 VPWR _688_/a_298_337# 0.00585f
C37460 baud_inst.counter\[21\] _695_/a_324_432# 0.00136f
C37461 baud_inst.counter\[23\] _695_/a_298_337# 0.01582f
C37462 net13 _463_/a_22_110# 0
C37463 baud_inst.counter\[20\] _107_ 0.06001f
C37464 hold161/a_438_182# net157 0.00735f
C37465 _540_/a_45_160# _308_ 0.016f
C37466 input6/a_40_152# net7 0
C37467 hold98/a_326_118# _039_ 0
C37468 net98 _507_/a_170_412# 0
C37469 hold98/a_438_182# net116 0
C37470 _660_/a_298_337# clk 0.01311f
C37471 rx_data[4] hold138/a_56_118# 0
C37472 _645_/a_843_236# _158_ 0
C37473 _654_/a_843_236# VPWR 0.00165f
C37474 _447_/a_379_118# _236_ 0
C37475 net101 clknet_4_2_0_clk 0
C37476 FILLER_16_176/a_40_246# net48 0
C37477 _634_/a_2250_412# clknet_4_15_0_clk 0.0021f
C37478 tx_inst.data_reg\[6\] _660_/a_550_127# 0
C37479 VPWR _664_/a_1840_334# 0.00218f
C37480 net94 _499_/a_209_168# 0
C37481 _058_ _647_/a_1583_191# 0
C37482 _663_/a_741_93# _215_ 0
C37483 clknet_0_clk _684_/a_843_236# 0
C37484 _079_ fanout43/a_40_152# 0
C37485 net124 _264_ 0.28375f
C37486 net32 _441_/a_154_118# 0.00116f
C37487 _346_/a_252_412# VPWR 0
C37488 baud_inst.counter\[21\] _701_/a_612_127# 0
C37489 net44 FILLER_20_95/a_40_246# 0
C37490 hold152/a_326_118# VPWR 0.00763f
C37491 net39 _670_/a_681_505# 0
C37492 _246_ hold180/a_438_182# 0
C37493 VPWR _347_/a_146_122# 0
C37494 clknet_4_0_0_clk _037_ 0.04876f
C37495 net29 hold180/a_56_118# 0
C37496 _434_/a_252_412# net25 0
C37497 net128 net90 0
C37498 _678_/a_2250_412# _677_/a_1583_191# 0
C37499 _678_/a_1489_191# _677_/a_741_93# 0
C37500 _696_/a_324_432# net90 0
C37501 net71 _273_ 0
C37502 net98 _682_/a_324_432# 0.04916f
C37503 _166_ _666_/a_38_114# 0.04714f
C37504 _009_ _682_/a_741_93# 0.0163f
C37505 _676_/a_324_432# _670_/a_298_337# 0
C37506 hold89/a_326_118# _518_/a_45_160# 0
C37507 clknet_4_14_0_clk _134_ 0.06573f
C37508 net14 _634_/a_1840_334# 0.00669f
C37509 clknet_4_13_0_clk _632_/a_324_432# 0.01506f
C37510 hold87/a_438_182# FILLER_16_70/a_40_246# 0
C37511 net179 FILLER_7_210/a_40_246# 0
C37512 hold154/a_438_182# clknet_4_3_0_clk 0.00264f
C37513 clknet_4_15_0_clk _649_/a_843_236# 0.03618f
C37514 _473_/a_22_110# net64 0.00117f
C37515 _073_ _706_/a_741_93# 0
C37516 _662_/a_1840_334# _706_/a_1489_191# 0
C37517 net79 FILLER_5_59/a_40_246# 0
C37518 _518_/a_45_160# baud_inst.counter\[13\] 0
C37519 hold121/a_56_118# net46 0
C37520 _279_ _504_/a_209_168# 0.03693f
C37521 tx_inst.bit_index\[2\] net168 0
C37522 _206_ _382_/a_496_118# 0.00225f
C37523 FILLER_3_207/a_40_246# VPWR 0.1519f
C37524 _699_/a_612_127# baud_inst.counter\[29\] 0
C37525 baud_inst.counter\[6\] net40 0.02233f
C37526 net74 net19 0
C37527 _117_ hold50/a_438_182# 0.00331f
C37528 FILLER_19_178/a_40_246# _247_ 0
C37529 _543_/a_248_122# baud_inst.counter\[24\] 0.00196f
C37530 net148 _106_ 0.00346f
C37531 _682_/a_843_236# clknet_4_2_0_clk 0.02519f
C37532 net53 clknet_4_11_0_clk 0.03363f
C37533 hold122/a_326_118# rx_inst.state\[3\] 0.00109f
C37534 net49 fanout49/a_40_152# 0.01274f
C37535 tx_inst.data_reg\[5\] _339_/a_805_385# 0.00312f
C37536 _011_ net108 0
C37537 _159_ _242_ 0
C37538 _025_ baud_inst.counter\[24\] 0.18423f
C37539 net141 _309_ 0
C37540 hold112/a_326_118# _448_/a_142_412# 0
C37541 hold112/a_56_118# _448_/a_244_412# 0
C37542 _671_/a_612_127# VPWR 0.00121f
C37543 hold161/a_438_182# _298_ 0
C37544 net49 _690_/a_843_236# 0.00207f
C37545 clkbuf_4_11_0_clk/a_27_118# hold100/a_56_118# 0
C37546 _358_/a_411_436# VPWR 0
C37547 net58 _700_/a_1489_191# 0
C37548 FILLER_5_32/a_40_246# _038_ 0
C37549 hold88/a_326_118# hold177/a_438_182# 0
C37550 _128_ _638_/a_324_432# 0
C37551 _267_ _638_/a_741_93# 0
C37552 VPWR _085_ 0.19379f
C37553 FILLER_7_146/a_32_246# _653_/a_2250_412# 0
C37554 _390_/a_59_156# _655_/a_1840_334# 0
C37555 _390_/a_382_118# _655_/a_1583_191# 0
C37556 clknet_4_5_0_clk _365_/a_257_140# 0
C37557 hold182/a_56_118# _676_/a_1489_191# 0
C37558 _637_/a_741_93# _634_/a_1840_334# 0.00128f
C37559 _637_/a_843_236# _634_/a_1583_191# 0.00337f
C37560 net65 rx_inst.data_reg\[6\] 0.02119f
C37561 rx_inst.data_reg\[3\] _157_ 0.00132f
C37562 net118 _668_/a_843_236# 0
C37563 _153_ _668_/a_741_93# 0.00196f
C37564 net48 _647_/a_843_236# 0.02461f
C37565 _632_/a_324_432# net65 0.00213f
C37566 _632_/a_38_114# _122_ 0
C37567 clknet_4_5_0_clk FILLER_1_201/a_40_246# 0.00986f
C37568 _481_/a_22_110# _176_ 0.00582f
C37569 hold143/a_56_118# _266_ 0.01168f
C37570 hold143/a_326_118# net30 0
C37571 net32 FILLER_17_160/a_40_246# 0.00161f
C37572 _641_/a_741_93# FILLER_19_118/a_32_246# 0.00112f
C37573 _699_/a_1583_191# baud_inst.counter\[24\] 0
C37574 FILLER_3_177/a_32_246# _197_ 0
C37575 net39 _682_/a_1583_191# 0
C37576 _177_ baud_inst.counter\[30\] 0.00183f
C37577 _689_/a_298_337# net157 0
C37578 baud_inst.counter\[31\] _703_/a_1489_191# 0.01783f
C37579 baud_inst.counter\[30\] _703_/a_550_127# 0
C37580 tx_data[0] net165 0.01157f
C37581 net79 _672_/a_2002_114# 0
C37582 net37 rx_inst.state\[4\] 0.01152f
C37583 net26 _650_/a_843_236# 0
C37584 FILLER_17_81/a_32_246# net46 0
C37585 rx_inst.bit_index\[2\] _421_/a_150_412# 0
C37586 tx_data[4] _209_ 0
C37587 hold174/a_438_182# clknet_4_4_0_clk 0
C37588 fanout27/a_40_152# _671_/a_741_93# 0
C37589 hold104/a_56_118# _300_ 0
C37590 net37 net119 0.02494f
C37591 net167 net29 0.15812f
C37592 rx_inst.bit_index\[1\] _434_/a_150_412# 0
C37593 _079_ _080_ 0.00358f
C37594 _691_/a_1840_334# clknet_4_8_0_clk 0.00111f
C37595 _467_/a_22_110# clknet_4_13_0_clk 0.00506f
C37596 net49 _262_ 0
C37597 hold86/a_326_118# baud_inst.counter\[3\] 0
C37598 _488_/a_177_436# net86 0
C37599 _488_/a_380_412# net181 0.00136f
C37600 net179 _654_/a_741_93# 0
C37601 net94 _680_/a_2250_412# 0.00143f
C37602 _178_ baud_inst.counter\[28\] 0
C37603 _640_/a_1583_191# rx_inst.bit_index\[0\] 0
C37604 _640_/a_1840_334# clknet_4_14_0_clk 0.01541f
C37605 _107_ _701_/a_298_337# 0
C37606 hold183/a_438_182# _219_ 0
C37607 _646_/a_1785_429# clknet_4_12_0_clk 0
C37608 net69 _632_/a_1840_334# 0
C37609 net114 _701_/a_2250_412# 0
C37610 _652_/a_324_432# net43 0.00368f
C37611 FILLER_26_227/a_40_246# _264_ 0
C37612 net32 _427_/a_350_122# 0
C37613 clknet_4_12_0_clk _435_/a_166_436# 0.001f
C37614 FILLER_19_149/a_40_246# net25 0
C37615 rx_inst.bit_index\[2\] _435_/a_72_436# 0
C37616 _655_/a_741_93# _145_ 0.00656f
C37617 input9/a_40_152# FILLER_0_156/a_32_246# 0.00624f
C37618 _278_ FILLER_12_128/a_40_246# 0.01398f
C37619 _183_ net117 0
C37620 _246_ _137_ 0.00257f
C37621 _155_ _242_ 0
C37622 hold65/a_438_182# _638_/a_324_432# 0
C37623 hold65/a_56_118# _638_/a_843_236# 0
C37624 hold65/a_326_118# _638_/a_741_93# 0.00638f
C37625 hold128/a_56_118# _685_/a_741_93# 0.00162f
C37626 hold128/a_326_118# _685_/a_324_432# 0
C37627 hold132/a_56_118# _134_ 0.03618f
C37628 _556_/a_192_429# _703_/a_38_114# 0
C37629 _635_/a_1840_334# _264_ 0.00372f
C37630 _206_ _209_ 0.43499f
C37631 _677_/a_741_93# net40 0
C37632 hold158/a_56_118# baud_inst.counter\[16\] 0
C37633 hold133/a_326_118# _700_/a_1489_191# 0
C37634 hold131/a_326_118# clknet_0_clk 0
C37635 _659_/a_2002_114# tx_inst.data_reg\[1\] 0
C37636 clknet_4_3_0_clk hold92/a_326_118# 0
C37637 net45 hold148/a_56_118# 0
C37638 hold75/a_56_118# baud_inst.counter\[23\] 0.04398f
C37639 _650_/a_298_337# rx_inst.state\[4\] 0
C37640 baud_inst.counter\[27\] clknet_4_11_0_clk 0.01723f
C37641 _058_ hold144/a_326_118# 0
C37642 _679_/a_843_236# hold95/a_56_118# 0
C37643 _679_/a_741_93# hold95/a_326_118# 0
C37644 net160 _015_ 0.03688f
C37645 net166 clk 0.00685f
C37646 clknet_4_11_0_clk _703_/a_1785_429# 0
C37647 _091_ _677_/a_324_432# 0
C37648 _650_/a_298_337# net119 0.00233f
C37649 _650_/a_38_114# _061_ 0.00911f
C37650 _135_ VPWR 0.185f
C37651 rx_inst.state\[3\] net49 0.00131f
C37652 _126_ rx_data[7] 0.04404f
C37653 _267_ _154_ 0.00183f
C37654 _128_ net126 0.01935f
C37655 _107_ _693_/a_1785_429# 0
C37656 _054_ clknet_0_clk 0.02152f
C37657 _663_/a_612_127# clknet_0_clk 0
C37658 _468_/a_120_432# _240_ 0.00104f
C37659 _036_ baud_inst.counter\[4\] 0
C37660 _216_ _651_/a_843_236# 0
C37661 _512_/a_165_412# net29 0.00144f
C37662 _078_ VPWR 0.38713f
C37663 _257_ net52 0
C37664 _152_ _275_ 0
C37665 net153 VPWR 0.02125f
C37666 _113_ hold134/a_438_182# 0.00104f
C37667 clknet_4_12_0_clk net24 0.02293f
C37668 _675_/a_1489_191# VPWR 0.00218f
C37669 _687_/a_741_93# _297_ 0
C37670 net37 _433_/a_244_412# 0
C37671 _249_ _647_/a_324_432# 0
C37672 _136_ _647_/a_38_114# 0
C37673 _044_ _633_/a_324_432# 0.01452f
C37674 FILLER_0_237/a_40_246# clk 0.00266f
C37675 _104_ net101 0
C37676 _052_ _697_/a_2250_412# 0.00624f
C37677 net176 _697_/a_1840_334# 0.01434f
C37678 clk _373_/a_170_412# 0
C37679 _642_/a_1583_191# _641_/a_1583_191# 0
C37680 clknet_4_5_0_clk hold179/a_438_182# 0.04352f
C37681 hold87/a_56_118# _517_/a_209_168# 0
C37682 _083_ net39 0.15682f
C37683 _650_/a_324_432# _264_ 0
C37684 _450_/a_127_436# _161_ 0.02522f
C37685 _046_ _636_/a_2250_412# 0.00285f
C37686 FILLER_13_137/a_32_246# net26 0.01593f
C37687 net89 _539_/a_45_160# 0
C37688 net112 _223_ 0.00222f
C37689 hold153/a_438_182# _035_ 0.01987f
C37690 net156 _528_/a_277_118# 0.00177f
C37691 clkbuf_0_clk/a_116_82# net43 0.00516f
C37692 hold165/a_56_118# VPWR 0.00737f
C37693 _206_ FILLER_0_161/a_40_246# 0.00821f
C37694 hold172/a_438_182# VPWR 0.00277f
C37695 hold110/a_326_118# net29 0.00533f
C37696 _035_ hold93/a_56_118# 0.00397f
C37697 net153 hold93/a_326_118# 0
C37698 _671_/a_1489_191# _000_ 0
C37699 net67 _115_ 0.03083f
C37700 _675_/a_843_236# _181_ 0
C37701 _206_ _069_ 0
C37702 baud_inst.counter\[15\] baud_inst.counter\[16\] 0
C37703 _699_/a_1489_191# _311_ 0
C37704 _662_/a_612_127# _200_ 0
C37705 _009_ FILLER_8_35/a_32_246# 0
C37706 hold65/a_326_118# _154_ 0
C37707 _114_ _701_/a_1583_191# 0
C37708 _079_ _041_ 0.00129f
C37709 _643_/a_298_337# net48 0
C37710 _065_ _144_ 0.10468f
C37711 net173 tx_inst.bit_index\[1\] 0.18867f
C37712 hold183/a_56_118# _220_ 0
C37713 baud_inst.counter\[18\] _017_ 0.00295f
C37714 net147 FILLER_24_4/a_40_246# 0
C37715 net46 FILLER_24_4/a_40_246# 0.02806f
C37716 hold171/a_326_118# _148_ 0.00108f
C37717 _679_/a_1840_334# net95 0
C37718 hold167/a_56_118# _670_/a_324_432# 0
C37719 _642_/a_1785_429# _260_ 0
C37720 _174_ _150_ 0.00134f
C37721 net16 net28 0
C37722 fanout35/a_40_152# VPWR 0.05565f
C37723 _676_/a_298_337# _281_ 0
C37724 _690_/a_1840_334# _523_/a_155_412# 0
C37725 hold67/a_56_118# net67 0
C37726 net18 _637_/a_2250_412# 0.04747f
C37727 _683_/a_1489_191# net29 0.00365f
C37728 hold183/a_438_182# tx_inst.bit_index\[2\] 0
C37729 net42 _676_/a_2250_412# 0.00187f
C37730 _431_/a_81_118# clknet_0_clk 0.0096f
C37731 _287_ _681_/a_1583_191# 0
C37732 _221_ net43 0
C37733 hold173/a_326_118# _221_ 0.00389f
C37734 _479_/a_120_432# net172 0.00108f
C37735 FILLER_10_222/a_32_246# hold50/a_56_118# 0.00404f
C37736 _189_ hold109/a_56_118# 0
C37737 net93 _185_ 0
C37738 clknet_4_1_0_clk hold94/a_438_182# 0.00111f
C37739 FILLER_5_74/a_32_246# net40 0
C37740 _278_ _652_/a_1489_191# 0
C37741 _126_ _636_/a_1840_334# 0.00483f
C37742 net74 _636_/a_1583_191# 0.02722f
C37743 FILLER_26_229/a_32_246# hold71/a_438_182# 0.00985f
C37744 _655_/a_843_236# VPWR 0.01444f
C37745 _075_ _666_/a_1583_191# 0
C37746 clknet_4_7_0_clk output22/a_40_152# 0.04634f
C37747 _205_ _372_/a_22_110# 0
C37748 net166 _409_/a_167_412# 0
C37749 rx_inst.bit_index\[1\] net28 0
C37750 _206_ _207_ 0.07177f
C37751 clknet_4_15_0_clk hold71/a_326_118# 0.00159f
C37752 tx_inst.data_reg\[7\] _657_/a_2002_114# 0
C37753 hold96/a_56_118# net29 0
C37754 net92 _353_/a_248_122# 0
C37755 _663_/a_843_236# net43 0.00365f
C37756 clknet_0_clk FILLER_12_82/a_32_246# 0
C37757 hold88/a_438_182# net128 0
C37758 net132 _440_/a_244_412# 0.01492f
C37759 hold112/a_326_118# _154_ 0
C37760 net35 _223_ 0.00176f
C37761 net165 _208_ 0
C37762 _448_/a_244_412# _136_ 0
C37763 VPWR _280_ 0.23753f
C37764 _646_/a_2250_412# net64 0.00106f
C37765 _646_/a_1840_334# _273_ 0
C37766 baud_inst.counter\[8\] _681_/a_2250_412# 0
C37767 hold57/a_326_118# _222_ 0.00293f
C37768 hold57/a_56_118# _141_ 0.04622f
C37769 VPWR _688_/a_1583_191# 0.01086f
C37770 hold142/a_438_182# _697_/a_324_432# 0.00218f
C37771 _652_/a_324_432# net152 0
C37772 _228_ fanout28/a_40_152# 0.02358f
C37773 baud_inst.counter\[23\] _695_/a_1583_191# 0.06104f
C37774 baud_inst.counter\[22\] _695_/a_132_114# 0
C37775 net49 _692_/a_324_432# 0.00948f
C37776 baud_inst.counter\[31\] _556_/a_341_118# 0
C37777 hold170/a_438_182# net54 0.01278f
C37778 tx_inst.data_reg\[6\] _391_/a_268_412# 0
C37779 hold170/a_56_118# _214_ 0
C37780 tx_inst.bit_index\[1\] FILLER_7_146/a_32_246# 0
C37781 _633_/a_741_93# _272_ 0.0034f
C37782 _633_/a_843_236# net77 0
C37783 hold59/a_438_182# _313_ 0
C37784 _060_ clknet_0_clk 0.0275f
C37785 _660_/a_1583_191# clk 0.0075f
C37786 net79 _679_/a_38_114# 0
C37787 FILLER_19_139/a_40_246# _131_ 0
C37788 _396_/a_155_412# net183 0
C37789 net166 net2 0.02707f
C37790 _284_ _162_ 0
C37791 clk FILLER_0_156/a_32_246# 0
C37792 _646_/a_298_337# _647_/a_38_114# 0
C37793 _646_/a_38_114# _647_/a_298_337# 0
C37794 tx_inst.data_reg\[6\] clknet_4_5_0_clk 1.36573f
C37795 FILLER_8_19/a_40_246# net38 0
C37796 _365_/a_257_140# _005_ 0
C37797 _280_ hold93/a_326_118# 0
C37798 baud_inst.counter\[20\] hold147/a_438_182# 0.01011f
C37799 _206_ clknet_4_4_0_clk 0.0459f
C37800 baud_inst.counter\[30\] VPWR 0.37978f
C37801 baud_inst.counter\[21\] net107 0
C37802 baud_inst.counter\[26\] hold113/a_56_118# 0.03964f
C37803 baud_inst.counter\[27\] hold113/a_326_118# 0.04897f
C37804 _427_/a_248_122# _242_ 0
C37805 _283_ _284_ 0
C37806 _656_/a_1840_334# _380_/a_59_156# 0
C37807 _656_/a_1583_191# _380_/a_382_118# 0
C37808 net49 _447_/a_175_118# 0
C37809 _653_/a_681_505# net43 0
C37810 _095_ _682_/a_324_432# 0.02347f
C37811 _663_/a_2250_412# hold146/a_438_182# 0
C37812 _166_ _666_/a_1840_334# 0.01134f
C37813 _009_ _682_/a_1785_429# 0.00195f
C37814 _676_/a_1583_191# _670_/a_324_432# 0
C37815 _661_/a_324_432# FILLER_3_123/a_32_246# 0
C37816 net2 _704_/a_843_236# 0.00609f
C37817 input2/a_40_152# _704_/a_1840_334# 0
C37818 VPWR _540_/a_45_160# 0.0165f
C37819 _674_/a_324_432# _504_/a_209_168# 0
C37820 net172 net11 0.29735f
C37821 hold128/a_438_182# clknet_0_clk 0.00447f
C37822 _669_/a_38_114# net29 0
C37823 FILLER_16_70/a_40_246# _517_/a_209_168# 0.01213f
C37824 clknet_4_15_0_clk _649_/a_612_127# 0.02381f
C37825 _662_/a_1840_334# _042_ 0.00105f
C37826 net173 hold174/a_56_118# 0
C37827 _040_ _706_/a_1840_334# 0.00799f
C37828 _687_/a_2250_412# _541_/a_209_168# 0
C37829 _279_ _287_ 0.12664f
C37830 _481_/a_22_110# _276_ 0.01465f
C37831 net114 baud_inst.counter\[29\] 0.06009f
C37832 net7 _389_/a_268_412# 0.00123f
C37833 FILLER_12_82/a_32_246# _182_ 0
C37834 _695_/a_324_432# _301_ 0
C37835 _424_/a_142_412# _158_ 0
C37836 _634_/a_324_432# hold82/a_326_118# 0
C37837 net111 _258_ 0
C37838 clknet_4_13_0_clk _668_/a_1583_191# 0
C37839 _132_ VPWR 0.20078f
C37840 baud_inst.counter\[28\] net133 0.01086f
C37841 net44 hold142/a_438_182# 0
C37842 _682_/a_612_127# clknet_4_2_0_clk 0
C37843 net180 FILLER_17_131/a_32_246# 0
C37844 _699_/a_741_93# net46 0
C37845 net49 _018_ 0
C37846 _248_ _436_/a_244_412# 0.0104f
C37847 hold112/a_326_118# _160_ 0.00363f
C37848 _283_ FILLER_9_79/a_32_246# 0.00138f
C37849 _412_/a_22_110# _227_ 0.01491f
C37850 hold53/a_438_182# VPWR 0.00746f
C37851 _191_ VPWR 0.4989f
C37852 _259_ _043_ 0
C37853 hold78/a_326_118# _123_ 0.0087f
C37854 _267_ _638_/a_1785_429# 0
C37855 net31 net25 0.07628f
C37856 _173_ tx_inst.data_reg\[2\] 0
C37857 _194_ clknet_4_4_0_clk 0.00697f
C37858 _635_/a_1489_191# FILLER_19_228/a_40_246# 0
C37859 hold154/a_438_182# baud_inst.counter\[5\] 0
C37860 net2 hold81/a_56_118# 0
C37861 clkbuf_4_12_0_clk/a_27_118# hold139/a_56_118# 0.00293f
C37862 net72 _634_/a_298_337# 0
C37863 _048_ _634_/a_38_114# 0.07041f
C37864 net48 _647_/a_612_127# 0.01007f
C37865 net26 _192_ 0.01435f
C37866 net2 _707_/a_38_114# 0
C37867 net75 hold147/a_56_118# 0
C37868 hold138/a_56_118# _635_/a_324_432# 0
C37869 net114 _695_/a_1583_191# 0
C37870 _675_/a_324_432# _087_ 0.0015f
C37871 _179_ net59 0
C37872 _225_ fanout35/a_40_152# 0.00804f
C37873 hold156/a_326_118# net40 0.01669f
C37874 hold142/a_326_118# clknet_0_clk 0.00379f
C37875 _661_/a_550_127# tx_inst.data_reg\[7\] 0
C37876 hold145/a_326_118# _067_ 0
C37877 hold55/a_326_118# net11 0.0012f
C37878 fanout37/a_40_152# _061_ 0.00446f
C37879 _445_/a_165_412# clknet_0_clk 0
C37880 _117_ _705_/a_843_236# 0
C37881 rx_inst.bit_index\[0\] _454_/a_155_412# 0
C37882 net175 _161_ 0.17819f
C37883 fanout32/a_40_152# hold62/a_438_182# 0
C37884 hold144/a_326_118# hold112/a_326_118# 0
C37885 hold144/a_56_118# hold112/a_438_182# 0
C37886 FILLER_21_31/a_40_246# _693_/a_1583_191# 0
C37887 _116_ _702_/a_741_93# 0.00103f
C37888 _019_ net86 0.6443f
C37889 net60 net38 0.15122f
C37890 _186_ _282_ 0.00323f
C37891 net67 hold105/a_56_118# 0
C37892 _703_/a_38_114# FILLER_23_83/a_32_246# 0
C37893 baud_inst.counter\[20\] _693_/a_298_337# 0
C37894 _652_/a_2250_412# net43 0.04642f
C37895 _180_ net29 1.82527f
C37896 net32 _244_ 0.00648f
C37897 hold168/a_56_118# _664_/a_741_93# 0.00212f
C37898 hold168/a_326_118# _664_/a_324_432# 0
C37899 _678_/a_298_337# net137 0
C37900 net35 _261_ 0.00392f
C37901 hold67/a_326_118# _702_/a_843_236# 0.00222f
C37902 hold67/a_438_182# _702_/a_741_93# 0.0011f
C37903 _655_/a_1840_334# tx_inst.data_reg\[1\] 0
C37904 net55 _203_ 0.00562f
C37905 _020_ _300_ 0
C37906 FILLER_15_116/a_40_246# _669_/a_741_93# 0.00392f
C37907 net72 net47 0.19536f
C37908 rx_data[3] _636_/a_38_114# 0
C37909 net15 _636_/a_324_432# 0
C37910 net58 _703_/a_324_432# 0.0025f
C37911 _316_ _703_/a_38_114# 0
C37912 _032_ _703_/a_298_337# 0.00139f
C37913 clknet_0_clk _649_/a_741_93# 0.03402f
C37914 tx_start FILLER_8_236/a_40_246# 0.01103f
C37915 net2 _671_/a_324_432# 0
C37916 FILLER_16_56/a_32_246# baud_inst.counter\[15\] 0
C37917 _646_/a_681_505# VPWR 0
C37918 net37 _002_ 0
C37919 baud_inst.counter\[7\] _678_/a_843_236# 0
C37920 clknet_4_3_0_clk _678_/a_681_505# 0
C37921 net51 net30 0.01818f
C37922 net3 _656_/a_843_236# 0
C37923 _357_/a_150_412# net40 0.0027f
C37924 hold101/a_56_118# _690_/a_324_432# 0
C37925 _650_/a_1840_334# _061_ 0
C37926 _058_ _140_ 0
C37927 _639_/a_324_432# FILLER_13_228/a_40_246# 0
C37928 fanout44/a_40_152# VPWR 0.00592f
C37929 _062_ hold56/a_326_118# 0
C37930 _125_ _240_ 0.00141f
C37931 FILLER_23_204/a_40_246# _463_/a_22_110# 0
C37932 hold177/a_56_118# FILLER_13_68/a_40_246# 0
C37933 FILLER_14_202/a_40_246# _265_ 0
C37934 _010_ net29 0.01978f
C37935 _635_/a_1583_191# _156_ 0
C37936 tx_data[1] input6/a_40_152# 0
C37937 input4/a_40_152# tx_data[3] 0.01052f
C37938 _256_ FILLER_26_141/a_40_246# 0
C37939 net48 net125 0.51665f
C37940 baud_inst.counter\[3\] VPWR 0.07563f
C37941 net182 _180_ 0.01719f
C37942 net7 input8/a_40_152# 0
C37943 input7/a_40_152# net8 0.09318f
C37944 net179 net54 0.03392f
C37945 _689_/a_1583_191# _298_ 0
C37946 _157_ _647_/a_550_127# 0
C37947 net48 _133_ 0.04763f
C37948 _345_/a_252_412# VPWR 0
C37949 clkbuf_4_1_0_clk/a_27_118# FILLER_6_98/a_40_246# 0.01094f
C37950 hold126/a_438_182# net72 0
C37951 _398_/a_115_308# _217_ 0
C37952 hold91/a_56_118# _297_ 0
C37953 _642_/a_741_93# net176 0
C37954 _132_ _641_/a_741_93# 0
C37955 clknet_4_12_0_clk _641_/a_324_432# 0.03114f
C37956 _642_/a_843_236# _052_ 0
C37957 _053_ _641_/a_843_236# 0
C37958 hold96/a_56_118# hold95/a_438_182# 0.00113f
C37959 _650_/a_2250_412# _264_ 0
C37960 _341_/a_589_385# tx_inst.data_reg\[2\] 0
C37961 _341_/a_886_118# clknet_4_4_0_clk 0.06061f
C37962 _705_/a_843_236# net11 0
C37963 rx_inst.data_reg\[7\] rx_inst.state\[1\] 0.00162f
C37964 _170_ hold139/a_326_118# 0
C37965 _230_ _131_ 0
C37966 _633_/a_741_93# _648_/a_298_337# 0
C37967 _633_/a_324_432# _648_/a_38_114# 0
C37968 hold53/a_438_182# _641_/a_741_93# 0
C37969 hold87/a_56_118# baud_inst.counter\[15\] 0.03746f
C37970 tx_inst.bit_index\[1\] _386_/a_559_412# 0
C37971 _083_ _676_/a_843_236# 0
C37972 rx_data[4] net80 0
C37973 _378_/a_496_118# net8 0
C37974 _040_ net172 0
C37975 _073_ _200_ 1.05946f
C37976 _511_/a_354_412# _291_ 0.00482f
C37977 _487_/a_146_122# net50 0
C37978 _487_/a_248_122# net146 0
C37979 hold122/a_326_118# _205_ 0
C37980 clknet_4_12_0_clk _647_/a_324_432# 0.00731f
C37981 clk _654_/a_324_432# 0.00322f
C37982 VPWR _101_ 0.25663f
C37983 hold103/a_326_118# clknet_4_8_0_clk 0
C37984 net167 _670_/a_741_93# 0
C37985 _132_ _225_ 0
C37986 _053_ _260_ 0
C37987 _076_ _203_ 0
C37988 net42 FILLER_11_125/a_32_246# 0.00344f
C37989 _699_/a_843_236# _312_ 0
C37990 _699_/a_741_93# _313_ 0.0073f
C37991 net70 net72 0
C37992 _371_/a_170_412# _201_ 0
C37993 _690_/a_1840_334# _298_ 0
C37994 clkbuf_4_8_0_clk/a_27_118# _687_/a_1583_191# 0.00568f
C37995 _456_/a_155_412# _264_ 0.01169f
C37996 baud_inst.counter\[11\] net29 0.00172f
C37997 clknet_4_1_0_clk clknet_4_0_0_clk 0.00132f
C37998 hold87/a_326_118# _294_ 0.00125f
C37999 _275_ net168 0
C38000 _006_ net172 0.00474f
C38001 net169 clknet_0_clk 0
C38002 clknet_4_14_0_clk net32 0.08129f
C38003 net60 FILLER_0_42/a_32_246# 0
C38004 net84 net138 0.00544f
C38005 net179 _368_/a_155_412# 0.00224f
C38006 baud_inst.counter\[13\] _290_ 0.00113f
C38007 hold163/a_438_182# baud_inst.counter\[20\] 0.00193f
C38008 output12/a_40_152# _637_/a_1583_191# 0
C38009 output13/a_40_152# net13 0.02784f
C38010 hold120/a_438_182# net49 0
C38011 net44 _698_/a_38_114# 0
C38012 hold156/a_56_118# _682_/a_843_236# 0
C38013 _223_ _416_/a_146_122# 0.00105f
C38014 _655_/a_612_127# VPWR 0.0025f
C38015 hold85/a_326_118# clknet_4_13_0_clk 0
C38016 _488_/a_177_436# net38 0
C38017 net44 hold101/a_326_118# 0
C38018 _178_ baud_inst.counter\[26\] 0
C38019 baud_inst.counter\[27\] _541_/a_209_168# 0
C38020 hold158/a_56_118# _016_ 0.03132f
C38021 hold158/a_438_182# net157 0.00461f
C38022 VPWR hold91/a_438_182# 0.00255f
C38023 _302_ _188_ 0
C38024 _510_/a_248_122# _505_/a_76_160# 0
C38025 _663_/a_612_127# net43 0
C38026 _696_/a_741_93# _696_/a_843_236# -0
C38027 _248_ net48 0.00686f
C38028 _236_ FILLER_25_141/a_32_246# 0
C38029 hold155/a_56_118# _148_ 0.01398f
C38030 _661_/a_843_236# _658_/a_38_114# 0
C38031 net31 _139_ 0
C38032 VPWR _688_/a_2002_114# 0
C38033 _092_ clknet_0_clk 0
C38034 baud_inst.counter\[23\] _695_/a_2002_114# 0.00103f
C38035 net71 _638_/a_741_93# 0
C38036 FILLER_21_192/a_40_246# FILLER_21_194/a_32_246# 0.0524f
C38037 hold136/a_326_118# net136 0.00967f
C38038 FILLER_10_222/a_32_246# _705_/a_324_432# 0
C38039 _423_/a_279_412# _249_ 0
C38040 net49 _692_/a_2250_412# 0.01007f
C38041 _698_/a_298_337# clknet_0_clk 0
C38042 _505_/a_76_160# _182_ 0
C38043 _240_ _416_/a_146_122# 0.00161f
C38044 net48 rx 0
C38045 hold55/a_438_182# _275_ 0
C38046 net177 hold130/a_56_118# 0
C38047 _635_/a_843_236# _122_ 0
C38048 _144_ VPWR 0.23023f
C38049 hold108/a_56_118# baud_inst.counter\[13\] 0
C38050 _646_/a_843_236# _647_/a_843_236# 0.00216f
C38051 baud_inst.counter\[26\] hold99/a_326_118# 0.02248f
C38052 baud_inst.counter\[27\] hold99/a_438_182# 0
C38053 _662_/a_324_432# net55 0.04721f
C38054 _075_ _215_ 0
C38055 hold98/a_326_118# net98 0
C38056 hold98/a_438_182# _009_ 0.00238f
C38057 net84 _047_ 0
C38058 _023_ FILLER_21_31/a_40_246# 0
C38059 _085_ FILLER_0_56/a_32_246# 0
C38060 _512_/a_165_412# _288_ 0.00532f
C38061 net49 _205_ 0.00268f
C38062 hold144/a_438_182# _136_ 0
C38063 baud_inst.counter\[20\] _537_/a_435_412# 0
C38064 hold86/a_438_182# VPWR 0.00618f
C38065 _661_/a_2250_412# net165 0
C38066 FILLER_24_218/a_40_246# clknet_4_15_0_clk 0.00541f
C38067 hold126/a_56_118# _128_ 0.02572f
C38068 hold126/a_326_118# _267_ 0.00211f
C38069 clknet_4_11_0_clk FILLER_23_83/a_32_246# 0.01807f
C38070 _663_/a_1489_191# tx_inst.state\[4\] 0
C38071 _083_ FILLER_13_100/a_40_246# 0.00262f
C38072 _486_/a_115_308# net51 0.0017f
C38073 _390_/a_59_156# net159 0.00443f
C38074 FILLER_0_128/a_40_246# _148_ 0.02599f
C38075 clknet_4_1_0_clk FILLER_3_123/a_32_246# 0
C38076 net86 FILLER_6_54/a_32_246# 0
C38077 _515_/a_170_160# _297_ 0
C38078 _637_/a_1840_334# hold71/a_438_182# 0.00107f
C38079 _098_ _281_ 0.00954f
C38080 _153_ _650_/a_324_432# 0.00834f
C38081 net118 _650_/a_741_93# 0
C38082 _170_ hold132/a_326_118# 0.04137f
C38083 _674_/a_324_432# _287_ 0
C38084 _669_/a_1840_334# net29 0
C38085 net48 _245_ 0
C38086 hold132/a_56_118# net32 0
C38087 clknet_4_15_0_clk net127 0
C38088 _316_ clknet_4_11_0_clk 0
C38089 _671_/a_324_432# _169_ 0
C38090 _339_/a_295_385# tx_inst.data_reg\[1\] 0
C38091 fanout39/a_40_152# _101_ 0.00101f
C38092 baud_inst.counter\[12\] FILLER_13_68/a_40_246# 0.0446f
C38093 _639_/a_324_432# _264_ 0
C38094 net48 hold73/a_438_182# 0.02576f
C38095 hold162/a_56_118# clknet_0_clk 0.0026f
C38096 _112_ _701_/a_843_236# 0
C38097 hold58/a_56_118# net49 0.00707f
C38098 _674_/a_2250_412# hold60/a_56_118# 0.00171f
C38099 hold110/a_326_118# _288_ 0.00304f
C38100 _639_/a_1489_191# rx_inst.state\[1\] 0.00195f
C38101 FILLER_16_70/a_40_246# baud_inst.counter\[15\] 0.00504f
C38102 _694_/a_298_337# net46 0
C38103 _693_/a_324_432# FILLER_24_19/a_40_246# 0
C38104 _699_/a_1785_429# net46 0
C38105 _697_/a_38_114# _025_ 0.01575f
C38106 net44 net89 0.01649f
C38107 _248_ _250_ 0.00289f
C38108 _268_ net126 0.05448f
C38109 net71 _154_ 0
C38110 net121 FILLER_22_22/a_32_246# 0.00516f
C38111 _092_ _182_ 0.05271f
C38112 _294_ _296_ 0
C38113 net41 _200_ 0
C38114 net98 net39 0.0122f
C38115 net36 net52 0.02484f
C38116 _672_/a_843_236# baud_inst.counter\[0\] 0
C38117 _192_ FILLER_5_181/a_32_246# 0.00351f
C38118 _284_ clkbuf_4_3_0_clk/a_27_118# 0.03481f
C38119 _678_/a_38_114# _287_ 0
C38120 _089_ hold108/a_438_182# 0
C38121 _048_ _634_/a_1840_334# 0
C38122 _151_ _213_ 0
C38123 FILLER_13_102/a_32_246# net123 0
C38124 net48 net139 0.10885f
C38125 hold135/a_56_118# _674_/a_2250_412# 0
C38126 net2 _707_/a_1840_334# 0.02869f
C38127 rx _707_/a_2250_412# 0.02385f
C38128 hold124/a_438_182# clknet_4_15_0_clk 0
C38129 _017_ _527_/a_192_429# 0.00135f
C38130 hold138/a_438_182# _635_/a_1583_191# 0
C38131 rx_inst.data_reg\[4\] _635_/a_843_236# 0
C38132 hold85/a_56_118# rx_inst.data_reg\[4\] 0.0161f
C38133 hold112/a_56_118# net47 0
C38134 _675_/a_2250_412# _087_ 0
C38135 _705_/a_681_505# _275_ 0
C38136 net26 rx_inst.state\[4\] 0.03326f
C38137 _702_/a_550_127# _115_ 0
C38138 net145 clknet_4_4_0_clk 0.14348f
C38139 net26 net119 0.02623f
C38140 _257_ clknet_0_clk 0.03173f
C38141 net55 net4 0.03481f
C38142 _117_ _705_/a_612_127# 0
C38143 rx_inst.bit_index\[0\] _263_ 0.00174f
C38144 net32 rx_inst.state\[4\] 0
C38145 _271_ clknet_4_15_0_clk 0
C38146 _646_/a_38_114# _160_ 0
C38147 hold146/a_438_182# _166_ 0.02313f
C38148 baud_inst.counter\[17\] _684_/a_132_114# 0
C38149 net62 net25 0
C38150 _116_ _702_/a_1785_429# 0
C38151 net179 _065_ 0.622f
C38152 net28 fanout28/a_40_152# 0.00149f
C38153 clknet_4_11_0_clk hold133/a_438_182# 0.00365f
C38154 _135_ _232_ 0.03204f
C38155 _655_/a_38_114# _066_ 0.02005f
C38156 net45 clknet_4_10_0_clk 0.47458f
C38157 _694_/a_1489_191# net107 0
C38158 _637_/a_298_337# rx_inst.data_reg\[6\] 0
C38159 baud_inst.counter\[20\] _693_/a_1583_191# 0.01761f
C38160 _230_ FILLER_24_133/a_32_246# 0
C38161 _163_ _688_/a_1583_191# 0
C38162 baud_inst.counter\[12\] net129 0.03449f
C38163 _678_/a_1583_191# net137 0.00142f
C38164 baud_inst.counter\[23\] _548_/a_76_160# 0.00388f
C38165 net103 FILLER_15_42/a_40_246# 0
C38166 net44 _310_ 0.0316f
C38167 hold163/a_326_118# net163 0.00126f
C38168 _045_ _634_/a_298_337# 0.00925f
C38169 _511_/a_354_412# baud_inst.counter\[4\] 0
C38170 _511_/a_252_412# _282_ 0.00112f
C38171 net39 FILLER_13_68/a_40_246# 0
C38172 _158_ _271_ 0.1192f
C38173 _032_ _703_/a_1583_191# 0
C38174 hold65/a_56_118# net70 0
C38175 hold77/a_56_118# _648_/a_1583_191# 0
C38176 hold62/a_326_118# rx_inst.state\[4\] 0.00156f
C38177 hold89/a_56_118# baud_inst.counter\[14\] 0.00915f
C38178 hold89/a_326_118# baud_inst.counter\[15\] 0.00774f
C38179 hold151/a_56_118# net47 0.00107f
C38180 _633_/a_38_114# _123_ 0.01082f
C38181 net34 _192_ 0
C38182 _175_ net27 0.12187f
C38183 hold154/a_438_182# clknet_0_clk 0.01984f
C38184 net39 _676_/a_324_432# 0.02972f
C38185 net37 FILLER_14_148/a_40_246# 0
C38186 net2 _671_/a_2250_412# 0
C38187 FILLER_25_7/a_40_246# net46 0
C38188 _646_/a_38_114# hold144/a_326_118# 0
C38189 _387_/a_46_156# _148_ 0
C38190 hold101/a_326_118# _302_ 0
C38191 _187_ baud_inst.counter\[14\] 0.02863f
C38192 _097_ _292_ 0.02551f
C38193 hold101/a_56_118# _164_ 0
C38194 _646_/a_550_127# VPWR 0
C38195 baud_inst.counter\[7\] _678_/a_612_127# 0
C38196 input11/a_40_152# tx_inst.state\[3\] 0.0045f
C38197 _671_/a_324_432# _084_ 0.0119f
C38198 VPWR _435_/a_411_436# 0
C38199 net3 _656_/a_612_127# 0
C38200 baud_inst.counter\[18\] _690_/a_843_236# 0.00108f
C38201 net39 _683_/a_324_432# 0
C38202 _550_/a_209_168# _550_/a_380_412# 0
C38203 VPWR _703_/a_1489_191# 0
C38204 clknet_4_14_0_clk FILLER_25_150/a_32_246# 0
C38205 _635_/a_2002_114# _156_ 0
C38206 _425_/a_268_412# _242_ 0
C38207 fanout24/a_40_152# clknet_0_clk 0.00122f
C38208 net26 _433_/a_244_412# 0
C38209 _059_ _633_/a_298_337# 0
C38210 net12 clknet_4_15_0_clk 0.01093f
C38211 _360_/a_382_118# hold165/a_326_118# 0
C38212 _160_ _473_/a_120_432# 0
C38213 FILLER_18_148/a_40_246# net175 0
C38214 net141 clknet_0_clk 0.00385f
C38215 _500_/a_155_412# _019_ 0
C38216 _339_/a_886_118# VPWR 0
C38217 FILLER_26_35/a_32_246# baud_inst.counter\[22\] 0.00108f
C38218 _269_ _650_/a_2250_412# 0
C38219 _250_ net139 0
C38220 _637_/a_38_114# _124_ 0.01456f
C38221 hold136/a_56_118# clknet_4_0_0_clk 0.00145f
C38222 _170_ _433_/a_244_140# 0
C38223 _680_/a_1489_191# VPWR -0
C38224 tx _478_/a_27_156# 0.00366f
C38225 _159_ _633_/a_298_337# 0.00792f
C38226 _045_ net47 0.14295f
C38227 _216_ _217_ 0.98388f
C38228 _053_ _641_/a_612_127# 0
C38229 clknet_4_12_0_clk _641_/a_2250_412# 0
C38230 _539_/a_45_160# _306_ 0.01267f
C38231 FILLER_23_143/a_32_246# net24 0
C38232 hold98/a_56_118# clknet_4_0_0_clk 0
C38233 _305_ _693_/a_843_236# 0
C38234 _023_ _693_/a_741_93# 0
C38235 _341_/a_1023_118# tx_inst.data_reg\[2\] 0
C38236 _705_/a_612_127# net11 0
C38237 baud_inst.counter\[31\] net45 0.07965f
C38238 _172_ _141_ 0
C38239 _306_ _108_ 0.00301f
C38240 _633_/a_1583_191# _648_/a_741_93# 0
C38241 _633_/a_1840_334# _648_/a_324_432# 0
C38242 FILLER_17_201/a_32_246# _647_/a_843_236# 0
C38243 hold151/a_326_118# net49 0.0032f
C38244 hold179/a_438_182# FILLER_1_201/a_40_246# 0.00941f
C38245 _680_/a_132_114# VPWR 0
C38246 tx_inst.data_reg\[4\] _173_ 0.0031f
C38247 hold129/a_326_118# net40 0.00232f
C38248 baud_inst.counter\[15\] _544_/a_46_156# 0.00447f
C38249 _170_ _410_/a_155_412# 0
C38250 hold164/a_438_182# net49 0
C38251 _390_/a_496_118# VPWR 0
C38252 net28 _667_/a_1840_334# 0
C38253 _646_/a_550_127# net144 0
C38254 clknet_0_clk _416_/a_248_122# 0
C38255 _465_/a_120_432# _264_ 0.01023f
C38256 _152_ net50 0.57064f
C38257 net4 _389_/a_46_156# 0.02209f
C38258 clk _654_/a_2250_412# 0
C38259 _663_/a_324_432# _001_ 0.00452f
C38260 VPWR _459_/a_27_156# 0.015f
C38261 baud_inst.counter\[7\] _037_ 0
C38262 hold154/a_438_182# _182_ 0
C38263 hold99/a_56_118# VPWR 0.04013f
C38264 _038_ baud_inst.counter\[9\] 0
C38265 clkbuf_0_clk/a_116_82# net51 0.0924f
C38266 net45 hold149/a_438_182# 0.01302f
C38267 hold143/a_438_182# net47 0
C38268 hold143/a_326_118# _054_ 0
C38269 clknet_4_3_0_clk _142_ 0.42788f
C38270 _206_ _386_/a_382_118# 0.01013f
C38271 tx_inst.bit_index\[1\] _659_/a_1583_191# 0.00314f
C38272 net42 clknet_4_3_0_clk 0.06343f
C38273 _646_/a_741_93# _043_ 0
C38274 _643_/a_1583_191# net143 0
C38275 hold165/a_326_118# net9 0.00247f
C38276 _090_ baud_inst.counter\[6\] 0.00303f
C38277 clknet_0_clk hold92/a_326_118# 0.04876f
C38278 hold53/a_326_118# net45 0.00109f
C38279 tx_inst.state\[1\] _704_/a_681_505# 0
C38280 clknet_4_7_0_clk _704_/a_132_114# 0
C38281 _145_ VPWR 0.40189f
C38282 _019_ net38 0.07652f
C38283 hold145/a_56_118# clknet_0_clk 0.00272f
C38284 hold137/a_438_182# clknet_4_4_0_clk 0.00117f
C38285 baud_inst.counter\[26\] net162 0
C38286 hold121/a_56_118# _692_/a_2250_412# 0
C38287 hold121/a_438_182# _692_/a_1583_191# 0
C38288 hold121/a_326_118# _692_/a_1840_334# 0
C38289 net121 _692_/a_741_93# 0
C38290 _156_ hold84/a_438_182# 0.00238f
C38291 input5/a_40_152# net171 0.00909f
C38292 _464_/a_22_110# _127_ 0.00618f
C38293 _658_/a_741_93# clknet_4_1_0_clk 0
C38294 _661_/a_2250_412# _658_/a_741_93# 0.00295f
C38295 hold102/a_438_182# net40 0
C38296 hold184/a_326_118# hold184/a_438_182# -0
C38297 VPWR _438_/a_350_122# 0
C38298 hold142/a_56_118# net142 0.01566f
C38299 hold142/a_326_118# _110_ 0.01022f
C38300 _279_ net181 0.00255f
C38301 _516_/a_165_412# net129 0.00154f
C38302 net104 _531_/a_209_168# 0.01125f
C38303 hold104/a_56_118# net163 0
C38304 _431_/a_277_118# net48 0
C38305 _241_ _136_ 0.18149f
C38306 net48 _466_/a_120_432# 0
C38307 tx hold172/a_56_118# 0.00565f
C38308 hold162/a_326_118# hold141/a_438_182# 0
C38309 net14 rx_data[5] 0
C38310 _698_/a_1583_191# clknet_0_clk 0.03028f
C38311 _165_ _311_ 0.10018f
C38312 hold162/a_438_182# hold141/a_326_118# 0
C38313 _430_/a_170_412# fanout25/a_40_152# 0
C38314 clkbuf_4_11_0_clk/a_27_118# _116_ 0
C38315 _638_/a_741_93# _273_ 0.01351f
C38316 clknet_4_12_0_clk FILLER_21_147/a_40_246# 0
C38317 tx_inst.state\[1\] _707_/a_324_432# 0
C38318 clknet_4_7_0_clk _707_/a_741_93# 0.02648f
C38319 net13 net30 0.69335f
C38320 hold98/a_326_118# _095_ 0
C38321 clknet_4_6_0_clk _666_/a_741_93# 0.02395f
C38322 _117_ output23/a_40_152# 0
C38323 _646_/a_1840_334# _647_/a_1583_191# 0
C38324 _646_/a_1583_191# _647_/a_1840_334# 0
C38325 hold54/a_438_182# _478_/a_27_156# 0
C38326 _531_/a_177_436# net163 0.00122f
C38327 _418_/a_268_412# _161_ 0
C38328 _292_ net116 0
C38329 _010_ _288_ 0.14596f
C38330 FILLER_14_202/a_40_246# _668_/a_324_432# 0
C38331 _464_/a_22_110# _266_ 0.02672f
C38332 hold170/a_438_182# VPWR 0.03049f
C38333 _675_/a_741_93# hold61/a_438_182# 0
C38334 _675_/a_843_236# hold61/a_326_118# 0
C38335 _225_ _435_/a_411_436# 0
C38336 net2 FILLER_25_141/a_32_246# 0
C38337 baud_inst.counter\[20\] _023_ 0.05571f
C38338 tx_inst.data_reg\[5\] _653_/a_741_93# 0.00378f
C38339 tx_inst.data_reg\[6\] FILLER_1_201/a_40_246# 0.02986f
C38340 _215_ _206_ 0
C38341 net37 _004_ 0
C38342 net49 _688_/a_741_93# 0
C38343 _641_/a_1583_191# net175 0
C38344 _090_ _677_/a_741_93# 0.00666f
C38345 net39 _677_/a_843_236# 0.02847f
C38346 hold100/a_438_182# baud_inst.counter\[25\] 0
C38347 net82 _637_/a_38_114# 0
C38348 FILLER_4_102/a_32_246# _655_/a_1583_191# 0
C38349 net87 _100_ 0.03506f
C38350 net73 _639_/a_741_93# 0
C38351 hold104/a_438_182# _104_ 0
C38352 output17/a_40_152# _637_/a_1583_191# 0
C38353 _674_/a_2250_412# _287_ 0
C38354 hold117/a_438_182# _681_/a_741_93# 0
C38355 hold117/a_326_118# _681_/a_843_236# 0
C38356 clknet_4_3_0_clk _670_/a_298_337# 0
C38357 tx_data[1] input8/a_40_152# 0
C38358 _339_/a_500_118# tx_inst.data_reg\[1\] 0
C38359 net16 _240_ 0.00708f
C38360 _265_ _636_/a_298_337# 0
C38361 _076_ FILLER_6_191/a_32_246# 0
C38362 _168_ _668_/a_38_114# 0
C38363 net109 _682_/a_1583_191# 0.00914f
C38364 net26 net168 0.13634f
C38365 _171_ _200_ 0.00731f
C38366 net44 _538_/a_379_118# 0.00106f
C38367 _556_/a_341_118# VPWR 0
C38368 _694_/a_1583_191# net46 0.00298f
C38369 _352_/a_268_412# baud_inst.counter\[6\] 0
C38370 _459_/a_27_156# _266_ 0.00809f
C38371 _058_ _270_ 0.00146f
C38372 _345_/a_150_412# net45 0
C38373 _531_/a_474_130# _104_ 0
C38374 hold86/a_56_118# _181_ 0.01621f
C38375 hold86/a_326_118# net60 0.0231f
C38376 _673_/a_324_432# _287_ 0.00634f
C38377 _657_/a_843_236# _209_ 0
C38378 _095_ net39 0.06601f
C38379 _102_ _015_ 0
C38380 _163_ _101_ 0
C38381 hold184/a_56_118# net34 0.05852f
C38382 _059_ FILLER_23_186/a_40_246# 0
C38383 hold64/a_326_118# rx_inst.data_reg\[0\] 0
C38384 _292_ net90 0
C38385 _000_ _458_/a_165_412# -0
C38386 hold113/a_438_182# _027_ 0
C38387 net28 _650_/a_324_432# 0.04841f
C38388 _154_ _273_ 0.05628f
C38389 _660_/a_843_236# _206_ 0.03622f
C38390 net159 tx_inst.data_reg\[1\] 0.17186f
C38391 _077_ _201_ 0.01084f
C38392 net108 _502_/a_279_412# 0
C38393 net102 _526_/a_248_122# 0
C38394 _017_ _526_/a_350_122# 0
C38395 hold102/a_326_118# net101 0
C38396 _431_/a_81_118# _249_ 0.00698f
C38397 FILLER_17_22/a_40_246# baud_inst.counter\[17\] 0
C38398 rx_inst.data_reg\[2\] net78 0
C38399 _466_/a_22_110# _157_ 0.01104f
C38400 net138 _635_/a_1785_429# 0
C38401 clknet_4_15_0_clk _648_/a_843_236# 0
C38402 _644_/a_132_114# net48 0
C38403 net21 _665_/a_843_236# 0.02564f
C38404 baud_inst.counter\[17\] _299_ 0.00124f
C38405 _214_ net9 0
C38406 hold58/a_438_182# hold59/a_56_118# 0
C38407 hold147/a_56_118# _303_ 0
C38408 FILLER_16_203/a_32_246# _061_ 0
C38409 net21 _166_ 0
C38410 _688_/a_298_337# net157 0
C38411 hold135/a_438_182# _673_/a_1583_191# 0
C38412 _460_/a_22_110# net43 0
C38413 _116_ _115_ 0
C38414 _262_ net25 0.01835f
C38415 tx_inst.data_reg\[5\] _652_/a_1583_191# 0
C38416 FILLER_5_164/a_40_246# _218_ 0
C38417 _408_/a_154_118# clknet_0_clk 0
C38418 _158_ _648_/a_843_236# 0
C38419 hold141/a_326_118# _025_ 0.00141f
C38420 hold141/a_438_182# _310_ 0.05448f
C38421 VPWR hold93/a_438_182# 0.00478f
C38422 net44 _528_/a_81_118# 0
C38423 _645_/a_681_505# net48 0
C38424 _553_/a_170_412# net107 0.00111f
C38425 baud_inst.counter\[20\] _693_/a_2002_114# 0
C38426 FILLER_1_90/a_32_246# tx_data[7] 0.02272f
C38427 baud_inst.counter\[10\] FILLER_8_35/a_32_246# 0
C38428 _096_ _682_/a_1840_334# 0.00341f
C38429 _163_ _688_/a_2002_114# 0
C38430 _270_ _636_/a_1583_191# 0
C38431 _125_ _636_/a_132_114# 0
C38432 baud_inst.counter\[23\] _312_ 0.05379f
C38433 hold67/a_438_182# _115_ 0
C38434 hold161/a_438_182# hold157/a_438_182# 0.00882f
C38435 _109_ net162 0.00568f
C38436 net65 rx_inst.data_reg\[5\] 0
C38437 hold170/a_326_118# net179 0
C38438 tx_inst.data_reg\[6\] hold179/a_438_182# 0.00175f
C38439 hold159/a_326_118# _211_ 0
C38440 _045_ _634_/a_1583_191# 0
C38441 FILLER_25_7/a_40_246# fanout49/a_40_152# 0.00536f
C38442 _032_ _703_/a_2002_114# 0
C38443 hold69/a_438_182# _264_ 0
C38444 hold148/a_56_118# _105_ 0
C38445 _646_/a_298_337# net47 0
C38446 fanout35/a_40_152# _406_/a_154_118# 0
C38447 net55 _366_/a_170_412# 0
C38448 _098_ _494_/a_165_412# 0.00102f
C38449 hold77/a_326_118# _648_/a_1489_191# 0
C38450 _633_/a_1840_334# _123_ 0
C38451 _480_/a_22_110# _005_ 0
C38452 _069_ _657_/a_843_236# 0
C38453 hold153/a_438_182# _284_ 0
C38454 _152_ _705_/a_38_114# 0.02437f
C38455 tx_inst.bit_index\[0\] clkbuf_4_6_0_clk/a_27_118# 0
C38456 net28 FILLER_14_164/a_32_246# 0
C38457 _112_ net99 0
C38458 _002_ net26 1.20531f
C38459 net55 net40 0.01798f
C38460 _265_ net19 0.08153f
C38461 baud_inst.counter\[7\] net93 0.02594f
C38462 _421_/a_252_412# _236_ 0.00178f
C38463 _305_ _701_/a_38_114# 0.00303f
C38464 FILLER_5_32/a_40_246# net38 0.00507f
C38465 hold93/a_326_118# hold93/a_438_182# 0
C38466 _287_ net29 0.18614f
C38467 _238_ clknet_0_clk 0
C38468 _653_/a_2250_412# _222_ 0
C38469 _509_/a_155_412# net29 0.00302f
C38470 FILLER_16_166/a_32_246# hold62/a_438_182# 0
C38471 _342_/a_170_412# net34 0
C38472 hold178/a_56_118# _684_/a_741_93# 0.00324f
C38473 _180_ FILLER_14_72/a_32_246# 0
C38474 _148_ net38 0
C38475 hold152/a_326_118# _063_ 0.00115f
C38476 _638_/a_298_337# VPWR 0.0061f
C38477 _639_/a_298_337# net81 0.02719f
C38478 _639_/a_38_114# _050_ 0.04217f
C38479 _059_ _633_/a_1583_191# 0
C38480 FILLER_16_176/a_40_246# VPWR 0.12895f
C38481 _160_ _273_ 0.34165f
C38482 _691_/a_132_114# VPWR 0
C38483 clknet_4_4_0_clk _220_ 0
C38484 FILLER_9_79/a_32_246# _499_/a_380_412# 0
C38485 _438_/a_248_122# _252_ -0
C38486 net38 FILLER_6_54/a_32_246# 0.01854f
C38487 _399_/a_154_118# _651_/a_38_114# 0
C38488 _159_ _633_/a_1583_191# 0
C38489 hold155/a_438_182# net155 0.00145f
C38490 _053_ net176 0.00695f
C38491 _132_ _052_ 0
C38492 _706_/a_843_236# _200_ 0
C38493 _706_/a_132_114# net172 0
C38494 _265_ hold51/a_326_118# 0
C38495 FILLER_16_56/a_32_246# _687_/a_741_93# 0
C38496 _305_ _693_/a_612_127# 0
C38497 net48 _649_/a_681_505# 0
C38498 _022_ _107_ 0
C38499 _643_/a_38_114# net24 0.05174f
C38500 rx_inst.bit_index\[1\] _261_ 0.00543f
C38501 net179 VPWR 0.21753f
C38502 _216_ _667_/a_843_236# 0
C38503 _230_ _642_/a_1840_334# 0.00374f
C38504 _661_/a_324_432# _209_ 0.00176f
C38505 _465_/a_120_432# _269_ 0.00221f
C38506 _465_/a_22_110# net73 0.01315f
C38507 _633_/a_2250_412# _648_/a_1840_334# 0
C38508 hold53/a_438_182# _052_ 0
C38509 net39 _102_ 0.34758f
C38510 baud_inst.counter\[14\] _025_ 0.00176f
C38511 _170_ _229_ 0
C38512 _231_ _228_ 0.07614f
C38513 _227_ rx_inst.state\[2\] 0.21146f
C38514 _643_/a_741_93# _273_ 0
C38515 baud_inst.counter\[13\] clknet_4_9_0_clk 0.04305f
C38516 _012_ FILLER_13_68/a_40_246# 0.00302f
C38517 fanout43/a_40_152# _204_ 0
C38518 net49 _703_/a_324_432# 0.03364f
C38519 hold100/a_438_182# baud_inst.counter\[24\] 0
C38520 _655_/a_38_114# FILLER_2_79/a_40_246# 0
C38521 _641_/a_843_236# VPWR 0
C38522 _656_/a_1840_334# net41 0
C38523 _269_ _264_ 0.13924f
C38524 _236_ net24 0.8923f
C38525 fanout36/a_40_152# _161_ 0.00737f
C38526 hold61/a_56_118# net38 0.06496f
C38527 _513_/a_192_429# VPWR 0.01645f
C38528 net114 _312_ 0.0011f
C38529 _376_/a_76_160# _166_ 0.0038f
C38530 hold162/a_56_118# _110_ 0
C38531 FILLER_27_194/a_40_246# _633_/a_843_236# 0.0026f
C38532 _148_ _383_/a_268_412# 0
C38533 _673_/a_324_432# clkbuf_4_0_0_clk/a_27_118# 0
C38534 hold126/a_326_118# net71 0.00105f
C38535 hold126/a_56_118# _268_ 0
C38536 _680_/a_843_236# _181_ 0
C38537 _657_/a_843_236# clknet_4_4_0_clk 0.00213f
C38538 _129_ _457_/a_120_432# 0
C38539 _265_ _457_/a_22_110# 0
C38540 net12 _637_/a_2250_412# 0
C38541 VPWR _647_/a_843_236# 0.00669f
C38542 clk FILLER_0_174/a_32_246# 0
C38543 _091_ net137 0.00175f
C38544 _639_/a_843_236# FILLER_16_221/a_32_246# 0
C38545 net41 _382_/a_382_118# 0.00125f
C38546 _388_/a_285_412# net165 0.00384f
C38547 _388_/a_59_156# _146_ 0.02362f
C38548 FILLER_15_185/a_32_246# _168_ 0
C38549 _260_ VPWR 0.06079f
C38550 _092_ net152 0
C38551 net57 VPWR 0.02288f
C38552 hold89/a_438_182# clknet_4_8_0_clk 0
C38553 hold76/a_438_182# _305_ 0
C38554 hold76/a_326_118# _023_ 0.01933f
C38555 net122 FILLER_11_134/a_32_246# 0
C38556 _077_ tx_inst.state\[3\] 0.02243f
C38557 _339_/a_382_118# _172_ 0.00113f
C38558 _360_/a_295_385# tx_inst.data_reg\[0\] 0.00777f
C38559 _696_/a_741_93# _024_ 0
C38560 net6 input10/a_40_152# 0.00744f
C38561 _661_/a_324_432# _069_ 0
C38562 _206_ _659_/a_681_505# 0
C38563 hold54/a_326_118# net54 0.00791f
C38564 baud_inst.counter\[5\] _142_ 0.06627f
C38565 clkbuf_4_7_0_clk/a_27_118# _668_/a_1489_191# 0
C38566 net42 baud_inst.counter\[5\] 0.03961f
C38567 VPWR _252_ 0.1445f
C38568 _206_ _120_ 0
C38569 net129 _012_ 0.17134f
C38570 rx_inst.data_reg\[3\] net30 0
C38571 net36 _452_/a_155_412# 0
C38572 rx_inst.bit_index\[1\] _452_/a_257_140# 0.00202f
C38573 hold156/a_438_182# net39 0.01536f
C38574 hold157/a_326_118# _690_/a_324_432# 0
C38575 hold157/a_56_118# _690_/a_741_93# 0
C38576 _693_/a_132_114# net149 0
C38577 net116 _289_ 0.00719f
C38578 _064_ _143_ 0.09166f
C38579 net50 net168 0
C38580 net146 _200_ 0.08677f
C38581 _698_/a_2002_114# clknet_0_clk 0
C38582 _043_ net24 0
C38583 net36 clknet_0_clk 0.05436f
C38584 _695_/a_1583_191# _296_ 0.00133f
C38585 _074_ net43 0.00244f
C38586 _519_/a_379_118# _292_ 0.00402f
C38587 hold119/a_326_118# _168_ 0
C38588 _013_ FILLER_17_79/a_40_246# 0
C38589 hold139/a_56_118# _137_ 0.01944f
C38590 hold139/a_326_118# _247_ 0
C38591 _638_/a_298_337# _266_ 0.02247f
C38592 _438_/a_146_122# _236_ 0.00242f
C38593 _638_/a_38_114# net30 0.01603f
C38594 FILLER_22_133/a_40_246# net24 0.03359f
C38595 _547_/a_175_118# net113 0.00348f
C38596 _080_ _204_ 0.00152f
C38597 hold88/a_438_182# _292_ 0
C38598 clknet_4_13_0_clk _650_/a_1489_191# 0.00163f
C38599 net163 _020_ 0.02987f
C38600 _640_/a_843_236# net52 0
C38601 _640_/a_2250_412# _455_/a_155_412# 0
C38602 net38 _681_/a_132_114# 0
C38603 _206_ _664_/a_741_93# 0.00966f
C38604 FILLER_8_14/a_32_246# net117 0.00137f
C38605 net173 _219_ 0.16461f
C38606 VPWR FILLER_8_19/a_40_246# 0.12476f
C38607 _675_/a_132_114# net61 0
C38608 _675_/a_1583_191# _033_ 0
C38609 _277_ fanout37/a_40_152# 0
C38610 baud_inst.counter\[14\] FILLER_17_79/a_40_246# 0.00124f
C38611 FILLER_16_176/a_40_246# _167_ 0.03124f
C38612 rx_inst.data_reg\[0\] FILLER_21_229/a_32_246# 0
C38613 _651_/a_2250_412# net43 0
C38614 _661_/a_324_432# _207_ 0
C38615 _661_/a_843_236# net55 0.00724f
C38616 clkbuf_4_0_0_clk/a_27_118# net29 0.0593f
C38617 net145 _386_/a_382_118# 0.02119f
C38618 _690_/a_38_114# _527_/a_341_118# 0
C38619 _536_/a_192_429# _693_/a_38_114# 0
C38620 tx_inst.data_reg\[2\] net170 0
C38621 clknet_4_4_0_clk _208_ 0
C38622 rx_inst.bit_index\[2\] FILLER_25_163/a_32_246# 0.01804f
C38623 _154_ clkbuf_4_14_0_clk/a_27_118# 0.00182f
C38624 _090_ _677_/a_1785_429# 0.00239f
C38625 _412_/a_120_432# net28 0.00931f
C38626 net49 _450_/a_127_436# 0
C38627 _246_ FILLER_18_158/a_40_246# 0.00302f
C38628 _177_ net45 0.02495f
C38629 baud_inst.counter\[26\] _111_ 0.0031f
C38630 net168 FILLER_5_181/a_32_246# 0.0013f
C38631 net118 _061_ 0.01744f
C38632 hold152/a_326_118# _089_ 0.00123f
C38633 hold63/a_438_182# _667_/a_298_337# 0
C38634 clknet_4_12_0_clk _054_ 0.01369f
C38635 _641_/a_741_93# _641_/a_843_236# 0
C38636 _194_ hold173/a_438_182# 0
C38637 _677_/a_843_236# _676_/a_843_236# 0
C38638 net39 _357_/a_252_412# 0
C38639 _694_/a_741_93# _302_ 0.05575f
C38640 hold55/a_438_182# net50 0
C38641 hold161/a_438_182# net40 0
C38642 _645_/a_741_93# net151 0
C38643 net48 hold127/a_56_118# 0.00857f
C38644 _549_/a_155_412# _027_ 0.01531f
C38645 _643_/a_550_127# clknet_4_12_0_clk 0
C38646 baud_inst.counter\[20\] _695_/a_324_432# 0.00516f
C38647 net109 _682_/a_2002_114# 0
C38648 _699_/a_324_432# clknet_4_8_0_clk 0.0019f
C38649 net44 _306_ 0.01242f
C38650 _184_ VPWR 0.02244f
C38651 _110_ net141 0
C38652 _224_ _435_/a_72_436# 0.01214f
C38653 net2 _450_/a_398_96# 0.00118f
C38654 _226_ _227_ 0.05463f
C38655 _673_/a_2250_412# _287_ 0.00347f
C38656 _657_/a_612_127# _209_ 0
C38657 hold177/a_56_118# _189_ 0
C38658 tx_inst.bit_index\[1\] _222_ 0
C38659 _643_/a_298_337# VPWR 0.00949f
C38660 _153_ _264_ 0
C38661 tx_inst.data_reg\[7\] _656_/a_38_114# 0
C38662 _287_ hold95/a_438_182# 0.00473f
C38663 rx_done _117_ 0
C38664 net44 FILLER_15_116/a_40_246# 0
C38665 _378_/a_285_118# net38 0
C38666 _660_/a_612_127# _206_ 0.00887f
C38667 hold160/a_326_118# net160 0.00201f
C38668 hold160/a_56_118# _296_ 0.0111f
C38669 _017_ _300_ 0.36233f
C38670 net35 _136_ 0.00105f
C38671 _217_ _395_/a_248_122# 0
C38672 net46 hold90/a_56_118# 0.06761f
C38673 _243_ FILLER_25_163/a_32_246# 0.00229f
C38674 net79 hold181/a_438_182# 0.01236f
C38675 _219_ FILLER_7_146/a_32_246# 0
C38676 hold110/a_326_118# clknet_4_2_0_clk 0
C38677 clk _339_/a_382_118# 0.03228f
C38678 net21 _665_/a_612_127# 0
C38679 tx_inst.bit_index\[0\] fanout34/a_40_152# 0
C38680 hold98/a_56_118# _096_ 0
C38681 hold101/a_438_182# baud_inst.counter\[17\] 0.01298f
C38682 net37 _404_/a_268_412# 0.00126f
C38683 rx_inst.state\[2\] _242_ 0
C38684 FILLER_19_132/a_40_246# clknet_0_clk 0.00163f
C38685 net121 _021_ 0.01191f
C38686 _182_ _503_/a_279_412# 0
C38687 net34 net168 0.00592f
C38688 _173_ _396_/a_155_412# 0
C38689 hold101/a_326_118# _688_/a_298_337# 0
C38690 _658_/a_1489_191# net41 0
C38691 net28 _456_/a_155_412# 0.00662f
C38692 VPWR FILLER_9_72/a_32_246# 0.06617f
C38693 net79 FILLER_0_54/a_40_246# 0.02123f
C38694 _041_ _204_ 0.17116f
C38695 net54 _665_/a_38_114# 0
C38696 _063_ _280_ 0
C38697 fanout27/a_40_152# VPWR 0.09635f
C38698 _685_/a_681_505# net29 0
C38699 _225_ _260_ 0
C38700 _431_/a_81_118# clknet_4_12_0_clk 0
C38701 net75 _695_/a_298_337# 0.00811f
C38702 _645_/a_550_127# net48 0
C38703 FILLER_15_67/a_40_246# VPWR 0.13443f
C38704 VPWR net60 0.30407f
C38705 _125_ _636_/a_1489_191# 0.01322f
C38706 net37 fanout31/a_40_152# 0.00176f
C38707 net44 _527_/a_341_118# 0
C38708 net173 tx_inst.bit_index\[2\] 0.07673f
C38709 _240_ _635_/a_38_114# 0
C38710 clknet_4_5_0_clk _665_/a_843_236# 0.01685f
C38711 baud_inst.counter\[7\] clknet_4_1_0_clk 0.02008f
C38712 _653_/a_298_337# VPWR 0
C38713 _488_/a_209_168# _145_ 0
C38714 hold116/a_438_182# baud_inst.counter\[9\] 0.00148f
C38715 net62 _667_/a_1583_191# 0
C38716 net26 FILLER_14_148/a_40_246# 0
C38717 VPWR _049_ 0.05363f
C38718 clknet_4_5_0_clk _166_ 0
C38719 _202_ _120_ 0
C38720 _201_ net43 0
C38721 net56 _651_/a_38_114# 0.00213f
C38722 _124_ hold82/a_56_118# 0
C38723 clkload0/Y hold128/a_56_118# 0.00129f
C38724 clknet_4_7_0_clk _078_ 0.00154f
C38725 clknet_0_clk _668_/a_843_236# 0
C38726 hold110/a_56_118# _683_/a_38_114# 0
C38727 _290_ net29 0.00297f
C38728 _689_/a_298_337# net40 0
C38729 hold124/a_56_118# net72 0.08563f
C38730 hold124/a_326_118# _048_ 0
C38731 net178 _684_/a_843_236# 0.00629f
C38732 _638_/a_1583_191# VPWR 0.01305f
C38733 _679_/a_324_432# _679_/a_741_93# 0
C38734 _639_/a_1840_334# _050_ -0
C38735 _465_/a_22_110# hold138/a_56_118# 0
C38736 baud_inst.counter\[21\] _692_/a_741_93# 0
C38737 hold125/a_56_118# net30 0
C38738 _691_/a_1489_191# VPWR 0.00515f
C38739 FILLER_22_54/a_40_246# clknet_0_clk 0
C38740 hold66/a_438_182# clknet_0_clk 0
C38741 FILLER_16_203/a_32_246# _156_ 0
C38742 _073_ _369_/a_146_122# 0
C38743 hold154/a_56_118# _293_ 0
C38744 FILLER_23_204/a_40_246# net30 0
C38745 _696_/a_741_93# baud_inst.counter\[25\] 0
C38746 rx_inst.state\[3\] _667_/a_298_337# 0
C38747 _159_ _633_/a_2002_114# 0
C38748 clknet_0_clk _648_/a_741_93# 0
C38749 _238_ FILLER_26_172/a_40_246# 0
C38750 hold138/a_326_118# _264_ 0.04554f
C38751 _089_ net153 0
C38752 _706_/a_612_127# _200_ 0.0083f
C38753 FILLER_13_228/a_40_246# hold80/a_56_118# 0.00786f
C38754 _058_ net25 0.0491f
C38755 _046_ net30 0.1567f
C38756 net47 net64 0
C38757 _658_/a_843_236# _388_/a_382_118# 0
C38758 _093_ hold136/a_56_118# 0
C38759 hold109/a_438_182# net97 0.04692f
C38760 clknet_4_1_0_clk _209_ 0.00178f
C38761 _428_/a_354_412# VPWR 0
C38762 net156 _295_ 0
C38763 _410_/a_155_412# hold180/a_326_118# 0
C38764 _643_/a_1785_429# _273_ 0.00118f
C38765 _207_ tx_data[7] 0.00604f
C38766 hold86/a_326_118# _019_ 0
C38767 tx_inst.bit_index\[2\] FILLER_7_146/a_32_246# 0
C38768 _639_/a_324_432# hold80/a_56_118# 0.00352f
C38769 _672_/a_324_432# hold60/a_56_118# 0
C38770 net49 _703_/a_2250_412# 0.01452f
C38771 _705_/a_324_432# net172 0
C38772 _705_/a_298_337# _200_ 0
C38773 _191_ _063_ 0
C38774 _643_/a_298_337# _266_ 0
C38775 hold57/a_438_182# net183 0.00446f
C38776 hold57/a_56_118# _221_ 0
C38777 net152 hold92/a_326_118# 0.00634f
C38778 hold108/a_56_118# net29 0.00185f
C38779 _022_ hold147/a_438_182# 0.00847f
C38780 FILLER_15_127/a_32_246# VPWR 0.07316f
C38781 net61 _085_ 0
C38782 _652_/a_843_236# VPWR 0.00586f
C38783 baud_inst.counter\[13\] _162_ 0
C38784 _188_ _688_/a_1583_191# 0
C38785 _644_/a_741_93# rx_inst.bit_index\[2\] 0
C38786 net79 net135 1.09133f
C38787 _314_ hold107/a_56_118# 0.01322f
C38788 hold112/a_438_182# hold127/a_438_182# 0
C38789 _078_ _007_ 0.00175f
C38790 net123 hold128/a_438_182# 0
C38791 _127_ _049_ 0
C38792 hold170/a_56_118# clk 0.00347f
C38793 _673_/a_132_114# clknet_0_clk 0
C38794 hold167/a_56_118# net167 0
C38795 hold167/a_326_118# _002_ 0.00534f
C38796 VPWR _647_/a_612_127# 0.00246f
C38797 _245_ _421_/a_354_412# 0
C38798 clknet_0_clk _667_/a_324_432# 0
C38799 net73 _156_ 0
C38800 net49 net175 0.00279f
C38801 FILLER_8_21/a_32_246# net40 0
C38802 _678_/a_550_127# clknet_0_clk 0
C38803 net156 clknet_4_2_0_clk 0.18026f
C38804 baud_inst.counter\[28\] FILLER_27_46/a_32_246# 0.00107f
C38805 net37 _168_ 1.22777f
C38806 baud_inst.counter\[12\] _189_ 0.91163f
C38807 _083_ FILLER_13_89/a_40_246# 0
C38808 _277_ clkbuf_4_6_0_clk/a_27_118# 0
C38809 net45 VPWR 1.77339f
C38810 _462_/a_22_110# rx_inst.data_reg\[6\] 0.05827f
C38811 _679_/a_1840_334# baud_inst.counter\[6\] 0
C38812 _062_ _216_ 0.0819f
C38813 _488_/a_177_436# VPWR 0
C38814 _339_/a_810_118# _172_ 0
C38815 _696_/a_843_236# _180_ 0.04874f
C38816 _360_/a_500_118# tx_inst.data_reg\[0\] 0.00106f
C38817 _699_/a_298_337# clknet_4_10_0_clk 0
C38818 net2 net24 0.03355f
C38819 tx_inst.data_reg\[7\] _658_/a_132_114# 0
C38820 _661_/a_2250_412# _069_ 0
C38821 _069_ clknet_4_1_0_clk 0.23927f
C38822 net66 rx_inst.data_reg\[0\] 0.22268f
C38823 _147_ _382_/a_496_118# 0.00117f
C38824 _227_ FILLER_19_149/a_40_246# 0
C38825 _049_ _266_ 0.24759f
C38826 hold53/a_326_118# _051_ 0
C38827 tx_inst.data_reg\[6\] _360_/a_805_385# 0
C38828 _644_/a_741_93# _243_ 0
C38829 hold76/a_56_118# _695_/a_741_93# 0
C38830 hold76/a_438_182# _695_/a_38_114# 0
C38831 _433_/a_244_412# _137_ 0.00134f
C38832 _089_ _280_ 0.01707f
C38833 _189_ net88 0.00185f
C38834 clkload3/Y net24 0
C38835 hold183/a_438_182# net34 0.00265f
C38836 _673_/a_38_114# net86 0
C38837 _673_/a_324_432# net181 0.03789f
C38838 _448_/a_142_412# _160_ 0.02561f
C38839 _288_ _287_ 0.0023f
C38840 _166_ _001_ 0.00913f
C38841 net26 FILLER_17_131/a_32_246# 0
C38842 _168_ _650_/a_298_337# 0.01162f
C38843 net82 hold82/a_56_118# 0.00234f
C38844 _638_/a_1840_334# net30 0.00181f
C38845 _638_/a_1583_191# _266_ 0
C38846 tx_inst.data_reg\[1\] _653_/a_843_236# 0
C38847 _509_/a_155_412# _288_ 0.0043f
C38848 net92 FILLER_9_70/a_40_246# 0
C38849 rx_inst.data_reg\[3\] _647_/a_2250_412# 0
C38850 clknet_4_13_0_clk rx_inst.data_reg\[7\] 1.03904f
C38851 net38 _681_/a_1489_191# 0
C38852 baud_inst.counter\[12\] hold129/a_438_182# 0.00423f
C38853 net128 hold129/a_326_118# 0
C38854 _690_/a_298_337# net101 0.01623f
C38855 _690_/a_1583_191# net103 0.00187f
C38856 rx_data[4] _636_/a_681_505# 0
C38857 _314_ _694_/a_324_432# 0
C38858 _043_ net30 0.05337f
C38859 _206_ _664_/a_1785_429# 0
C38860 _705_/a_612_127# hold50/a_56_118# 0
C38861 _675_/a_1489_191# net61 0
C38862 _706_/a_1840_334# _042_ 0.01134f
C38863 net39 FILLER_10_78/a_32_246# 0
C38864 FILLER_26_227/a_40_246# _637_/a_843_236# 0
C38865 _004_ net26 0.00107f
C38866 _055_ hold151/a_56_118# 0
C38867 _661_/a_612_127# net55 0.0015f
C38868 hold90/a_56_118# _685_/a_741_93# 0
C38869 clknet_4_12_0_clk _649_/a_741_93# 0
C38870 net120 _693_/a_324_432# 0.00755f
C38871 _022_ _693_/a_298_337# 0
C38872 FILLER_1_67/a_40_246# _672_/a_2250_412# 0.01012f
C38873 _017_ net160 0
C38874 _662_/a_38_114# net43 0.00449f
C38875 _662_/a_298_337# _120_ 0
C38876 net98 net109 0
C38877 _009_ _292_ 0
C38878 _353_/a_350_122# _186_ 0
C38879 net39 net154 0
C38880 net125 VPWR 0.01275f
C38881 FILLER_12_89/a_40_246# net154 0
C38882 _231_ net28 0.06275f
C38883 _004_ net32 0
C38884 net150 clknet_4_14_0_clk 0
C38885 net43 tx_inst.state\[3\] 0
C38886 net73 _050_ 0
C38887 net49 _161_ 0.03633f
C38888 _070_ _149_ 0.00654f
C38889 hold117/a_326_118# net117 0.003f
C38890 _286_ _505_/a_76_160# 0
C38891 _079_ _667_/a_843_236# 0.00232f
C38892 _661_/a_298_337# VPWR 0.00327f
C38893 net42 clknet_0_clk 0.79264f
C38894 hold131/a_326_118# _429_/a_142_412# 0
C38895 _133_ VPWR 0.05169f
C38896 hold144/a_56_118# _448_/a_244_412# 0
C38897 hold173/a_56_118# _195_ 0.00636f
C38898 net39 _189_ 0.00565f
C38899 fanout41/a_40_152# net41 0.03815f
C38900 baud_inst.counter\[8\] _039_ 0.00104f
C38901 _555_/a_380_412# hold114/a_56_118# 0
C38902 _360_/a_886_118# VPWR 0.01122f
C38903 _010_ clknet_4_2_0_clk 0
C38904 _101_ net157 0.00623f
C38905 _635_/a_324_432# clknet_0_clk 0
C38906 _193_ _364_/a_155_412# 0.00662f
C38907 net184 FILLER_3_177/a_32_246# 0
C38908 hold145/a_438_182# _659_/a_2250_412# 0.00887f
C38909 hold116/a_326_118# net29 0
C38910 _269_ _153_ 0
C38911 _696_/a_38_114# _309_ 0
C38912 _696_/a_741_93# baud_inst.counter\[24\] 0.00443f
C38913 hold99/a_56_118# _052_ 0.00533f
C38914 net159 _066_ 0.00138f
C38915 _147_ _209_ 0.03217f
C38916 _277_ hold62/a_438_182# 0
C38917 _513_/a_192_429# _163_ 0.00513f
C38918 _639_/a_843_236# _047_ 0
C38919 hold105/a_326_118# _701_/a_2250_412# 0
C38920 hold105/a_438_182# _701_/a_1840_334# 0
C38921 _663_/a_132_114# VPWR 0
C38922 net26 _669_/a_1583_191# 0.00144f
C38923 net121 hold149/a_56_118# 0.00574f
C38924 _643_/a_1583_191# VPWR 0.00894f
C38925 FILLER_8_92/a_32_246# _282_ 0.00191f
C38926 net108 net29 1.14146f
C38927 _151_ net38 0
C38928 clknet_4_1_0_clk clknet_4_4_0_clk 0.13309f
C38929 baud_inst.counter\[20\] net107 0.02018f
C38930 net166 net29 0.68266f
C38931 _672_/a_741_93# FILLER_0_54/a_40_246# 0.00125f
C38932 net29 net181 0.02898f
C38933 baud_inst.counter\[8\] _682_/a_1583_191# 0
C38934 _089_ _191_ 0.01706f
C38935 _099_ net90 0
C38936 rx_inst.data_reg\[1\] net48 0.19881f
C38937 _641_/a_324_432# _111_ 0
C38938 _046_ hold74/a_326_118# 0
C38939 net13 _634_/a_38_114# 0
C38940 _642_/a_1583_191# net25 0
C38941 clknet_4_10_0_clk _105_ 0.02342f
C38942 rst net1 0.04421f
C38943 net48 _446_/a_248_122# 0
C38944 tx_inst.state\[4\] _217_ 0
C38945 _286_ _092_ 0.00417f
C38946 net42 _386_/a_59_156# 0
C38947 _671_/a_324_432# clknet_4_6_0_clk 0.00659f
C38948 baud_inst.counter\[18\] _688_/a_741_93# 0
C38949 net75 _303_ 0.00124f
C38950 net28 _264_ 0.00123f
C38951 output16/a_40_152# _157_ 0
C38952 _409_/a_73_118# VPWR 0.06449f
C38953 _654_/a_1840_334# FILLER_1_212/a_32_246# 0
C38954 net54 _665_/a_1840_334# 0.04222f
C38955 _010_ _683_/a_298_337# 0
C38956 _142_ _182_ 0
C38957 _292_ _683_/a_38_114# 0.01156f
C38958 _685_/a_550_127# net29 0
C38959 net75 _695_/a_1583_191# 0
C38960 _305_ _695_/a_132_114# 0
C38961 net35 rx_inst.bit_index\[2\] 0.0803f
C38962 _442_/a_350_122# VPWR 0
C38963 _674_/a_38_114# net38 0.00658f
C38964 baud_inst.counter\[11\] clknet_4_2_0_clk 0
C38965 _516_/a_165_412# _189_ 0.00506f
C38966 _411_/a_494_160# _161_ 0
C38967 _248_ VPWR 0.07441f
C38968 _680_/a_324_432# _489_/a_115_308# 0
C38969 _101_ _298_ 0
C38970 hold120/a_326_118# baud_inst.counter\[23\] 0
C38971 hold120/a_56_118# baud_inst.counter\[22\] 0.07588f
C38972 _198_ _275_ 0
C38973 fanout43/a_40_152# VPWR 0.01472f
C38974 clknet_4_5_0_clk _665_/a_612_127# 0.00503f
C38975 _653_/a_1583_191# VPWR 0.01431f
C38976 _701_/a_324_432# baud_inst.counter\[29\] 0
C38977 _448_/a_244_140# _043_ 0
C38978 _548_/a_76_160# _296_ 0.00575f
C38979 baud_inst.counter\[31\] _698_/a_324_432# 0
C38980 _670_/a_298_337# clknet_0_clk 0.00317f
C38981 FILLER_29_221/a_32_246# VPWR 0.06863f
C38982 _114_ _302_ 0.00804f
C38983 tx_inst.bit_index\[1\] _339_/a_295_385# 0.01124f
C38984 _680_/a_38_114# _681_/a_741_93# 0
C38985 _680_/a_298_337# _681_/a_843_236# 0.00117f
C38986 net50 _705_/a_550_127# 0
C38987 hold154/a_438_182# _035_ 0.00379f
C38988 _460_/a_22_110# net51 0.00113f
C38989 _141_ _651_/a_681_505# 0
C38990 clknet_4_3_0_clk net39 0.39743f
C38991 input10/a_40_152# net8 0
C38992 _684_/a_843_236# _297_ 0
C38993 hold74/a_56_118# _126_ 0.04593f
C38994 rx_data[1] net47 0.01462f
C38995 _059_ clknet_0_clk 0.07338f
C38996 hold115/a_56_118# baud_inst.counter\[9\] 0.06935f
C38997 net110 _683_/a_324_432# 0.00283f
C38998 _689_/a_1583_191# net40 0.01175f
C38999 rx VPWR 0.24544f
C39000 _555_/a_209_168# _551_/a_76_160# 0
C39001 net178 _684_/a_612_127# 0.00433f
C39002 _637_/a_298_337# rx_inst.data_reg\[5\] 0
C39003 net72 _648_/a_324_432# 0
C39004 net85 hold111/a_326_118# 0.0026f
C39005 _216_ FILLER_7_176/a_32_246# 0
C39006 _638_/a_2002_114# VPWR 0
C39007 tx_start _275_ 0
C39008 _639_/a_1489_191# clknet_4_13_0_clk 0
C39009 net71 _649_/a_1840_334# 0
C39010 _268_ _649_/a_1583_191# 0.00387f
C39011 _246_ _436_/a_244_140# 0
C39012 net35 _243_ 0
C39013 _201_ _664_/a_2250_412# 0
C39014 _203_ _664_/a_1840_334# 0
C39015 FILLER_18_160/a_32_246# FILLER_18_158/a_40_246# 0.0524f
C39016 _683_/a_741_93# _096_ 0.00121f
C39017 net89 _687_/a_681_505# 0
C39018 _119_ _200_ 0.03431f
C39019 _240_ _650_/a_324_432# 0
C39020 _047_ FILLER_19_228/a_40_246# 0
C39021 hold125/a_438_182# _154_ 0
C39022 _694_/a_741_93# FILLER_22_32/a_40_246# 0
C39023 _658_/a_741_93# net165 0
C39024 _547_/a_379_118# _311_ 0.00202f
C39025 _245_ VPWR 0.11288f
C39026 _160_ _154_ 0.00236f
C39027 _659_/a_324_432# _657_/a_298_337# 0
C39028 _659_/a_298_337# _657_/a_324_432# 0
C39029 _166_ _199_ 0
C39030 baud_inst.counter\[13\] hold91/a_56_118# 0
C39031 _229_ hold180/a_326_118# 0.04112f
C39032 hold100/a_438_182# _697_/a_38_114# 0
C39033 hold100/a_326_118# _697_/a_324_432# 0
C39034 hold165/a_438_182# _206_ 0
C39035 _392_/a_382_118# clknet_4_4_0_clk 0
C39036 _639_/a_741_93# net80 0.00221f
C39037 hold87/a_326_118# net87 0.00391f
C39038 FILLER_2_110/a_32_246# _151_ 0
C39039 FILLER_4_108/a_40_246# net38 0
C39040 hold96/a_326_118# _679_/a_324_432# 0
C39041 hold96/a_438_182# _679_/a_38_114# 0
C39042 _690_/a_1840_334# net40 0
C39043 VPWR hold73/a_438_182# 0.00188f
C39044 net49 clkbuf_4_14_0_clk/a_27_118# 0.04798f
C39045 _701_/a_298_337# net107 0
C39046 net176 VPWR 0.14974f
C39047 net42 hold146/a_56_118# 0
C39048 _643_/a_1583_191# _266_ 0.0089f
C39049 baud_inst.counter\[22\] _314_ 0
C39050 _675_/a_2250_412# _674_/a_843_236# 0.00138f
C39051 net96 FILLER_5_59/a_40_246# 0
C39052 _081_ _668_/a_38_114# 0.05086f
C39053 _223_ FILLER_14_164/a_32_246# 0.00533f
C39054 hold138/a_56_118# _156_ 0.01246f
C39055 _443_/a_150_412# _161_ 0.00377f
C39056 _691_/a_324_432# net49 0.0035f
C39057 _678_/a_741_93# _282_ 0.00278f
C39058 _671_/a_324_432# net29 0.01149f
C39059 _000_ _235_ 0
C39060 _638_/a_132_114# _049_ 0
C39061 FILLER_15_89/a_32_246# _686_/a_843_236# 0.00105f
C39062 net31 _227_ 0
C39063 _461_/a_22_110# _049_ 0
C39064 _080_ VPWR 0.0686f
C39065 clknet_0_clk hold90/a_438_182# 0.00393f
C39066 _458_/a_279_412# _140_ 0
C39067 _155_ clknet_0_clk 0.12493f
C39068 net27 clknet_4_4_0_clk 0.01445f
C39069 _686_/a_324_432# net29 0
C39070 _232_ _252_ 0.12958f
C39071 _643_/a_741_93# _154_ 0
C39072 tx_inst.data_reg\[3\] _067_ 0
C39073 VPWR net139 0.10164f
C39074 _245_ _239_ 0.02939f
C39075 FILLER_7_82/a_32_246# net40 0
C39076 clknet_0_clk _667_/a_2250_412# 0.00274f
C39077 _392_/a_559_412# _076_ 0
C39078 hold108/a_438_182# net40 0
C39079 fanout37/a_40_152# net62 0
C39080 _461_/a_22_110# _638_/a_1583_191# 0
C39081 _160_ FILLER_20_198/a_40_246# 0.00253f
C39082 _680_/a_324_432# _490_/a_45_160# 0
C39083 FILLER_25_177/a_40_246# _245_ 0
C39084 hold59/a_56_118# _703_/a_612_127# 0
C39085 _019_ VPWR 0.13272f
C39086 clknet_4_3_0_clk _352_/a_46_156# 0.00791f
C39087 net43 _668_/a_843_236# 0.0021f
C39088 _544_/a_46_156# hold91/a_56_118# 0
C39089 _696_/a_612_127# _180_ 0.02552f
C39090 _313_ _702_/a_741_93# 0
C39091 _230_ _421_/a_150_412# 0.00364f
C39092 _555_/a_209_168# _700_/a_741_93# 0
C39093 tx_inst.data_reg\[7\] _658_/a_1489_191# 0.01718f
C39094 hold55/a_438_182# _705_/a_1840_334# 0
C39095 VPWR hold83/a_56_118# 0.00115f
C39096 FILLER_21_96/a_40_246# VPWR 0.13884f
C39097 _114_ hold106/a_56_118# 0
C39098 _653_/a_298_337# _652_/a_741_93# 0
C39099 _248_ _167_ 0.2953f
C39100 net44 hold100/a_326_118# 0
C39101 baud_inst.counter\[7\] hold94/a_438_182# 0.0137f
C39102 _192_ _076_ 0.00586f
C39103 _372_/a_22_110# _405_/a_27_156# 0
C39104 net55 _706_/a_324_432# 0.04782f
C39105 _644_/a_1785_429# _243_ 0
C39106 _643_/a_741_93# FILLER_20_198/a_40_246# 0
C39107 clknet_4_12_0_clk _257_ 0.00699f
C39108 _230_ _435_/a_72_436# 0.00479f
C39109 rx_inst.bit_index\[2\] _254_ 0
C39110 VPWR _523_/a_257_140# 0.00308f
C39111 hold54/a_326_118# VPWR 0.00744f
C39112 net2 net30 0.0495f
C39113 hold105/a_326_118# baud_inst.counter\[29\] 0.00833f
C39114 net48 FILLER_19_178/a_40_246# 0.01994f
C39115 net69 net65 0
C39116 _673_/a_1840_334# net86 0
C39117 _495_/a_154_118# net29 0.00146f
C39118 _707_/a_38_114# _668_/a_1583_191# 0
C39119 fanout30/a_40_152# _140_ 0.01153f
C39120 hold150/a_326_118# net47 0.01725f
C39121 _448_/a_550_140# _133_ 0
C39122 _656_/a_741_93# _146_ 0
C39123 net108 hold95/a_438_182# 0
C39124 net37 _278_ 0.05293f
C39125 _668_/a_2250_412# net19 0.00597f
C39126 _488_/a_209_168# net60 0
C39127 _168_ _650_/a_1583_191# 0.00125f
C39128 _183_ _683_/a_843_236# 0
C39129 _290_ _288_ 0
C39130 _530_/a_155_412# _300_ 0.03152f
C39131 net144 net139 0.00236f
C39132 net38 baud_inst.counter\[9\] 0.00205f
C39133 _690_/a_843_236# _300_ 0
C39134 _690_/a_1583_191# net101 0.00239f
C39135 baud_inst.counter\[20\] _533_/a_146_122# 0.00369f
C39136 _229_ _247_ 0
C39137 VPWR _634_/a_741_93# 0.00677f
C39138 _255_ _438_/a_248_122# 0
C39139 _360_/a_71_118# _360_/a_382_118# -0
C39140 _216_ FILLER_8_191/a_32_246# 0.00124f
C39141 _486_/a_115_308# clk 0.00536f
C39142 net132 net151 0
C39143 hold100/a_56_118# clknet_0_clk 0.00749f
C39144 _073_ clkbuf_4_5_0_clk/a_27_118# 0
C39145 net90 _685_/a_843_236# 0
C39146 _103_ _527_/a_435_412# 0.0011f
C39147 net120 _693_/a_2250_412# 0.00391f
C39148 _022_ _693_/a_1583_191# 0
C39149 _095_ net109 0.00485f
C39150 _662_/a_1583_191# _120_ 0.00151f
C39151 net33 _706_/a_1785_429# 0
C39152 hold87/a_56_118# _109_ 0.00161f
C39153 _041_ VPWR 0.5132f
C39154 _643_/a_741_93# _160_ 0
C39155 _643_/a_298_337# _232_ 0
C39156 net113 baud_inst.counter\[29\] 0
C39157 net87 _296_ 0.11197f
C39158 _242_ _455_/a_155_412# 0
C39159 hold144/a_326_118# _160_ 0.00681f
C39160 _205_ _667_/a_298_337# 0
C39161 hold52/a_326_118# net24 0.00201f
C39162 _641_/a_741_93# net176 0.00414f
C39163 _641_/a_843_236# _052_ 0.00285f
C39164 hold171/a_56_118# net41 0
C39165 _107_ _302_ 0.01357f
C39166 FILLER_22_86/a_32_246# baud_inst.counter\[25\] 0
C39167 _117_ _704_/a_324_432# 0.01592f
C39168 baud_inst.counter\[31\] _699_/a_1583_191# 0
C39169 _143_ tx_inst.data_reg\[3\] 0.00155f
C39170 _244_ _158_ 0
C39171 _193_ _197_ 0
C39172 _194_ _476_/a_248_122# 0
C39173 net169 _274_ 0.00121f
C39174 net43 _667_/a_324_432# 0.03904f
C39175 _671_/a_2250_412# _668_/a_298_337# 0
C39176 hold101/a_326_118# _101_ 0
C39177 _696_/a_1785_429# baud_inst.counter\[24\] 0
C39178 FILLER_10_147/a_32_246# net43 0
C39179 net92 _678_/a_324_432# 0.00195f
C39180 _283_ _678_/a_38_114# 0
C39181 _180_ _683_/a_1583_191# 0
C39182 net26 _669_/a_2002_114# 0
C39183 _643_/a_2002_114# VPWR 0
C39184 net42 FILLER_10_110/a_40_246# 0
C39185 _125_ hold118/a_56_118# 0
C39186 _152_ net55 0
C39187 _679_/a_298_337# net115 0
C39188 _093_ clknet_4_0_0_clk 0.04138f
C39189 _242_ FILLER_26_151/a_32_246# 0
C39190 _058_ hold119/a_438_182# 0
C39191 _545_/a_146_122# baud_inst.counter\[25\] 0
C39192 hold140/a_56_118# net140 0.00202f
C39193 _360_/a_71_118# net9 0
C39194 _289_ _683_/a_38_114# 0
C39195 _653_/a_741_93# net183 0
C39196 rx_done _639_/a_38_114# 0
C39197 _167_ net139 0
C39198 hold76/a_56_118# net120 0
C39199 _295_ _518_/a_45_160# 0.00144f
C39200 net26 _404_/a_268_412# 0
C39201 hold85/a_56_118# _636_/a_741_93# 0
C39202 clknet_4_11_0_clk _699_/a_843_236# 0
C39203 net58 net49 0.07007f
C39204 rx_data[7] _668_/a_1840_334# 0
C39205 net49 FILLER_18_148/a_40_246# 0.00185f
C39206 _671_/a_2250_412# clknet_4_6_0_clk 0.00947f
C39207 clknet_4_9_0_clk net29 0.59701f
C39208 _292_ _683_/a_1840_334# 0
C39209 _255_ VPWR 0.19431f
C39210 _674_/a_1583_191# _085_ 0
C39211 _674_/a_1840_334# net38 0
C39212 _086_ net86 0.18628f
C39213 _012_ _189_ 0.01098f
C39214 _294_ _190_ 0.36565f
C39215 fanout31/a_40_152# net26 0.01061f
C39216 rx_data[6] _637_/a_1583_191# 0.00161f
C39217 _117_ hold146/a_438_182# 0
C39218 net31 _242_ 0.3505f
C39219 _532_/a_155_412# _303_ 0.00195f
C39220 FILLER_11_144/a_32_246# net43 0
C39221 fanout31/a_40_152# net32 0
C39222 net131 clkbuf_4_14_0_clk/a_27_118# 0
C39223 _701_/a_2250_412# baud_inst.counter\[29\] 0.0026f
C39224 _312_ _296_ 0.00173f
C39225 VPWR _665_/a_38_114# 0
C39226 _670_/a_1583_191# clknet_0_clk 0.00222f
C39227 _442_/a_146_122# _236_ 0
C39228 net15 net30 0
C39229 _673_/a_38_114# net38 0.01306f
C39230 clknet_4_5_0_clk FILLER_5_192/a_40_246# 0.01116f
C39231 hold173/a_438_182# _220_ 0
C39232 _142_ net43 0.03419f
C39233 hold173/a_326_118# _142_ 0.001f
C39234 net146 net22 0
C39235 clknet_4_14_0_clk clknet_4_15_0_clk 0.0013f
C39236 net36 _249_ 0
C39237 _141_ _651_/a_550_127# 0
C39238 net42 net43 1.14777f
C39239 hold156/a_56_118# net156 0.00119f
C39240 _466_/a_120_432# VPWR 0
C39241 VPWR _477_/a_22_110# 0.00283f
C39242 _194_ _196_ 0.1192f
C39243 net26 _666_/a_324_432# 0.05217f
C39244 net49 _418_/a_268_412# 0
C39245 _689_/a_2002_114# net40 0
C39246 net177 _513_/a_192_429# 0
C39247 _555_/a_380_412# net105 0.00109f
C39248 net72 _648_/a_2250_412# 0
C39249 VPWR FILLER_5_32/a_40_246# 0.162f
C39250 clknet_4_3_0_clk _676_/a_843_236# 0.02425f
C39251 input9/a_40_152# net9 0.00161f
C39252 _070_ clknet_0_clk 0
C39253 _666_/a_843_236# FILLER_8_191/a_32_246# 0
C39254 net182 clknet_4_9_0_clk 0
C39255 _098_ _180_ 0.01345f
C39256 _228_ net28 0.0354f
C39257 VPWR _148_ 0.16789f
C39258 _679_/a_38_114# net96 0.02334f
C39259 net167 _669_/a_324_432# 0.01076f
C39260 hold167/a_56_118# _669_/a_1840_334# 0
C39261 _633_/a_1840_334# _264_ 0
C39262 _217_ _403_/a_22_110# 0.03254f
C39263 clknet_4_14_0_clk _158_ 0.86081f
C39264 net37 _447_/a_277_118# 0.00178f
C39265 _486_/a_115_308# net2 0.02271f
C39266 net174 _197_ 0
C39267 _273_ _649_/a_1840_334# 0.00198f
C39268 FILLER_16_70/a_40_246# _109_ 0
C39269 _683_/a_1583_191# baud_inst.counter\[11\] 0.00296f
C39270 _100_ _687_/a_298_337# 0.0241f
C39271 VPWR FILLER_6_54/a_32_246# 0.08163f
C39272 net147 _693_/a_843_236# 0
C39273 hold135/a_438_182# FILLER_5_59/a_40_246# 0.00941f
C39274 net39 baud_inst.counter\[5\] 0.01628f
C39275 _693_/a_843_236# net46 0.01197f
C39276 net27 _666_/a_1583_191# 0.00203f
C39277 clkbuf_4_6_0_clk/a_27_118# net62 0.04685f
C39278 hold74/a_326_118# net2 0
C39279 baud_inst.counter\[27\] _699_/a_324_432# 0
C39280 FILLER_14_185/a_32_246# VPWR 0.08705f
C39281 net53 _698_/a_843_236# 0.00265f
C39282 _177_ _699_/a_298_337# 0.0138f
C39283 _159_ FILLER_26_172/a_40_246# 0
C39284 _199_ _665_/a_612_127# 0
C39285 VPWR FILLER_17_22/a_40_246# 0.1253f
C39286 input3/a_40_152# _212_ 0
C39287 hold159/a_56_118# net159 0
C39288 _658_/a_1785_429# net165 0
C39289 _658_/a_1840_334# _146_ 0.00142f
C39290 _143_ _090_ 0
C39291 net33 _200_ 0
C39292 tx_inst.data_reg\[4\] _661_/a_1840_334# 0
C39293 _374_/a_244_140# clknet_4_6_0_clk 0
C39294 hold116/a_56_118# net116 0.00455f
C39295 hold116/a_326_118# _288_ 0.01535f
C39296 _206_ _390_/a_59_156# 0.03765f
C39297 _094_ _681_/a_843_236# 0.00164f
C39298 _689_/a_38_114# _015_ 0
C39299 VPWR _299_ 0.20794f
C39300 net124 net72 0
C39301 _031_ _115_ 0
C39302 _643_/a_2002_114# _266_ 0
C39303 clknet_4_13_0_clk _122_ 0.02648f
C39304 _675_/a_1583_191# _674_/a_1489_191# 0
C39305 _675_/a_324_432# _030_ 0
C39306 rx_inst.state\[2\] _669_/a_843_236# 0
C39307 _691_/a_2250_412# net49 0.04126f
C39308 _201_ FILLER_5_213/a_32_246# 0.00779f
C39309 clkbuf_0_clk/a_116_82# clk 0.05457f
C39310 _055_ rx_inst.bit_index\[2\] 0
C39311 _023_ _022_ 0.98258f
C39312 net108 _288_ 0.03271f
C39313 _358_/a_166_436# net29 0
C39314 hold52/a_56_118# VPWR 0.01364f
C39315 VPWR hold61/a_56_118# 0.04879f
C39316 _677_/a_132_114# net154 0
C39317 _240_ _456_/a_155_412# 0.01176f
C39318 _057_ _156_ 0
C39319 _070_ _386_/a_59_156# 0.00391f
C39320 net126 net47 0.02332f
C39321 _686_/a_2250_412# net29 0
C39322 hold159/a_438_182# tx_inst.data_reg\[1\] 0.01681f
C39323 hold157/a_56_118# _688_/a_324_432# 0
C39324 hold157/a_326_118# _688_/a_38_114# 0
C39325 _661_/a_741_93# hold155/a_438_182# 0.00404f
C39326 _083_ rx_inst.state\[3\] 0
C39327 _638_/a_324_432# net70 0
C39328 net26 _168_ 1.67726f
C39329 _680_/a_843_236# _279_ 0
C39330 hold130/a_56_118# net40 0
C39331 _378_/a_382_118# tx_inst.data_reg\[1\] 0
C39332 baud_inst.counter\[12\] _685_/a_38_114# 0
C39333 net128 _685_/a_298_337# 0.03886f
C39334 net103 baud_inst.counter\[17\] 0.01144f
C39335 net28 _153_ 0.01933f
C39336 hold119/a_56_118# _157_ 0.00155f
C39337 net84 _636_/a_612_127# 0
C39338 clknet_4_14_0_clk _633_/a_1489_191# 0.00225f
C39339 hold134/a_438_182# VPWR 0.01096f
C39340 net65 _122_ 0.11504f
C39341 net32 _168_ 0
C39342 net49 _027_ 0
C39343 baud_inst.counter\[7\] _185_ 0
C39344 clk _221_ 0
C39345 rx_inst.state\[3\] FILLER_10_145/a_40_246# 0.0034f
C39346 net37 _671_/a_38_114# 0
C39347 _690_/a_843_236# net160 0
C39348 _690_/a_741_93# _296_ 0
C39349 _025_ hold91/a_326_118# 0
C39350 _227_ net62 0.02171f
C39351 _694_/a_843_236# clknet_4_10_0_clk 0.01706f
C39352 output23/a_40_152# _705_/a_324_432# 0
C39353 _545_/a_146_122# baud_inst.counter\[24\] 0.00444f
C39354 hold132/a_56_118# _158_ 0.01776f
C39355 net67 _700_/a_843_236# 0
C39356 _360_/a_382_118# clk 0
C39357 hold184/a_326_118# _216_ 0
C39358 _653_/a_741_93# _652_/a_1583_191# 0.00292f
C39359 _653_/a_324_432# _652_/a_1840_334# 0
C39360 clknet_4_6_0_clk _475_/a_170_412# 0
C39361 hold177/a_56_118# clknet_0_clk 0.00537f
C39362 _138_ net125 0.07812f
C39363 clkbuf_4_11_0_clk/a_27_118# net46 0.0076f
C39364 _660_/a_298_337# net41 0.00136f
C39365 hold126/a_438_182# net126 0
C39366 baud_inst.counter\[26\] _698_/a_741_93# 0.00438f
C39367 baud_inst.counter\[27\] _698_/a_843_236# 0
C39368 hold150/a_438_182# net131 0
C39369 _055_ _243_ 0
C39370 _641_/a_2250_412# net2 0
C39371 _466_/a_120_432# _266_ 0.00654f
C39372 net125 _232_ 0.42693f
C39373 hold122/a_326_118# net183 0
C39374 net49 _154_ 0
C39375 VPWR _051_ 0.17679f
C39376 _168_ hold62/a_326_118# 0
C39377 net62 hold62/a_438_182# 0.01563f
C39378 hold134/a_56_118# net133 0.0111f
C39379 _342_/a_170_412# _076_ 0
C39380 hold57/a_56_118# _651_/a_324_432# 0.0017f
C39381 _232_ _133_ 0.08425f
C39382 clknet_4_4_0_clk _388_/a_285_412# 0
C39383 net30 _084_ 0
C39384 hold118/a_326_118# _265_ 0
C39385 hold118/a_56_118# _129_ 0.0177f
C39386 rx_inst.data_reg\[4\] clknet_4_13_0_clk 0.15521f
C39387 _206_ tx_inst.data_reg\[0\] 0.02609f
C39388 clknet_4_1_0_clk _386_/a_382_118# 0.00683f
C39389 _399_/a_154_118# _220_ 0.00314f
C39390 _292_ _357_/a_150_412# 0
C39391 net152 _142_ 0.0134f
C39392 baud_inst.counter\[18\] _355_/a_354_412# 0.00207f
C39393 _018_ _300_ 0.02841f
C39394 hold70/a_326_118# hold72/a_56_118# 0.00494f
C39395 hold75/a_56_118# _695_/a_1583_191# 0
C39396 clknet_4_8_0_clk _301_ 0.01791f
C39397 net42 net152 0.00709f
C39398 _690_/a_2002_114# net101 0
C39399 _690_/a_612_127# _300_ 0
C39400 net35 _449_/a_229_118# 0
C39401 baud_inst.counter\[20\] _304_ 0.05621f
C39402 _654_/a_298_337# net170 0
C39403 _680_/a_1583_191# _092_ 0
C39404 VPWR _681_/a_132_114# 0
C39405 _635_/a_324_432# clkbuf_4_13_0_clk/a_27_118# 0.00304f
C39406 hold89/a_56_118# VPWR 0.00525f
C39407 net90 _685_/a_612_127# 0
C39408 hold127/a_326_118# net24 0
C39409 FILLER_23_204/a_40_246# _054_ 0
C39410 _696_/a_132_114# net46 0
C39411 _651_/a_2250_412# _274_ 0
C39412 _187_ VPWR 0.21048f
C39413 FILLER_14_185/a_32_246# _266_ 0.01179f
C39414 _543_/a_248_122# _308_ 0.00151f
C39415 _644_/a_2250_412# clkbuf_4_14_0_clk/a_27_118# 0
C39416 net70 net126 0.25618f
C39417 _109_ _544_/a_46_156# 0
C39418 _023_ _108_ 0.00278f
C39419 _450_/a_127_436# net25 0.01844f
C39420 _643_/a_1785_429# _160_ 0
C39421 net49 _405_/a_27_156# 0.01373f
C39422 _242_ _130_ 0
C39423 _677_/a_612_127# _034_ 0
C39424 clk net9 0.07356f
C39425 _511_/a_252_412# _186_ 0
C39426 _547_/a_81_118# net46 0.01064f
C39427 _512_/a_279_412# _010_ 0.00174f
C39428 net39 _689_/a_38_114# 0.01004f
C39429 VPWR _649_/a_681_505# 0
C39430 baud_inst.counter\[30\] _699_/a_1489_191# 0
C39431 net43 _667_/a_2250_412# 0.00518f
C39432 rx_inst.data_reg\[3\] _468_/a_22_110# 0
C39433 hold101/a_56_118# fanout40/a_40_152# 0.00117f
C39434 _024_ net140 0.04344f
C39435 _643_/a_324_432# net47 0.03585f
C39436 _643_/a_38_114# _054_ 0.00347f
C39437 clknet_4_1_0_clk FILLER_3_141/a_40_246# 0
C39438 hold181/a_56_118# clknet_4_0_0_clk 0.01124f
C39439 _705_/a_298_337# net22 0
C39440 net49 fanout36/a_40_152# 0.0039f
C39441 _163_ _684_/a_132_114# 0
C39442 _011_ _684_/a_843_236# 0
C39443 net81 _047_ 0
C39444 tx_inst.state\[1\] VPWR 0.06046f
C39445 fanout32/a_40_152# clknet_0_clk 0.00501f
C39446 _253_ FILLER_25_141/a_32_246# 0
C39447 hold147/a_438_182# _302_ 0.01322f
C39448 _283_ _678_/a_1840_334# 0
C39449 FILLER_5_192/a_40_246# _005_ 0
C39450 clkbuf_0_clk/a_116_82# net2 0.04458f
C39451 hold125/a_438_182# net49 0.00988f
C39452 _246_ fanout35/a_40_152# 0
C39453 hold149/a_56_118# _694_/a_132_114# 0
C39454 _378_/a_285_118# VPWR 0
C39455 rx_done FILLER_8_238/a_32_246# 0
C39456 hold153/a_56_118# hold154/a_56_118# 0.00543f
C39457 rx_data[2] _264_ 0
C39458 _417_/a_22_110# _235_ 0.02078f
C39459 _417_/a_120_432# _140_ 0
C39460 _170_ net78 0.00115f
C39461 _052_ net45 0.02198f
C39462 hold110/a_438_182# _010_ 0.00986f
C39463 _639_/a_741_93# _121_ 0
C39464 net99 _311_ 0.58735f
C39465 _360_/a_1109_431# net9 0
C39466 _653_/a_1840_334# _221_ 0
C39467 net2 FILLER_21_147/a_40_246# 0
C39468 hold79/a_438_182# _085_ 0
C39469 _231_ _223_ 0
C39470 net135 _683_/a_38_114# 0
C39471 hold85/a_56_118# net48 0.00173f
C39472 _662_/a_741_93# net54 0.0177f
C39473 _699_/a_298_337# VPWR 0.00491f
C39474 hold146/a_438_182# _006_ 0
C39475 net44 hold163/a_438_182# 0.00194f
C39476 VPWR _651_/a_843_236# 0.00315f
C39477 net44 _696_/a_324_432# 0.01047f
C39478 _031_ hold105/a_56_118# 0.08513f
C39479 _637_/a_843_236# _264_ 0
C39480 _162_ net29 0.42375f
C39481 FILLER_3_123/a_32_246# _209_ 0
C39482 _163_ _523_/a_257_140# 0
C39483 net173 net26 0
C39484 VPWR _665_/a_1840_334# 0.00111f
C39485 _673_/a_1583_191# _085_ 0
C39486 _673_/a_1840_334# net38 0.02496f
C39487 _354_/a_170_412# _296_ 0
C39488 _488_/a_209_168# _019_ 0.00367f
C39489 hold117/a_326_118# _682_/a_324_432# 0
C39490 hold117/a_56_118# _682_/a_741_93# 0
C39491 clk _652_/a_2250_412# 0.01201f
C39492 _141_ clknet_4_6_0_clk 0.00106f
C39493 net92 net95 0.01122f
C39494 hold96/a_438_182# _292_ 0
C39495 _283_ net29 0.00391f
C39496 _231_ _240_ 0
C39497 _045_ _123_ 0.00655f
C39498 _138_ _245_ 0.02625f
C39499 baud_inst.counter\[8\] _683_/a_324_432# 0
C39500 net55 net168 0
C39501 net58 hold59/a_438_182# 0.01124f
C39502 _032_ hold59/a_56_118# 0.03289f
C39503 FILLER_6_205/a_40_246# _200_ 0
C39504 net44 _014_ 0
C39505 net67 _314_ 0.01836f
C39506 _060_ hold125/a_56_118# 0.00589f
C39507 clknet_4_3_0_clk _676_/a_612_127# 0.00532f
C39508 _232_ _245_ 0
C39509 _043_ _054_ 0.00685f
C39510 net94 FILLER_5_84/a_40_246# 0
C39511 _171_ clkbuf_4_5_0_clk/a_27_118# 0.0874f
C39512 hold56/a_56_118# _216_ 0
C39513 baud_inst.counter\[12\] clknet_0_clk 0.18863f
C39514 _702_/a_324_432# _700_/a_1583_191# 0
C39515 _702_/a_38_114# _700_/a_1840_334# 0
C39516 _060_ FILLER_23_204/a_40_246# 0
C39517 _147_ _386_/a_382_118# 0.04054f
C39518 _068_ _386_/a_285_412# 0
C39519 _679_/a_1583_191# clknet_4_3_0_clk 0.00164f
C39520 _002_ _669_/a_1785_429# 0
C39521 _218_ _141_ 0
C39522 _081_ _650_/a_298_337# 0
C39523 _180_ baud_inst.counter\[25\] 0.01264f
C39524 _659_/a_38_114# net41 0.01125f
C39525 net106 hold106/a_56_118# 0
C39526 _693_/a_298_337# _302_ 0
C39527 _500_/a_155_412# _086_ 0
C39528 _267_ hold70/a_438_182# 0.00127f
C39529 _128_ hold70/a_326_118# 0.0131f
C39530 _341_/a_886_118# tx_inst.data_reg\[0\] 0
C39531 net50 _198_ 0
C39532 net182 _162_ 0.00825f
C39533 net128 _517_/a_380_412# 0
C39534 _100_ _687_/a_1583_191# 0
C39535 rx_inst.bit_index\[1\] rx_inst.bit_index\[2\] 0.20166f
C39536 net36 clknet_4_12_0_clk 1.58997f
C39537 hold88/a_56_118# _013_ 0
C39538 _170_ FILLER_17_162/a_32_246# 0.00217f
C39539 _693_/a_612_127# net46 0.0058f
C39540 _177_ _699_/a_1583_191# 0.00232f
C39541 baud_inst.counter\[27\] _699_/a_2250_412# 0
C39542 _107_ FILLER_22_32/a_40_246# 0
C39543 FILLER_0_161/a_40_246# net165 0
C39544 tx_inst.bit_index\[1\] _652_/a_38_114# 0
C39545 net42 hold152/a_438_182# 0.00159f
C39546 _636_/a_298_337# hold84/a_438_182# 0
C39547 FILLER_25_9/a_32_246# net1 0.02325f
C39548 _069_ net165 0.00204f
C39549 hold169/a_438_182# net183 0
C39550 clknet_0_clk net88 0.06596f
C39551 hold171/a_56_118# tx_inst.data_reg\[7\] 0.0186f
C39552 _676_/a_843_236# baud_inst.counter\[5\] 0
C39553 hold88/a_56_118# baud_inst.counter\[14\] 0.00398f
C39554 _643_/a_38_114# _060_ 0
C39555 _659_/a_2250_412# _657_/a_1583_191# 0
C39556 _659_/a_1840_334# _657_/a_1840_334# 0.00131f
C39557 _659_/a_1583_191# _657_/a_2250_412# 0
C39558 fanout37/a_40_152# net19 0
C39559 _698_/a_324_432# VPWR 0.00479f
C39560 _693_/a_741_93# FILLER_22_22/a_32_246# 0
C39561 net100 _697_/a_612_127# 0
C39562 hold100/a_56_118# _110_ 0.00126f
C39563 _689_/a_2250_412# _296_ 0
C39564 _050_ net80 0.25663f
C39565 _069_ FILLER_3_123/a_32_246# 0.00135f
C39566 _094_ _681_/a_612_127# 0
C39567 _246_ _132_ 0
C39568 _045_ _648_/a_2250_412# 0
C39569 hold127/a_56_118# VPWR 0.04395f
C39570 hold101/a_438_182# VPWR 0.00834f
C39571 _229_ _234_ 0
C39572 _154_ _649_/a_38_114# 0.02119f
C39573 baud_inst.counter\[3\] _674_/a_1583_191# 0.00187f
C39574 hold55/a_438_182# net55 0
C39575 net21 net11 0.02746f
C39576 baud_inst.counter\[5\] _683_/a_843_236# 0
C39577 hold137/a_326_118# tx_inst.data_reg\[5\] 0.0062f
C39578 hold179/a_56_118# _074_ 0.00427f
C39579 hold65/a_56_118# FILLER_26_227/a_40_246# 0
C39580 _240_ _264_ 0.93746f
C39581 _077_ _706_/a_38_114# 0
C39582 _670_/a_741_93# clknet_4_9_0_clk 0.02524f
C39583 baud_inst.counter\[15\] _521_/a_170_412# 0.00358f
C39584 _060_ _236_ 0
C39585 hold65/a_326_118# hold70/a_438_182# 0.00209f
C39586 hold65/a_438_182# hold70/a_326_118# 0
C39587 _292_ baud_inst.counter\[10\] 0.13273f
C39588 net109 _183_ 0.00404f
C39589 net44 _529_/a_139_160# 0.00106f
C39590 net103 _687_/a_843_236# 0
C39591 VPWR _502_/a_165_412# 0
C39592 _536_/a_341_118# _303_ 0.00465f
C39593 net175 net25 0.26098f
C39594 _699_/a_741_93# _549_/a_155_412# 0
C39595 net55 _146_ 0.02144f
C39596 _076_ net168 0.04971f
C39597 _215_ net27 0.14344f
C39598 FILLER_10_222/a_32_246# net43 0
C39599 baud_inst.counter\[12\] _182_ 0
C39600 net39 clknet_0_clk 0.26645f
C39601 VPWR _105_ 0.15295f
C39602 _644_/a_1489_191# VPWR 0
C39603 _638_/a_1583_191# net18 0.00185f
C39604 _678_/a_550_127# _035_ 0
C39605 hold127/a_56_118# _239_ 0
C39606 FILLER_12_89/a_40_246# clknet_0_clk 0.00142f
C39607 net87 _294_ 0.00143f
C39608 _206_ tx_inst.data_reg\[1\] 0.15036f
C39609 _174_ tx_inst.data_reg\[2\] 0.0032f
C39610 _175_ clknet_4_4_0_clk 0.0248f
C39611 _202_ _365_/a_155_412# 0
C39612 _650_/a_1840_334# net19 0.02843f
C39613 _358_/a_411_436# net40 0.00131f
C39614 baud_inst.counter\[17\] net101 0.16438f
C39615 hold145/a_326_118# _339_/a_886_118# 0
C39616 net37 _671_/a_1840_334# 0
C39617 _241_ _224_ 0.02778f
C39618 hold162/a_438_182# VPWR 0.00126f
C39619 _313_ _115_ 0.00248f
C39620 _045_ net124 0
C39621 net40 _085_ 0
C39622 _086_ net38 0.053f
C39623 _341_/a_805_385# VPWR 0
C39624 FILLER_8_116/a_40_246# _142_ 0.0045f
C39625 _306_ _540_/a_45_160# 0
C39626 _694_/a_612_127# clknet_4_10_0_clk 0.00493f
C39627 _491_/a_192_429# _033_ 0.00395f
C39628 hold146/a_326_118# net27 0
C39629 _665_/a_1840_334# FILLER_7_234/a_32_246# 0
C39630 net16 hold118/a_56_118# 0
C39631 _695_/a_2250_412# _311_ 0
C39632 FILLER_25_177/a_40_246# hold127/a_56_118# 0
C39633 _660_/a_843_236# _392_/a_382_118# 0.00119f
C39634 net42 FILLER_8_116/a_40_246# 0.00341f
C39635 net56 _220_ 0.04302f
C39636 net44 hold104/a_326_118# 0.00692f
C39637 VPWR hold71/a_438_182# 0.00331f
C39638 baud_inst.counter\[25\] net140 3.41441f
C39639 rx_inst.state\[2\] net52 0
C39640 _070_ net43 0
C39641 output13/a_40_152# net77 0
C39642 _653_/a_298_337# _063_ 0.00368f
C39643 _653_/a_1840_334# _652_/a_2250_412# 0.00109f
C39644 rx_inst.bit_index\[2\] FILLER_22_152/a_32_246# 0
C39645 net110 _183_ 0
C39646 tx_inst.bit_index\[2\] _222_ 0
C39647 input11/a_40_152# net172 0
C39648 net98 _689_/a_741_93# 0
C39649 FILLER_19_55/a_40_246# baud_inst.counter\[24\] 0
C39650 rx_inst.state\[1\] hold81/a_326_118# 0
C39651 FILLER_19_132/a_40_246# clknet_4_12_0_clk 0.00542f
C39652 hold147/a_326_118# _692_/a_1583_191# 0
C39653 _393_/a_170_412# clknet_0_clk 0
C39654 net51 _668_/a_843_236# 0.05929f
C39655 _707_/a_324_432# rx_inst.state\[1\] 0.00176f
C39656 net57 _651_/a_741_93# 0
C39657 net44 _531_/a_380_412# 0.00743f
C39658 net55 _656_/a_298_337# 0.00121f
C39659 clknet_4_4_0_clk net165 0.47522f
C39660 _067_ _146_ 0.00494f
C39661 hold177/a_438_182# baud_inst.counter\[14\] 0
C39662 hold163/a_326_118# _164_ 0
C39663 _227_ rx_inst.state\[3\] 0
C39664 hold163/a_438_182# _302_ 0
C39665 _671_/a_1583_191# _650_/a_38_114# 0
C39666 _689_/a_681_505# clknet_4_2_0_clk 0
C39667 baud_inst.counter\[17\] _682_/a_843_236# 0
C39668 hold129/a_56_118# _180_ 0.03001f
C39669 _216_ _200_ 0.02981f
C39670 VPWR _681_/a_1489_191# 0.00649f
C39671 net90 net130 0
C39672 _677_/a_1840_334# net137 0
C39673 hold56/a_438_182# FILLER_9_169/a_32_246# 0.00985f
C39674 _126_ _468_/a_120_432# 0
C39675 output12/a_40_152# net30 0.01847f
C39676 _439_/a_354_412# net24 0.00109f
C39677 hold117/a_56_118# FILLER_8_35/a_32_246# 0.00404f
C39678 net156 hold102/a_326_118# 0
C39679 _696_/a_1489_191# net46 0.00489f
C39680 _424_/a_244_412# VPWR 0.00289f
C39681 net39 _182_ 0.87376f
C39682 _376_/a_76_160# net11 0
C39683 baud_inst.counter\[20\] FILLER_22_22/a_32_246# 0
C39684 _161_ net25 1.86094f
C39685 FILLER_12_89/a_40_246# _182_ 0
C39686 _003_ baud_inst.counter\[4\] 0
C39687 _254_ _418_/a_46_156# 0
C39688 net154 _034_ 0.09776f
C39689 net39 _685_/a_1840_334# 0.00106f
C39690 _052_ net176 0.00979f
C39691 hold165/a_326_118# net3 0
C39692 _290_ clknet_4_2_0_clk 0.09568f
C39693 clknet_4_3_0_clk _677_/a_1489_191# 0.00657f
C39694 net39 _689_/a_1840_334# 0.006f
C39695 FILLER_13_102/a_32_246# baud_inst.counter\[13\] 0.00326f
C39696 VPWR _649_/a_550_127# 0
C39697 _662_/a_298_337# tx_inst.data_reg\[0\] 0
C39698 _690_/a_2250_412# net88 0
C39699 _690_/a_1840_334# _014_ 0
C39700 _656_/a_298_337# _067_ 0.00506f
C39701 _180_ baud_inst.counter\[24\] 0.0233f
C39702 net153 net40 0.37014f
C39703 net37 _374_/a_244_412# 0.00541f
C39704 hold129/a_326_118# _292_ 0.00145f
C39705 _241_ _235_ 0
C39706 _095_ baud_inst.counter\[8\] 0
C39707 _663_/a_38_114# _075_ 0.01498f
C39708 hold162/a_56_118# net162 0
C39709 hold140/a_438_182# net46 0
C39710 _643_/a_2250_412# net47 0.00404f
C39711 _536_/a_192_429# net120 0.01088f
C39712 rx_data[7] _650_/a_1583_191# 0
C39713 _695_/a_324_432# _108_ 0.04662f
C39714 net110 net115 0
C39715 _705_/a_1583_191# net22 0.01724f
C39716 _127_ hold71/a_438_182# 0.00197f
C39717 _163_ _684_/a_1489_191# 0.01937f
C39718 net121 _106_ 0.01467f
C39719 _285_ hold95/a_326_118# 0.00636f
C39720 FILLER_29_221/a_32_246# _634_/a_324_432# 0
C39721 FILLER_2_81/a_32_246# net86 0
C39722 _089_ _184_ 0.00248f
C39723 _391_/a_268_412# net170 0
C39724 net156 FILLER_15_42/a_40_246# 0.00573f
C39725 _537_/a_435_412# _302_ 0
C39726 _232_ _255_ 0.14267f
C39727 tx_inst.data_reg\[6\] _173_ 0
C39728 _151_ VPWR 0.14584f
C39729 _284_ hold154/a_438_182# 0.00123f
C39730 _651_/a_298_337# net183 0.00102f
C39731 VPWR _025_ 0.2588f
C39732 net51 _667_/a_324_432# 0
C39733 net58 _699_/a_741_93# 0
C39734 _316_ _699_/a_324_432# 0
C39735 clk net171 0
C39736 _040_ net21 0.17292f
C39737 net50 _666_/a_2250_412# 0
C39738 tx_busy net50 0
C39739 hold151/a_438_182# _056_ 0.00417f
C39740 _679_/a_741_93# _287_ 0.00682f
C39741 net146 clkbuf_4_5_0_clk/a_27_118# 0
C39742 _669_/a_741_93# _669_/a_1583_191# 0
C39743 _008_ _675_/a_2250_412# 0
C39744 tx_inst.bit_index\[1\] _653_/a_843_236# 0.00399f
C39745 FILLER_15_89/a_32_246# hold91/a_438_182# 0.00985f
C39746 _217_ clkbuf_4_4_0_clk/a_27_118# 0.00138f
C39747 hold108/a_56_118# clknet_4_2_0_clk 0
C39748 _083_ _205_ 0
C39749 _166_ net183 0
C39750 _290_ _683_/a_298_337# 0
C39751 _516_/a_165_412# _182_ 0
C39752 _531_/a_209_168# _692_/a_38_114# 0
C39753 _345_/a_354_412# baud_inst.counter\[22\] 0.00454f
C39754 _662_/a_1785_429# net54 0.0023f
C39755 _699_/a_1583_191# VPWR 0.01315f
C39756 hold141/a_326_118# _696_/a_741_93# 0
C39757 net21 _006_ 0
C39758 hold91/a_56_118# net29 0.08129f
C39759 _639_/a_38_114# net19 0.00231f
C39760 _696_/a_2250_412# FILLER_17_94/a_40_246# 0.0016f
C39761 _661_/a_1583_191# net5 0.00149f
C39762 _674_/a_38_114# VPWR 0.03059f
C39763 _662_/a_1489_191# clknet_4_5_0_clk 0
C39764 _164_ _529_/a_45_160# 0
C39765 _302_ _529_/a_139_160# 0
C39766 net44 _696_/a_2250_412# 0.00265f
C39767 FILLER_26_88/a_40_246# hold58/a_438_182# 0.00941f
C39768 tx_inst.data_reg\[4\] _388_/a_382_118# 0
C39769 net15 hold73/a_56_118# 0
C39770 _637_/a_612_127# _264_ 0
C39771 _346_/a_252_412# _165_ 0
C39772 hold72/a_326_118# rx_inst.data_reg\[5\] 0.00249f
C39773 _378_/a_59_156# FILLER_0_103/a_32_246# 0
C39774 net45 hold134/a_326_118# 0.01117f
C39775 net85 hold143/a_56_118# 0.01385f
C39776 _663_/a_324_432# _166_ 0.00702f
C39777 FILLER_13_228/a_40_246# hold51/a_56_118# 0.00786f
C39778 _655_/a_843_236# net40 0.00978f
C39779 net184 _172_ 0
C39780 _686_/a_1840_334# net90 0
C39781 _658_/a_741_93# _069_ 0.00302f
C39782 _352_/a_46_156# _182_ 0
C39783 _493_/a_45_160# _162_ 0.03221f
C39784 _191_ _667_/a_741_93# 0
C39785 _701_/a_1840_334# net46 0
C39786 _073_ _478_/a_27_156# 0
C39787 hold164/a_438_182# _300_ 0
C39788 _695_/a_741_93# net76 0
C39789 net151 _159_ 0
C39790 clknet_4_5_0_clk _479_/a_120_432# 0.00155f
C39791 _270_ _647_/a_1583_191# 0.00438f
C39792 net83 net30 0
C39793 _442_/a_248_122# _255_ -0
C39794 net140 baud_inst.counter\[24\] 0.20387f
C39795 _091_ _655_/a_741_93# 0
C39796 _639_/a_324_432# hold51/a_56_118# 0
C39797 FILLER_14_202/a_40_246# net118 0.0104f
C39798 clknet_4_3_0_clk _034_ 0.10819f
C39799 hold104/a_326_118# _302_ 0.0087f
C39800 hold104/a_56_118# _164_ 0.03107f
C39801 _678_/a_298_337# VPWR 0.00261f
C39802 _280_ net40 0.06751f
C39803 clkload3/Y _054_ 0
C39804 FILLER_21_96/a_40_246# FILLER_20_95/a_40_246# 0
C39805 hold145/a_438_182# VPWR 0.0023f
C39806 hold146/a_56_118# _393_/a_170_412# 0
C39807 _688_/a_1583_191# net40 0.02588f
C39808 _696_/a_1840_334# clknet_0_clk 0.00268f
C39809 _163_ _187_ 0.00803f
C39810 _659_/a_1840_334# net41 0
C39811 hold158/a_56_118# clknet_4_2_0_clk 0
C39812 hold105/a_56_118# _313_ 0.00206f
C39813 fanout46/a_40_152# net46 0
C39814 _693_/a_1583_191# _302_ 0
C39815 _285_ _086_ 0
C39816 _412_/a_22_110# net43 0
C39817 _632_/a_843_236# _273_ 0.00117f
C39818 net42 net51 0
C39819 net141 net162 0
C39820 net147 net149 0
C39821 hold157/a_438_182# _101_ 0.00481f
C39822 _531_/a_380_412# _302_ 0.01891f
C39823 net44 _023_ 0
C39824 baud_inst.counter\[28\] _555_/a_380_412# 0
C39825 net30 _649_/a_1489_191# 0
C39826 net149 net46 0.15927f
C39827 _411_/a_358_436# _241_ 0
C39828 net163 _690_/a_843_236# 0
C39829 _177_ _699_/a_2002_114# 0
C39830 _547_/a_277_118# clknet_0_clk 0
C39831 _285_ _091_ 0
C39832 net173 net34 1.53586f
C39833 tx_inst.data_reg\[6\] _341_/a_589_385# 0.00133f
C39834 _678_/a_38_114# hold93/a_56_118# 0
C39835 FILLER_8_189/a_40_246# clknet_0_clk 0.00105f
C39836 clkbuf_4_3_0_clk/a_27_118# net29 0
C39837 _295_ baud_inst.counter\[15\] 0
C39838 VPWR FILLER_17_79/a_40_246# 0.12305f
C39839 net3 _214_ 0.0055f
C39840 rx_inst.state\[3\] _676_/a_324_432# 0
C39841 _696_/a_741_93# baud_inst.counter\[14\] 0
C39842 hold126/a_56_118# net70 0.06709f
C39843 _643_/a_1840_334# _060_ 0
C39844 _659_/a_741_93# tx_inst.data_reg\[3\] 0
C39845 hold173/a_438_182# net27 0
C39846 _698_/a_2250_412# VPWR 0.00578f
C39847 _654_/a_38_114# _071_ 0
C39848 _392_/a_382_118# _664_/a_741_93# 0
C39849 _094_ net117 0.06571f
C39850 _464_/a_22_110# _271_ 0
C39851 _634_/a_298_337# hold83/a_438_182# 0
C39852 _634_/a_38_114# hold83/a_326_118# 0
C39853 _073_ _376_/a_272_160# 0.00103f
C39854 _644_/a_132_114# _232_ 0
C39855 VPWR _439_/a_252_412# 0
C39856 baud_inst.counter\[10\] _289_ 0.00403f
C39857 clknet_4_13_0_clk FILLER_17_199/a_40_246# 0
C39858 _269_ _240_ 0.0067f
C39859 _268_ _648_/a_1583_191# 0.0014f
C39860 hold66/a_56_118# _273_ 0
C39861 net126 _649_/a_2250_412# 0.03946f
C39862 _154_ _649_/a_1840_334# 0.00843f
C39863 hold66/a_326_118# net64 0.00882f
C39864 VPWR FILLER_4_108/a_40_246# 0.13734f
C39865 _170_ _436_/a_142_412# 0.00463f
C39866 _312_ net113 0
C39867 rx_data[7] _639_/a_298_337# 0.00112f
C39868 output15/a_40_152# net15 0.02972f
C39869 hold75/a_438_182# _108_ 0
C39870 output21/a_40_152# _665_/a_741_93# 0
C39871 baud_inst.counter\[20\] _692_/a_741_93# 0.00448f
C39872 hold163/a_326_118# _692_/a_1583_191# 0.00358f
C39873 _154_ _420_/a_146_122# 0
C39874 _360_/a_71_118# _341_/a_71_118# 0
C39875 _644_/a_38_114# net47 0
C39876 _192_ _664_/a_38_114# 0.0171f
C39877 _204_ _667_/a_843_236# 0
C39878 net103 _687_/a_612_127# 0.00118f
C39879 _661_/a_1583_191# tx_data[2] 0.00169f
C39880 _228_ _223_ 0
C39881 clknet_4_12_0_clk _635_/a_324_432# 0
C39882 _704_/a_550_127# rx_inst.state\[1\] 0
C39883 hold80/a_326_118# net80 0.0108f
C39884 _116_ clknet_0_clk 0.00571f
C39885 _699_/a_741_93# _027_ 0.03726f
C39886 _062_ _403_/a_22_110# 0
C39887 clkbuf_0_clk/a_116_82# baud_inst.counter\[13\] 0
C39888 _534_/a_46_156# _693_/a_324_432# 0
C39889 rx_inst.data_reg\[1\] VPWR 0.0907f
C39890 clknet_4_5_0_clk net11 0
C39891 _658_/a_741_93# clknet_4_4_0_clk 0.02272f
C39892 _266_ _470_/a_120_432# 0.00796f
C39893 net30 _470_/a_22_110# 0.00346f
C39894 _073_ hold172/a_56_118# 0
C39895 _384_/a_496_118# net171 0.00106f
C39896 _384_/a_559_412# _148_ 0
C39897 clknet_4_2_0_clk FILLER_12_42/a_32_246# 0
C39898 _003_ hold123/a_56_118# 0.02683f
C39899 net26 _671_/a_38_114# 0
C39900 _704_/a_38_114# hold50/a_326_118# 0
C39901 _704_/a_298_337# hold50/a_438_182# 0
C39902 _191_ net40 0.02286f
C39903 _103_ _296_ 0
C39904 net47 hold83/a_438_182# 0.00355f
C39905 net41 _212_ 0
C39906 net145 _339_/a_1377_160# 0
C39907 _676_/a_843_236# clknet_0_clk 0.00363f
C39908 _341_/a_308_118# VPWR 0
C39909 net108 clknet_4_2_0_clk 0.21982f
C39910 _645_/a_298_337# net47 0
C39911 _446_/a_248_122# VPWR 0.00328f
C39912 _181_ _033_ 0.00364f
C39913 _375_/a_170_412# _200_ 0
C39914 _170_ _671_/a_324_432# 0
C39915 _411_/a_494_160# net49 0
C39916 _679_/a_741_93# clkbuf_4_0_0_clk/a_27_118# 0.01704f
C39917 baud_inst.counter\[8\] _350_/a_165_412# 0
C39918 net34 FILLER_7_146/a_32_246# 0
C39919 net23 _705_/a_1489_191# 0
C39920 net32 _671_/a_38_114# 0
C39921 output12/a_40_152# _461_/a_120_432# 0
C39922 net47 FILLER_29_165/a_40_246# 0.02876f
C39923 _672_/a_298_337# _085_ 0.02292f
C39924 _672_/a_38_114# net38 0.00372f
C39925 clknet_0_clk _683_/a_843_236# 0.00293f
C39926 _112_ clknet_4_8_0_clk 0.01676f
C39927 _095_ _689_/a_741_93# 0.00109f
C39928 _228_ _240_ 0
C39929 net39 FILLER_10_110/a_40_246# 0.00156f
C39930 net25 _647_/a_298_337# 0
C39931 net51 _668_/a_612_127# 0.02613f
C39932 _644_/a_324_432# net49 0.05f
C39933 net55 _656_/a_1583_191# 0
C39934 net47 _634_/a_681_505# 0
C39935 _706_/a_298_337# _120_ 0.01721f
C39936 _706_/a_38_114# net43 0.04379f
C39937 _671_/a_324_432# hold62/a_56_118# 0.00352f
C39938 _643_/a_38_114# _257_ 0.00132f
C39939 hold150/a_438_182# _044_ 0
C39940 _060_ clkload3/Y 0.05021f
C39941 tx_inst.bit_index\[0\] _666_/a_132_114# 0
C39942 _232_ _649_/a_681_505# 0
C39943 VPWR baud_inst.counter\[9\] 0.06623f
C39944 output16/a_40_152# net30 0.00383f
C39945 _313_ _701_/a_1840_334# 0
C39946 _673_/a_298_337# _145_ 0
C39947 net74 _270_ 0
C39948 _126_ _125_ 0.13098f
C39949 hold107/a_438_182# VPWR 0.00465f
C39950 _253_ net24 0.03188f
C39951 net30 net77 0.04967f
C39952 _645_/a_38_114# net49 0.05441f
C39953 net69 _637_/a_1583_191# 0
C39954 net108 _683_/a_298_337# 0.02276f
C39955 net123 _670_/a_298_337# 0.02214f
C39956 hold123/a_438_182# _670_/a_843_236# 0
C39957 _223_ _153_ 0
C39958 _257_ _236_ 0
C39959 net55 _382_/a_59_156# 0.00311f
C39960 _256_ _236_ 0.72712f
C39961 net145 tx_inst.data_reg\[1\] 0.02724f
C39962 _191_ _670_/a_38_114# 0.00207f
C39963 fanout30/a_40_152# net25 0
C39964 _643_/a_1583_191# _649_/a_843_236# 0
C39965 _643_/a_843_236# _649_/a_1583_191# 0
C39966 _676_/a_843_236# _182_ 0
C39967 _307_ _695_/a_741_93# 0
C39968 VPWR _632_/a_38_114# 0.00278f
C39969 net33 net22 0.00131f
C39970 _346_/a_150_412# hold114/a_56_118# 0
C39971 net35 _224_ 0.06168f
C39972 _360_/a_1453_124# _206_ 0
C39973 _656_/a_843_236# tx_inst.data_reg\[2\] 0
C39974 _679_/a_298_337# _182_ 0.0224f
C39975 _341_/a_71_118# _172_ 0
C39976 _294_ _354_/a_170_412# 0
C39977 _461_/a_22_110# hold71/a_438_182# 0
C39978 hold109/a_438_182# VPWR 0.00603f
C39979 _088_ _033_ 0
C39980 _073_ _664_/a_1489_191# 0
C39981 _182_ _683_/a_843_236# 0.00276f
C39982 hold130/a_326_118# baud_inst.counter\[12\] 0
C39983 hold130/a_56_118# net128 0.00314f
C39984 _315_ _701_/a_324_432# 0
C39985 net49 _443_/a_150_412# 0
C39986 clknet_0_clk net172 0.07653f
C39987 _652_/a_612_127# _063_ 0.00276f
C39988 _705_/a_2002_114# net22 0.001f
C39989 net179 _203_ 0.09176f
C39990 hold58/a_326_118# _702_/a_2250_412# 0
C39991 hold58/a_438_182# _702_/a_1840_334# 0
C39992 _068_ _211_ 0.10941f
C39993 _080_ _063_ 0
C39994 _699_/a_2250_412# FILLER_23_83/a_32_246# 0.01061f
C39995 _168_ _137_ 0
C39996 _214_ _150_ -0
C39997 _240_ _153_ 0.01349f
C39998 _023_ _302_ 0.01412f
C39999 hold110/a_438_182# _287_ 0.00157f
C40000 net36 _449_/a_27_156# 0.01168f
C40001 baud_inst.counter\[28\] _702_/a_38_114# 0.03273f
C40002 _111_ _698_/a_298_337# 0.00589f
C40003 net45 _698_/a_38_114# 0.03783f
C40004 _316_ _699_/a_2250_412# 0
C40005 hold140/a_56_118# _697_/a_1583_191# 0
C40006 _677_/a_1489_191# baud_inst.counter\[5\] 0
C40007 net50 _704_/a_741_93# 0
C40008 net51 _667_/a_2250_412# 0
C40009 _050_ _121_ 0
C40010 net71 hold70/a_438_182# 0.00157f
C40011 rx_inst.data_reg\[1\] _266_ 0.02214f
C40012 _268_ hold70/a_326_118# 0
C40013 FILLER_13_100/a_40_246# clknet_0_clk 0.00308f
C40014 rx_inst.state\[3\] hold167/a_438_182# 0
C40015 baud_inst.counter\[1\] _673_/a_843_236# 0
C40016 hold86/a_326_118# _673_/a_1840_334# 0
C40017 _457_/a_120_432# _264_ 0
C40018 clkbuf_4_10_0_clk/a_27_118# _023_ 0
C40019 _635_/a_38_114# net64 0.01405f
C40020 net4 _145_ 0
C40021 _679_/a_612_127# net135 0
C40022 net18 _634_/a_741_93# 0
C40023 tx_inst.bit_index\[1\] _653_/a_612_127# 0
C40024 _077_ net172 0.00236f
C40025 hold161/a_326_118# net156 0
C40026 net131 net49 0
C40027 _469_/a_120_432# net30 0.00312f
C40028 _257_ _043_ 0
C40029 _672_/a_38_114# FILLER_0_42/a_32_246# 0
C40030 _173_ net183 0
C40031 FILLER_18_148/a_40_246# net25 0.0023f
C40032 _178_ baud_inst.counter\[22\] 0.14218f
C40033 _012_ _182_ 0.00256f
C40034 _101_ net40 0.01854f
C40035 _020_ _692_/a_298_337# 0.0026f
C40036 net163 _692_/a_324_432# 0.00262f
C40037 _694_/a_843_236# VPWR 0.01337f
C40038 _139_ clkbuf_4_14_0_clk/a_27_118# 0
C40039 _639_/a_1583_191# _707_/a_298_337# 0
C40040 _639_/a_741_93# _707_/a_843_236# 0.00104f
C40041 _639_/a_843_236# _707_/a_741_93# 0
C40042 net44 _002_ 0
C40043 VPWR _124_ 0.16032f
C40044 _134_ _426_/a_154_118# 0.00155f
C40045 _699_/a_2002_114# VPWR 0
C40046 _639_/a_1840_334# net19 0.00736f
C40047 FILLER_24_218/a_40_246# _638_/a_298_337# 0
C40048 _382_/a_382_118# net137 0.0281f
C40049 net157 _523_/a_257_140# 0
C40050 _081_ net26 0.01753f
C40051 net55 _381_/a_268_412# 0
C40052 hold98/a_438_182# hold117/a_56_118# 0
C40053 hold98/a_326_118# hold117/a_326_118# 0.00127f
C40054 _102_ _689_/a_741_93# 0.00172f
C40055 FILLER_16_166/a_32_246# clknet_0_clk 0
C40056 FILLER_22_133/a_40_246# _256_ 0
C40057 _674_/a_1840_334# VPWR 0.00571f
C40058 _040_ clknet_4_5_0_clk 0.12707f
C40059 baud_inst.counter\[8\] FILLER_8_70/a_32_246# 0
C40060 net72 _264_ 0
C40061 baud_inst.counter\[30\] _165_ 0.00133f
C40062 _638_/a_298_337# _632_/a_298_337# 0.00269f
C40063 _662_/a_741_93# VPWR 0.03654f
C40064 hold96/a_438_182# net135 0.0138f
C40065 hold96/a_326_118# _287_ 0.01493f
C40066 _663_/a_2250_412# _166_ 0
C40067 _083_ FILLER_12_117/a_40_246# 0
C40068 _655_/a_612_127# net40 0.01729f
C40069 hold53/a_56_118# _640_/a_1583_191# 0
C40070 net53 _640_/a_38_114# 0.0272f
C40071 clknet_4_7_0_clk rx 0.00587f
C40072 FILLER_0_109/a_32_246# _383_/a_46_156# 0.0073f
C40073 _217_ VPWR 0.10749f
C40074 hold121/a_56_118# net49 0.01318f
C40075 _645_/a_741_93# _644_/a_298_337# 0
C40076 _645_/a_324_432# _644_/a_38_114# 0
C40077 _673_/a_38_114# VPWR 0.00653f
C40078 clknet_4_5_0_clk _006_ 0.27762f
C40079 _677_/a_132_114# clknet_0_clk 0
C40080 _270_ _647_/a_2002_114# 0
C40081 FILLER_8_189/a_40_246# FILLER_6_189/a_40_246# 0
C40082 _097_ hold178/a_438_182# 0.00461f
C40083 hold118/a_438_182# _668_/a_1840_334# 0
C40084 FILLER_19_178/a_40_246# VPWR 0.15f
C40085 _639_/a_1583_191# hold51/a_438_182# 0
C40086 _138_ hold127/a_56_118# 0
C40087 net42 _274_ 0
C40088 net177 _684_/a_1489_191# 0
C40089 _692_/a_843_236# _104_ 0
C40090 fanout46/a_40_152# fanout49/a_40_152# 0.00944f
C40091 FILLER_1_90/a_32_246# _207_ 0
C40092 _678_/a_1583_191# VPWR 0.00498f
C40093 hold55/a_326_118# _077_ 0
C40094 _082_ rx_inst.state\[2\] 0
C40095 _227_ _205_ 0.04376f
C40096 _688_/a_2002_114# net40 0
C40097 _232_ hold127/a_56_118# 0.02554f
C40098 _223_ FILLER_20_177/a_32_246# 0
C40099 hold108/a_56_118# _683_/a_1583_191# 0.00119f
C40100 baud_inst.counter\[13\] _684_/a_843_236# 0.00935f
C40101 _187_ _684_/a_681_505# 0
C40102 net149 fanout49/a_40_152# 0
C40103 fanout25/a_40_152# _247_ 0
C40104 clk FILLER_2_237/a_40_246# 0.00222f
C40105 clknet_0_clk _156_ 0
C40106 net13 _648_/a_741_93# 0
C40107 _170_ _259_ 0.015f
C40108 _678_/a_324_432# _036_ 0.00573f
C40109 FILLER_13_100/a_40_246# _685_/a_1840_334# 0
C40110 net73 _636_/a_298_337# 0
C40111 _178_ FILLER_22_54/a_40_246# 0
C40112 _020_ _164_ 0
C40113 _341_/a_71_118# clk 0.00882f
C40114 _687_/a_298_337# _296_ 0.00128f
C40115 net163 _018_ 0
C40116 _307_ FILLER_19_55/a_40_246# 0.00668f
C40117 net30 rx_inst.data_reg\[6\] 0.05981f
C40118 _632_/a_324_432# net30 0.02179f
C40119 _632_/a_38_114# _266_ 0.00395f
C40120 rx_inst.state\[2\] _452_/a_155_412# 0.02916f
C40121 _531_/a_209_168# _103_ 0
C40122 _230_ _241_ 0
C40123 _230_ FILLER_25_163/a_32_246# 0
C40124 _444_/a_550_140# net24 0
C40125 _671_/a_1583_191# clkbuf_4_6_0_clk/a_27_118# 0
C40126 _636_/a_132_114# _264_ 0
C40127 hold148/a_56_118# FILLER_24_19/a_40_246# 0
C40128 _034_ baud_inst.counter\[5\] 0
C40129 tx_inst.data_reg\[6\] _341_/a_1023_118# 0
C40130 rx_inst.state\[3\] _676_/a_2250_412# 0
C40131 _696_/a_612_127# baud_inst.counter\[15\] 0
C40132 _083_ hold123/a_326_118# 0
C40133 hold102/a_438_182# net102 0
C40134 rx_inst.state\[2\] clknet_0_clk 0.04689f
C40135 net36 FILLER_23_143/a_32_246# 0
C40136 _392_/a_59_156# _664_/a_612_127# 0
C40137 _000_ _668_/a_38_114# 0.00621f
C40138 FILLER_19_75/a_40_246# net46 0.00297f
C40139 _431_/a_81_118# _431_/a_379_118# -0
C40140 _178_ _694_/a_2250_412# 0.00274f
C40141 _455_/a_155_412# net52 0.02107f
C40142 _382_/a_496_118# _209_ 0.00112f
C40143 VPWR _251_ 0.05997f
C40144 hold86/a_326_118# _086_ 0
C40145 FILLER_11_142/a_40_246# _667_/a_298_337# 0
C40146 hold166/a_56_118# net167 0
C40147 hold166/a_326_118# _002_ 0.00948f
C40148 net166 hold167/a_56_118# 0
C40149 net41 _664_/a_1489_191# 0
C40150 FILLER_2_81/a_32_246# net38 0.01919f
C40151 _395_/a_248_122# _200_ 0
C40152 _432_/a_248_122# _170_ 0
C40153 _170_ _157_ 0.05477f
C40154 _536_/a_435_412# _304_ 0
C40155 _536_/a_155_160# net147 0
C40156 net39 net152 0.14401f
C40157 _688_/a_741_93# net160 0.00118f
C40158 _688_/a_324_432# _296_ 0
C40159 hold101/a_56_118# baud_inst.counter\[16\] 0
C40160 rx_data[7] _639_/a_1583_191# 0
C40161 _315_ hold105/a_326_118# 0.00416f
C40162 _254_ _224_ 0.0121f
C40163 _536_/a_155_160# net46 0
C40164 clk FILLER_1_237/a_40_246# 0.00799f
C40165 _703_/a_324_432# _702_/a_741_93# 0
C40166 baud_inst.counter\[20\] _692_/a_1785_429# 0
C40167 hold59/a_438_182# net49 0
C40168 _677_/a_132_114# _182_ 0
C40169 _644_/a_1840_334# net47 0
C40170 rx_inst.bit_index\[1\] _418_/a_46_156# 0.01547f
C40171 hold146/a_56_118# net172 0
C40172 _099_ _669_/a_741_93# 0
C40173 _389_/a_268_412# _381_/a_46_156# 0
C40174 _206_ _066_ 0
C40175 _662_/a_324_432# net179 0.00818f
C40176 _508_/a_177_436# net40 0
C40177 _699_/a_1785_429# _027_ 0.00112f
C40178 _377_/a_46_156# net10 0.10348f
C40179 _680_/a_324_432# _030_ 0
C40180 rx_inst.data_reg\[7\] hold81/a_56_118# 0.00186f
C40181 _126_ _129_ 0
C40182 net48 hold139/a_326_118# 0.02794f
C40183 _021_ _693_/a_741_93# 0.00927f
C40184 _658_/a_2250_412# tx_inst.data_reg\[2\] 0
C40185 _266_ _124_ 0.02942f
C40186 net120 net76 0.0156f
C40187 net177 hold89/a_56_118# 0
C40188 net51 _650_/a_741_93# 0
C40189 net26 _671_/a_1840_334# 0.01123f
C40190 _227_ _642_/a_1583_191# 0
C40191 hold77/a_56_118# _158_ 0.00392f
C40192 _650_/a_1489_191# _157_ 0
C40193 _696_/a_843_236# clknet_4_9_0_clk 0
C40194 hold181/a_438_182# net96 0
C40195 _676_/a_612_127# clknet_0_clk 0.00157f
C40196 clknet_4_6_0_clk net30 0
C40197 net177 _187_ 0.01007f
C40198 rx_inst.state\[2\] hold166/a_438_182# 0
C40199 _467_/a_22_110# net30 0.00216f
C40200 net45 _310_ 0
C40201 _645_/a_1583_191# net47 0
C40202 net82 VPWR 0.04907f
C40203 _697_/a_298_337# baud_inst.counter\[25\] 0
C40204 _697_/a_324_432# net99 0
C40205 _029_ clknet_4_10_0_clk 0
C40206 _679_/a_1583_191# clknet_0_clk 0.00416f
C40207 hold153/a_438_182# net29 0.03842f
C40208 hold106/a_438_182# _701_/a_324_432# 0
C40209 hold106/a_326_118# _701_/a_741_93# 0.00231f
C40210 hold106/a_56_118# _701_/a_843_236# 0.0028f
C40211 hold165/a_56_118# _379_/a_46_156# 0.05339f
C40212 clknet_4_5_0_clk _392_/a_59_156# 0.00309f
C40213 baud_inst.counter\[8\] _183_ 0.51633f
C40214 net23 net22 0.07296f
C40215 net132 _236_ 0
C40216 net43 hold50/a_438_182# 0.00226f
C40217 net62 _669_/a_843_236# 0
C40218 hold161/a_326_118# hold102/a_56_118# 0.00427f
C40219 hold161/a_56_118# hold102/a_326_118# 0.00427f
C40220 hold87/a_438_182# baud_inst.counter\[24\] 0
C40221 rx_data[0] _043_ 0
C40222 baud_inst.counter\[21\] _106_ 0
C40223 net73 net19 0.00118f
C40224 net2 _460_/a_22_110# 0.00663f
C40225 _312_ _542_/a_257_140# 0
C40226 _232_ _424_/a_244_412# 0.00379f
C40227 _699_/a_132_114# net45 0
C40228 net167 fanout26/a_40_152# 0
C40229 net31 net52 0.04027f
C40230 _676_/a_843_236# FILLER_10_110/a_40_246# 0
C40231 FILLER_17_162/a_32_246# _247_ 0
C40232 _644_/a_2250_412# net49 0
C40233 net47 _634_/a_550_127# 0
C40234 _292_ _685_/a_298_337# 0.01429f
C40235 net75 _692_/a_1840_334# 0
C40236 _305_ _692_/a_1583_191# 0
C40237 _706_/a_1583_191# _120_ 0
C40238 _706_/a_1840_334# net43 0
C40239 _671_/a_843_236# rx_inst.state\[4\] 0.01876f
C40240 rx_inst.bit_index\[2\] _427_/a_146_122# 0
C40241 hold169/a_56_118# net169 0
C40242 hold169/a_438_182# _166_ 0.051f
C40243 net55 tx_data[3] 0
C40244 tx_data[2] FILLER_0_130/a_32_246# 0.02325f
C40245 _199_ net11 0.02687f
C40246 tx_inst.data_reg\[0\] _208_ 0.02604f
C40247 _657_/a_298_337# VPWR 0.00298f
C40248 FILLER_24_156/a_32_246# net24 0.00151f
C40249 net182 hold153/a_438_182# 0
C40250 _696_/a_681_505# clknet_4_8_0_clk 0
C40251 _158_ _633_/a_741_93# 0.0108f
C40252 net37 _421_/a_150_412# 0.00894f
C40253 clknet_4_1_0_clk _655_/a_132_114# 0
C40254 net57 _195_ 0
C40255 _305_ hold148/a_438_182# 0.00105f
C40256 _645_/a_1840_334# net49 0
C40257 net35 FILLER_23_158/a_40_246# 0
C40258 clk _074_ 0.01211f
C40259 _291_ _683_/a_741_93# 0
C40260 net108 _683_/a_1583_191# 0.01636f
C40261 hold69/a_56_118# net17 0
C40262 _679_/a_741_93# net181 0
C40263 _679_/a_324_432# net86 0.00486f
C40264 hold174/a_438_182# hold169/a_326_118# 0
C40265 net27 net56 0.04027f
C40266 hold123/a_56_118# _670_/a_1489_191# 0
C40267 net123 _670_/a_1583_191# 0.00227f
C40268 hold65/a_56_118# _264_ 0
C40269 net47 _649_/a_1583_191# 0.02786f
C40270 net44 net99 0
C40271 output20/a_40_152# net22 0.00331f
C40272 net157 _299_ 0.29437f
C40273 output16/a_40_152# _647_/a_2250_412# 0
C40274 _191_ _670_/a_1840_334# 0.03737f
C40275 net44 _669_/a_298_337# 0.0238f
C40276 _058_ FILLER_16_203/a_32_246# 0
C40277 net37 _435_/a_72_436# 0.00239f
C40278 _388_/a_59_156# net5 0
C40279 _307_ net140 0.03528f
C40280 VPWR _632_/a_1840_334# 0.00277f
C40281 _656_/a_550_127# clknet_4_4_0_clk 0
C40282 _360_/a_1377_160# _206_ 0
C40283 _656_/a_612_127# tx_inst.data_reg\[2\] 0
C40284 hold54/a_326_118# _665_/a_1583_191# 0.00358f
C40285 _110_ _696_/a_1840_334# 0.00135f
C40286 net142 _696_/a_1583_191# 0
C40287 baud_inst.counter\[8\] net115 0.36713f
C40288 net39 _688_/a_38_114# 0
C40289 _663_/a_1489_191# clknet_4_7_0_clk 0
C40290 clkbuf_4_9_0_clk/a_27_118# FILLER_17_94/a_40_246# 0.00459f
C40291 _073_ tx_inst.state\[2\] 0.03066f
C40292 _227_ _374_/a_142_412# 0
C40293 _116_ _314_ 0
C40294 _226_ clknet_0_clk 0.013f
C40295 VPWR _668_/a_132_114# 0
C40296 net28 _223_ 0.00882f
C40297 net44 clkbuf_4_9_0_clk/a_27_118# 0.06916f
C40298 _675_/a_38_114# clknet_4_0_0_clk 0.00265f
C40299 baud_inst.counter\[3\] _672_/a_298_337# 0.00132f
C40300 VPWR net103 0.86245f
C40301 net30 net29 0
C40302 hold171/a_56_118# _658_/a_1583_191# 0
C40303 tx_inst.data_reg\[4\] _658_/a_324_432# 0.01133f
C40304 baud_inst.counter\[20\] _021_ 0.02196f
C40305 _554_/a_350_122# _180_ 0
C40306 _111_ _698_/a_1583_191# 0
C40307 net45 _698_/a_1840_334# 0.00195f
C40308 _696_/a_2250_412# _686_/a_843_236# 0
C40309 net35 FILLER_19_139/a_40_246# 0.01145f
C40310 baud_inst.counter\[30\] _702_/a_132_114# 0
C40311 baud_inst.counter\[28\] _702_/a_1840_334# 0
C40312 _257_ net2 0
C40313 clknet_4_0_0_clk FILLER_2_46/a_40_246# 0.00128f
C40314 net2 _256_ 0.00382f
C40315 _160_ net25 0
C40316 clk hold145/a_56_118# 0.07636f
C40317 FILLER_24_218/a_40_246# _049_ 0
C40318 _238_ _236_ 0.00481f
C40319 _698_/a_324_432# FILLER_20_95/a_40_246# 0
C40320 net96 net135 0.62478f
C40321 FILLER_16_154/a_32_246# rx_inst.state\[2\] 0
C40322 net18 _634_/a_1785_429# 0
C40323 VPWR _648_/a_681_505# 0
C40324 _635_/a_1840_334# net64 0
C40325 _273_ hold70/a_438_182# 0
C40326 _693_/a_38_114# clknet_4_10_0_clk 0.00718f
C40327 _508_/a_209_168# _682_/a_843_236# 0.00135f
C40328 hold152/a_438_182# net39 0
C40329 _246_ _260_ 0
C40330 _633_/a_741_93# _633_/a_1489_191# -0
C40331 net82 _266_ 0
C40332 _219_ _400_/a_192_429# 0.002f
C40333 _217_ _400_/a_155_160# 0
C40334 _314_ _701_/a_741_93# 0.00235f
C40335 FILLER_15_185/a_32_246# _000_ 0.01002f
C40336 net28 _240_ 0.00643f
C40337 _632_/a_298_337# _049_ 0
C40338 _694_/a_612_127# VPWR 0.00734f
C40339 _291_ _185_ 0
C40340 rx_data[1] _123_ 0.04919f
C40341 _309_ net46 0.16845f
C40342 _207_ _209_ 0.19649f
C40343 tx_inst.data_reg\[7\] _212_ 0.00396f
C40344 hold57/a_326_118# _220_ 0.0016f
C40345 hold57/a_56_118# _142_ 0.01048f
C40346 _379_/a_268_412# net54 0
C40347 hold76/a_438_182# hold120/a_438_182# 0.00262f
C40348 _662_/a_1785_429# VPWR 0
C40349 rx_done net80 0.2927f
C40350 _235_ _416_/a_146_122# 0
C40351 _155_ _429_/a_142_412# 0.0025f
C40352 _638_/a_741_93# _632_/a_843_236# 0
C40353 net70 _649_/a_1583_191# 0
C40354 _638_/a_843_236# _632_/a_741_93# 0
C40355 tx_data[3] _389_/a_46_156# 0
C40356 clknet_4_11_0_clk _702_/a_843_236# 0.00659f
C40357 hold102/a_56_118# _690_/a_298_337# 0
C40358 _145_ net40 0.04129f
C40359 net118 net19 0.07696f
C40360 FILLER_15_173/a_40_246# clknet_0_clk 0
C40361 _697_/a_298_337# baud_inst.counter\[24\] 0.03421f
C40362 _645_/a_1840_334# _644_/a_324_432# 0
C40363 _645_/a_1583_191# _644_/a_741_93# 0.00243f
C40364 _673_/a_1840_334# VPWR 0.00619f
C40365 net75 net148 0.0244f
C40366 net13 _059_ 0
C40367 _245_ _424_/a_142_412# 0
C40368 _230_ _443_/a_252_412# 0.0018f
C40369 _339_/a_1377_160# FILLER_6_151/a_40_246# 0.01106f
C40370 net2 fanout24/a_40_152# 0
C40371 _046_ rx_data[4] 0
C40372 VPWR _667_/a_843_236# 0.00323f
C40373 _692_/a_612_127# _104_ 0
C40374 VPWR hold95/a_326_118# 0.00688f
C40375 _098_ _685_/a_550_127# 0
C40376 hold119/a_326_118# _000_ 0.0013f
C40377 hold119/a_56_118# net30 0.07f
C40378 _115_ _700_/a_1489_191# 0.0195f
C40379 _699_/a_741_93# net49 0
C40380 _674_/a_1583_191# net60 0.00128f
C40381 net104 _103_ 0.01593f
C40382 FILLER_28_204/a_32_246# _648_/a_1840_334# 0
C40383 tx_data[2] _388_/a_59_156# 0
C40384 hold66/a_56_118# _638_/a_741_93# 0
C40385 _339_/a_71_118# _070_ 0.00191f
C40386 hold108/a_326_118# _683_/a_1489_191# 0
C40387 baud_inst.counter\[13\] _684_/a_612_127# 0.01998f
C40388 _187_ _684_/a_550_127# 0
C40389 net43 net172 0.03961f
C40390 _515_/a_76_160# net90 0
C40391 hold68/a_56_118# _113_ 0.00622f
C40392 net111 rx_inst.data_reg\[0\] 0.04352f
C40393 _675_/a_1840_334# FILLER_0_40/a_40_246# 0
C40394 rst VPWR 0.15927f
C40395 _060_ _649_/a_132_114# 0
C40396 clknet_0_clk _434_/a_252_412# 0
C40397 _045_ _264_ 0.02243f
C40398 tx_inst.data_reg\[4\] _656_/a_843_236# 0.00684f
C40399 FILLER_8_116/a_40_246# net39 0
C40400 _642_/a_741_93# hold176/a_326_118# 0.00299f
C40401 _642_/a_843_236# hold176/a_56_118# 0
C40402 _056_ FILLER_27_135/a_32_246# 0.01055f
C40403 _644_/a_298_337# _256_ 0
C40404 net167 baud_inst.counter\[14\] 0
C40405 _517_/a_177_436# _180_ 0.00124f
C40406 _645_/a_2250_412# FILLER_29_165/a_40_246# 0
C40407 _657_/a_843_236# tx_inst.data_reg\[1\] 0.01007f
C40408 _040_ _199_ 0
C40409 _687_/a_1583_191# _296_ 0.01016f
C40410 _632_/a_2250_412# net30 0
C40411 rx_inst.state\[3\] FILLER_11_125/a_32_246# 0
C40412 _139_ _154_ 0.4212f
C40413 _173_ _343_/a_257_140# 0
C40414 _194_ _343_/a_155_412# 0
C40415 _636_/a_1489_191# _264_ 0
C40416 rx_inst.data_reg\[1\] _138_ 0.00354f
C40417 net45 hold107/a_326_118# 0
C40418 _171_ _664_/a_1489_191# 0
C40419 hold128/a_438_182# baud_inst.counter\[13\] 0.01678f
C40420 _024_ baud_inst.counter\[15\] 0
C40421 net94 hold94/a_326_118# 0
C40422 tx_inst.data_reg\[5\] _068_ 0
C40423 _392_/a_59_156# _005_ 0
C40424 net168 _664_/a_38_114# 0.02672f
C40425 net156 _689_/a_132_114# 0
C40426 _266_ _668_/a_132_114# 0
C40427 net30 _668_/a_1583_191# 0
C40428 rx_inst.data_reg\[1\] _232_ 0
C40429 net52 _130_ 0.04195f
C40430 _680_/a_741_93# net116 0
C40431 _006_ _199_ 0.04861f
C40432 _680_/a_324_432# _039_ 0
C40433 _680_/a_843_236# _288_ 0
C40434 fanout32/a_40_152# net51 0
C40435 _126_ net16 0.3081f
C40436 FILLER_21_194/a_32_246# _160_ 0.0015f
C40437 net41 tx_inst.state\[2\] 0
C40438 net27 _476_/a_248_122# 0.00238f
C40439 hold149/a_56_118# _693_/a_741_93# 0.00785f
C40440 hold149/a_326_118# _693_/a_324_432# 0.00347f
C40441 fanout41/a_40_152# net137 0
C40442 _022_ _304_ 0.01943f
C40443 net145 _653_/a_324_432# 0
C40444 _477_/a_22_110# _007_ 0.02462f
C40445 _688_/a_2250_412# _296_ 0
C40446 _644_/a_2250_412# net131 0.0031f
C40447 clknet_4_11_0_clk net100 0.00259f
C40448 tx_inst.bit_index\[2\] _400_/a_192_429# 0.02845f
C40449 _703_/a_741_93# _702_/a_2250_412# 0
C40450 _023_ FILLER_22_32/a_40_246# 0.00157f
C40451 net41 FILLER_0_174/a_32_246# 0.0183f
C40452 FILLER_0_54/a_40_246# hold60/a_438_182# 0
C40453 hold143/a_438_182# _264_ 0
C40454 net13 _155_ 0
C40455 _677_/a_1489_191# _182_ 0.0018f
C40456 _266_ _648_/a_681_505# 0
C40457 hold65/a_56_118# hold69/a_438_182# 0
C40458 hold55/a_326_118# net43 0
C40459 _676_/a_741_93# baud_inst.counter\[4\] 0.01373f
C40460 _676_/a_843_236# net152 0
C40461 net48 _433_/a_244_140# 0
C40462 net36 _236_ 0.02335f
C40463 _658_/a_741_93# FILLER_3_141/a_40_246# 0.00125f
C40464 hold181/a_438_182# hold135/a_438_182# 0
C40465 _176_ _005_ 0.00468f
C40466 tx_inst.state\[4\] _200_ 0.00872f
C40467 net12 _049_ 0.00493f
C40468 hold174/a_326_118# _166_ 0.00423f
C40469 output23/a_40_152# _121_ 0
C40470 _351_/a_46_156# baud_inst.counter\[5\] 0.01515f
C40471 hold167/a_56_118# clknet_4_9_0_clk 0.01526f
C40472 _634_/a_38_114# net83 0.01074f
C40473 _643_/a_741_93# FILLER_21_194/a_32_246# 0.00112f
C40474 _069_ clknet_4_4_0_clk 0.00666f
C40475 _282_ _683_/a_324_432# 0
C40476 _090_ net153 0
C40477 net39 _035_ 0
C40478 _555_/a_177_436# VPWR 0
C40479 net46 FILLER_20_0/a_40_246# 0.00338f
C40480 FILLER_0_35/a_40_246# _675_/a_843_236# 0
C40481 hold178/a_56_118# _296_ 0
C40482 _180_ _685_/a_132_114# 0
C40483 _486_/a_115_308# net29 0.00334f
C40484 FILLER_16_154/a_32_246# _226_ 0.01531f
C40485 FILLER_13_102/a_32_246# net29 0
C40486 net156 _690_/a_1583_191# 0
C40487 net12 _638_/a_1583_191# 0.01684f
C40488 _034_ clknet_0_clk 0.04163f
C40489 baud_inst.counter\[18\] net49 0.11727f
C40490 clknet_4_5_0_clk _276_ 0.01277f
C40491 hold150/a_326_118# _123_ 0
C40492 _314_ hold105/a_438_182# 0.01147f
C40493 hold75/a_438_182# _302_ 0
C40494 _697_/a_1583_191# baud_inst.counter\[25\] 0.0044f
C40495 _679_/a_2002_114# clknet_0_clk 0
C40496 hold85/a_56_118# VPWR 0.00978f
C40497 _640_/a_1583_191# net24 0
C40498 _635_/a_843_236# VPWR 0.00313f
C40499 VPWR _086_ 0.23482f
C40500 _188_ _187_ 0.06246f
C40501 _481_/a_120_432# _196_ 0
C40502 FILLER_21_96/a_40_246# _310_ 0
C40503 _025_ FILLER_20_95/a_40_246# 0
C40504 hold153/a_438_182# _493_/a_45_160# 0
C40505 FILLER_19_149/a_40_246# clknet_0_clk 0.0015f
C40506 hold169/a_56_118# _651_/a_2250_412# 0
C40507 _098_ _686_/a_324_432# 0
C40508 net35 _230_ 2.74243f
C40509 _091_ VPWR 0.22205f
C40510 net50 _376_/a_170_160# 0.00133f
C40511 net42 _284_ 0.00423f
C40512 _695_/a_1489_191# _313_ 0
C40513 _315_ baud_inst.counter\[29\] 0.00789f
C40514 net45 _694_/a_741_93# 0.0032f
C40515 FILLER_0_130/a_32_246# _210_ 0
C40516 net31 FILLER_26_141/a_40_246# 0
C40517 _699_/a_1489_191# net45 0.00152f
C40518 net41 _197_ 0
C40519 rx_data[7] FILLER_16_221/a_32_246# 0
C40520 _292_ _685_/a_1583_191# 0
C40521 hold164/a_326_118# net104 0
C40522 _023_ _692_/a_1489_191# 0
C40523 hold117/a_438_182# clknet_4_0_0_clk 0.00122f
C40524 hold110/a_326_118# net97 0.00529f
C40525 hold110/a_438_182# net108 0.00929f
C40526 _671_/a_612_127# rx_inst.state\[4\] 0.01211f
C40527 net40 hold93/a_438_182# 0.05172f
C40528 _705_/a_843_236# _704_/a_1583_191# 0
C40529 net182 FILLER_13_102/a_32_246# 0
C40530 _705_/a_1583_191# _704_/a_843_236# 0
C40531 hold150/a_56_118# _159_ 0
C40532 _160_ _632_/a_843_236# 0
C40533 _657_/a_1583_191# VPWR 0.01561f
C40534 net27 _196_ 0
C40535 net81 _636_/a_843_236# 0
C40536 clknet_4_13_0_clk _636_/a_741_93# 0.03507f
C40537 net184 _193_ 0.04758f
C40538 _162_ clknet_4_2_0_clk 0
C40539 clknet_4_1_0_clk _655_/a_1489_191# 0.01762f
C40540 _661_/a_324_432# tx_inst.data_reg\[1\] 0
C40541 _091_ hold93/a_326_118# 0.00978f
C40542 net90 net91 0.46271f
C40543 rx_inst.state\[3\] _669_/a_843_236# 0
C40544 _158_ _633_/a_1785_429# 0
C40545 hold141/a_56_118# baud_inst.counter\[25\] 0.02245f
C40546 hold141/a_438_182# net99 0
C40547 tx_inst.bit_index\[0\] net43 0
C40548 _688_/a_681_505# clknet_4_2_0_clk 0
C40549 FILLER_22_133/a_40_246# net36 0.0241f
C40550 _504_/a_177_436# _287_ 0.00105f
C40551 _504_/a_209_168# _038_ 0.02441f
C40552 _705_/a_843_236# net43 0.00863f
C40553 hold164/a_56_118# _020_ 0.047f
C40554 hold164/a_438_182# net163 0.00349f
C40555 tx_inst.data_reg\[6\] net170 0.0061f
C40556 hold101/a_326_118# FILLER_17_22/a_40_246# 0
C40557 net38 FILLER_6_21/a_40_246# 0.01071f
C40558 _277_ clknet_0_clk 0.07058f
C40559 FILLER_20_57/a_32_246# baud_inst.counter\[25\] 0
C40560 rx_inst.data_reg\[3\] _635_/a_324_432# 0
C40561 _185_ baud_inst.counter\[4\] 0.279f
C40562 net47 _649_/a_2002_114# 0.00169f
C40563 _060_ hold127/a_326_118# 0
C40564 net135 hold60/a_438_182# 0
C40565 _287_ hold60/a_326_118# 0
C40566 net49 _437_/a_154_118# 0
C40567 rx_inst.bit_index\[1\] _641_/a_1489_191# 0
C40568 net44 _669_/a_1583_191# 0
C40569 hold125/a_56_118# _648_/a_741_93# 0
C40570 hold125/a_438_182# _648_/a_38_114# 0
C40571 _034_ _182_ 0
C40572 tx_done tx_start 0.03195f
C40573 net55 _198_ 0.18456f
C40574 rx_inst.state\[2\] _436_/a_550_140# 0
C40575 _662_/a_38_114# clk 0.00124f
C40576 tx_inst.bit_index\[1\] _206_ 0
C40577 _676_/a_1583_191# clknet_4_9_0_clk 0
C40578 _670_/a_324_432# VPWR 0.00595f
C40579 net18 hold71/a_438_182# 0.02679f
C40580 _090_ _280_ 0.00447f
C40581 clknet_4_7_0_clk tx_inst.state\[1\] 0.02234f
C40582 net39 _688_/a_1840_334# 0
C40583 clknet_4_3_0_clk _685_/a_741_93# 0
C40584 _640_/a_2250_412# _161_ 0
C40585 _046_ hold66/a_438_182# 0.00357f
C40586 hold183/a_326_118# net43 0
C40587 FILLER_4_108/a_40_246# clkbuf_4_1_0_clk/a_27_118# 0
C40588 _706_/a_1489_191# net21 0
C40589 _118_ _275_ 0.02023f
C40590 net128 _191_ 0
C40591 hold135/a_438_182# net135 0.0158f
C40592 hold135/a_326_118# _287_ 0
C40593 net156 hold158/a_326_118# 0.01771f
C40594 _234_ fanout25/a_40_152# 0
C40595 _675_/a_1840_334# clknet_4_0_0_clk 0.00416f
C40596 FILLER_11_32/a_32_246# _096_ 0.00153f
C40597 VPWR net101 0.10654f
C40598 hold61/a_326_118# _033_ 0.00173f
C40599 hold61/a_56_118# net61 0
C40600 tx_inst.data_reg\[4\] _658_/a_2250_412# 0.00389f
C40601 hold159/a_56_118# _206_ 0
C40602 _482_/a_154_118# clknet_0_clk 0
C40603 _111_ _698_/a_2002_114# 0
C40604 baud_inst.counter\[30\] _702_/a_1489_191# 0.01032f
C40605 net55 tx_start 0
C40606 clknet_0_clk _669_/a_132_114# 0
C40607 net54 _706_/a_741_93# 0.01295f
C40608 _705_/a_324_432# net21 0
C40609 hold87/a_56_118# net141 0
C40610 VPWR _648_/a_550_127# 0
C40611 _116_ _347_/a_248_122# 0
C40612 _693_/a_1840_334# clknet_4_10_0_clk 0
C40613 FILLER_7_9/a_32_246# _094_ 0.01204f
C40614 net173 _398_/a_358_436# 0.00119f
C40615 hold108/a_438_182# _292_ 0
C40616 _444_/a_142_412# _236_ 0.00584f
C40617 _169_ _416_/a_248_122# 0
C40618 _635_/a_681_505# net30 0
C40619 _635_/a_843_236# _266_ 0.00128f
C40620 _218_ _221_ 0
C40621 clknet_4_13_0_clk hold81/a_326_118# 0.03645f
C40622 net81 hold81/a_438_182# 0
C40623 hold85/a_56_118# _266_ 0.00251f
C40624 hold85/a_326_118# net30 0.02441f
C40625 net30 hold70/a_56_118# 0.01117f
C40626 hold141/a_326_118# _180_ 0.0503f
C40627 FILLER_13_89/a_40_246# _685_/a_38_114# 0
C40628 _513_/a_192_429# net40 0.00987f
C40629 _663_/a_843_236# clknet_4_6_0_clk 0.00926f
C40630 _216_ _666_/a_741_93# 0
C40631 hold152/a_438_182# _676_/a_843_236# 0.00148f
C40632 net37 _000_ 0.02506f
C40633 _698_/a_38_114# _051_ 0.00195f
C40634 _363_/a_120_432# _193_ 0
C40635 _194_ tx_inst.bit_index\[1\] 0.01654f
C40636 _355_/a_252_412# _296_ 0.00153f
C40637 hold121/a_326_118# net121 0
C40638 _644_/a_38_114# _055_ 0
C40639 _644_/a_298_337# net132 0.00324f
C40640 rx_inst.bit_index\[1\] _224_ 0.02408f
C40641 _660_/a_298_337# _656_/a_2250_412# 0
C40642 baud_inst.counter\[27\] _112_ 0
C40643 clkbuf_4_10_0_clk/a_27_118# _695_/a_2250_412# 0.00298f
C40644 hold155/a_56_118# _658_/a_132_114# 0
C40645 _677_/a_843_236# _282_ 0
C40646 _200_ FILLER_7_210/a_40_246# 0.00898f
C40647 VPWR _682_/a_843_236# 0.02752f
C40648 _548_/a_76_160# _312_ 0.03969f
C40649 hold116/a_56_118# baud_inst.counter\[10\] 0.0034f
C40650 _638_/a_1583_191# _632_/a_1583_191# 0.0061f
C40651 hold53/a_56_118# _263_ 0.01197f
C40652 net6 _213_ 0.0046f
C40653 clknet_4_11_0_clk _702_/a_612_127# 0.00219f
C40654 _302_ net107 0.01217f
C40655 tx_data[6] _380_/a_382_118# 0
C40656 net9 _380_/a_59_156# 0.03266f
C40657 net34 _402_/a_154_118# 0.00195f
C40658 net123 net39 0.03911f
C40659 net156 baud_inst.counter\[14\] 0.00137f
C40660 _017_ _690_/a_324_432# 0.00514f
C40661 net102 _690_/a_38_114# 0.01623f
C40662 net184 net174 0
C40663 _076_ _198_ 0.00429f
C40664 clkbuf_4_13_0_clk/a_27_118# _156_ 0
C40665 _043_ _632_/a_132_114# 0
C40666 hold53/a_438_182# clknet_4_14_0_clk 0.00481f
C40667 _697_/a_1583_191# baud_inst.counter\[24\] 0
C40668 _645_/a_298_337# _055_ 0.00675f
C40669 _645_/a_2250_412# _644_/a_1840_334# 0
C40670 hold79/a_438_182# net60 0.00126f
C40671 hold79/a_326_118# _181_ 0
C40672 _661_/a_681_505# VPWR 0
C40673 net138 _636_/a_38_114# 0
C40674 rx_inst.data_reg\[4\] _636_/a_324_432# 0
C40675 VPWR _702_/a_298_337# 0.00198f
C40676 _677_/a_298_337# net153 0
C40677 _230_ _254_ 0.09018f
C40678 _640_/a_132_114# VPWR 0
C40679 VPWR _667_/a_612_127# 0
C40680 clkbuf_0_clk/a_116_82# net29 0.01923f
C40681 net164 _104_ 0.00175f
C40682 hold52/a_438_182# _254_ 0
C40683 hold52/a_326_118# _256_ 0
C40684 net49 _694_/a_298_337# 0.01527f
C40685 net156 net97 0.0026f
C40686 _098_ clknet_4_9_0_clk 0.03388f
C40687 _650_/a_298_337# _000_ 0.00274f
C40688 hold131/a_56_118# _272_ 0
C40689 _674_/a_1489_191# _181_ 0.00208f
C40690 hold54/a_438_182# _201_ 0
C40691 _232_ _251_ 0
C40692 clknet_4_10_0_clk FILLER_24_19/a_40_246# 0.00761f
C40693 net66 _638_/a_843_236# 0
C40694 hold108/a_326_118# baud_inst.counter\[11\] 0
C40695 net28 FILLER_12_166/a_40_246# 0
C40696 _679_/a_324_432# net38 0
C40697 _650_/a_38_114# _458_/a_279_412# 0
C40698 _269_ _636_/a_1489_191# 0
C40699 net49 net25 0.03772f
C40700 tx_inst.data_reg\[4\] _656_/a_612_127# 0.00487f
C40701 FILLER_12_106/a_40_246# _685_/a_1583_191# 0
C40702 net44 _533_/a_146_122# 0
C40703 net92 baud_inst.counter\[6\] 0.18858f
C40704 _422_/a_146_122# _223_ 0
C40705 _013_ _180_ 0.14882f
C40706 _673_/a_1583_191# net60 0.03173f
C40707 _657_/a_612_127# tx_inst.data_reg\[1\] 0.00249f
C40708 _687_/a_2002_114# _296_ 0
C40709 _286_ _352_/a_46_156# 0
C40710 net55 tx_data[5] 0
C40711 _651_/a_1583_191# _166_ 0.00279f
C40712 _392_/a_382_118# tx_inst.data_reg\[0\] 0.01127f
C40713 _392_/a_559_412# _144_ 0.00153f
C40714 hold80/a_56_118# hold51/a_56_118# 0.02531f
C40715 _180_ baud_inst.counter\[14\] 0.18105f
C40716 _276_ _005_ 0.11333f
C40717 _171_ tx_inst.state\[2\] 0
C40718 hold141/a_326_118# net140 0.00761f
C40719 hold141/a_56_118# baud_inst.counter\[24\] 0.0017f
C40720 FILLER_8_19/a_40_246# net40 0.02406f
C40721 _634_/a_2250_412# hold71/a_438_182# 0
C40722 _200_ _664_/a_1583_191# 0.00375f
C40723 net168 _664_/a_1840_334# 0.01938f
C40724 net172 _664_/a_2250_412# 0.02348f
C40725 rx_inst.state\[3\] clknet_4_3_0_clk 0
C40726 _266_ _668_/a_1489_191# 0.00182f
C40727 _355_/a_150_412# net88 0
C40728 _224_ FILLER_22_152/a_32_246# 0.00232f
C40729 baud_inst.counter\[23\] hold103/a_326_118# 0
C40730 FILLER_20_57/a_32_246# baud_inst.counter\[24\] 0
C40731 _636_/a_38_114# _047_ 0.05881f
C40732 tx_busy tx_done 0.16409f
C40733 rx_inst.data_reg\[1\] hold131/a_438_182# 0.0194f
C40734 _133_ _258_ 0.12159f
C40735 hold52/a_326_118# fanout24/a_40_152# 0
C40736 baud_inst.counter\[1\] _672_/a_843_236# 0.00169f
C40737 hold86/a_326_118# _672_/a_1840_334# 0
C40738 hold86/a_438_182# _672_/a_1583_191# 0.00297f
C40739 tx tx_inst.state\[3\] 0.00801f
C40740 _062_ VPWR 0.1572f
C40741 _636_/a_550_127# _156_ 0
C40742 _703_/a_324_432# _115_ 0
C40743 _422_/a_146_122# _240_ 0
C40744 net31 clknet_0_clk 0.03234f
C40745 net30 _648_/a_1489_191# 0
C40746 hold100/a_438_182# VPWR 0.00548f
C40747 tx_inst.bit_index\[1\] _341_/a_886_118# 0.00113f
C40748 _676_/a_1785_429# baud_inst.counter\[4\] 0.00277f
C40749 clkbuf_4_12_0_clk/a_27_118# _435_/a_72_436# 0
C40750 net30 FILLER_29_198/a_40_246# 0.00144f
C40751 _116_ _703_/a_298_337# 0.04065f
C40752 _022_ FILLER_22_22/a_32_246# 0
C40753 net174 net169 0
C40754 _194_ hold174/a_56_118# 0.05471f
C40755 hold116/a_438_182# _010_ 0
C40756 net42 _663_/a_298_337# 0.02618f
C40757 FILLER_26_229/a_32_246# _637_/a_1583_191# 0
C40758 _046_ _635_/a_324_432# 0.03613f
C40759 net44 net102 0
C40760 _442_/a_146_122# _253_ 0
C40761 _296_ _520_/a_257_140# 0
C40762 net49 FILLER_25_7/a_40_246# 0.00328f
C40763 VPWR _281_ 0.02295f
C40764 _469_/a_22_110# net47 0.00526f
C40765 net51 _061_ 0
C40766 _546_/a_341_118# net99 0.00429f
C40767 _681_/a_298_337# net117 0.00138f
C40768 net128 hold91/a_438_182# 0.00186f
C40769 hold89/a_56_118# net89 0
C40770 _677_/a_298_337# _280_ 0.00159f
C40771 net12 _638_/a_2002_114# 0
C40772 _454_/a_155_412# net24 0.03159f
C40773 _666_/a_741_93# _666_/a_843_236# -0
C40774 _010_ net97 0.31962f
C40775 _697_/a_2002_114# baud_inst.counter\[25\] 0
C40776 net3 input9/a_40_152# 0.0302f
C40777 input3/a_40_152# net9 0
C40778 net89 _187_ 0.00268f
C40779 hold162/a_56_118# _544_/a_46_156# 0
C40780 FILLER_6_205/a_40_246# clkbuf_4_5_0_clk/a_27_118# 0.01094f
C40781 net65 hold72/a_438_182# 0
C40782 FILLER_27_194/a_40_246# net30 0.03252f
C40783 hold106/a_56_118# net107 0
C40784 _640_/a_2002_114# net24 0
C40785 _642_/a_324_432# baud_inst.counter\[25\] 0
C40786 _283_ _677_/a_324_432# 0.00695f
C40787 FILLER_12_0/a_32_246# VPWR 0.06641f
C40788 _171_ _197_ 0.12041f
C40789 clknet_0_clk clkbuf_4_15_0_clk/a_27_118# 0.07979f
C40790 hold175/a_56_118# _451_/a_155_412# 0
C40791 hold68/a_56_118# _700_/a_324_432# 0.00258f
C40792 _287_ _349_/a_146_122# 0.00105f
C40793 _246_ _248_ 0
C40794 net14 _637_/a_681_505# 0
C40795 _536_/a_192_429# _534_/a_46_156# 0.00265f
C40796 _672_/a_38_114# VPWR 0.00219f
C40797 _414_/a_165_412# net166 0
C40798 net36 net2 0.18281f
C40799 net45 _694_/a_1785_429# 0
C40800 baud_inst.counter\[15\] baud_inst.counter\[24\] 0
C40801 _658_/a_38_114# net5 0
C40802 net180 _241_ 0
C40803 clknet_4_12_0_clk _061_ 0
C40804 _653_/a_324_432# _220_ 0
C40805 _653_/a_38_114# _142_ 0.00869f
C40806 hold85/a_326_118# hold74/a_326_118# 0
C40807 _064_ _653_/a_298_337# 0.0126f
C40808 net42 _653_/a_38_114# 0.00894f
C40809 _351_/a_46_156# clknet_0_clk 0
C40810 _160_ _632_/a_612_127# 0
C40811 _359_/a_22_110# VPWR 0.00312f
C40812 _705_/a_2250_412# _704_/a_2250_412# 0
C40813 net27 _365_/a_155_412# 0
C40814 _201_ _665_/a_324_432# 0.00186f
C40815 _203_ _665_/a_38_114# 0
C40816 _678_/a_1583_191# clkbuf_4_1_0_clk/a_27_118# 0.00528f
C40817 rx_done _121_ 0
C40818 _059_ hold125/a_56_118# 0.00599f
C40819 FILLER_21_192/a_40_246# clknet_0_clk 0
C40820 hold142/a_438_182# _025_ 0.00193f
C40821 tx_data[5] _389_/a_46_156# 0
C40822 _657_/a_2002_114# VPWR 0
C40823 FILLER_13_89/a_40_246# clknet_0_clk 0.00175f
C40824 _649_/a_1583_191# _649_/a_2250_412# 0
C40825 _556_/a_192_429# _112_ 0
C40826 clkbuf_4_11_0_clk/a_27_118# clkload2/Y 0.10916f
C40827 clknet_4_1_0_clk tx_inst.data_reg\[1\] 0.15192f
C40828 _099_ _685_/a_298_337# 0
C40829 net48 clknet_4_13_0_clk 0.01643f
C40830 _688_/a_550_127# clknet_4_2_0_clk 0
C40831 input7/a_40_152# net7 0.01007f
C40832 _287_ _038_ 0.16127f
C40833 _705_/a_612_127# net43 0.0026f
C40834 VPWR _650_/a_681_505# 0
C40835 _291_ _096_ 0
C40836 _432_/a_248_122# _247_ 0
C40837 _157_ _247_ 0.00937f
C40838 FILLER_27_210/a_40_246# rx_inst.data_reg\[5\] 0.00172f
C40839 _019_ _673_/a_298_337# 0
C40840 net88 _520_/a_155_412# 0.06947f
C40841 _232_ _444_/a_244_140# 0
C40842 _180_ _546_/a_155_160# 0
C40843 _044_ net131 0.00499f
C40844 _634_/a_324_432# _124_ 0.01769f
C40845 net36 _411_/a_115_308# 0
C40846 net79 _491_/a_341_118# 0.00447f
C40847 hold54/a_438_182# tx_inst.state\[3\] 0.00203f
C40848 net34 _222_ 0.1735f
C40849 _170_ _435_/a_166_436# 0
C40850 rx_inst.state\[2\] _249_ 0
C40851 net32 _435_/a_72_436# 0.04786f
C40852 _638_/a_843_236# hold70/a_326_118# 0
C40853 _638_/a_741_93# hold70/a_438_182# 0
C40854 _662_/a_1840_334# clk 0.00299f
C40855 _670_/a_2250_412# VPWR 0.00498f
C40856 _636_/a_298_337# net80 0
C40857 _378_/a_496_118# net7 0
C40858 hold63/a_56_118# net62 0
C40859 hold157/a_326_118# baud_inst.counter\[16\] 0.00559f
C40860 _132_ _696_/a_2250_412# 0
C40861 clknet_4_10_0_clk _701_/a_681_505# 0
C40862 _043_ _635_/a_324_432# 0
C40863 _078_ net168 0.02959f
C40864 _360_/a_1453_124# _208_ 0
C40865 _042_ net21 0.0107f
C40866 _405_/a_27_156# _667_/a_1583_191# 0
C40867 _048_ _633_/a_324_432# 0
C40868 _358_/a_72_436# _357_/a_150_412# 0
C40869 VPWR rx_inst.state\[1\] 0.08544f
C40870 baud_inst.counter\[15\] FILLER_15_42/a_40_246# 0.01619f
C40871 hold112/a_56_118# FILLER_20_177/a_32_246# 0
C40872 _533_/a_146_122# _302_ 0.00233f
C40873 output12/a_40_152# hold71/a_56_118# 0
C40874 _394_/a_22_110# _166_ 0
C40875 clk _667_/a_324_432# 0.03033f
C40876 _180_ _686_/a_741_93# 0.00124f
C40877 net49 _139_ 0
C40878 hold137/a_56_118# _653_/a_612_127# 0
C40879 _684_/a_843_236# net29 0
C40880 hold88/a_56_118# VPWR 0.00627f
C40881 hold99/a_438_182# net100 0.01162f
C40882 clknet_0_clk _669_/a_1489_191# 0
C40883 _114_ net45 1.55511f
C40884 net54 _706_/a_1785_429# 0.00315f
C40885 _378_/a_496_118# net155 0.00383f
C40886 _652_/a_681_505# _142_ 0
C40887 FILLER_10_147/a_32_246# clk 0.00141f
C40888 _351_/a_46_156# _182_ 0.00243f
C40889 _544_/a_46_156# net141 0.01449f
C40890 _283_ _679_/a_741_93# 0
C40891 net94 _679_/a_681_505# 0
C40892 _285_ _679_/a_324_432# 0.01103f
C40893 net92 _679_/a_843_236# 0.00183f
C40894 _527_/a_155_160# baud_inst.counter\[16\] 0
C40895 _179_ _116_ 0.0344f
C40896 _286_ _679_/a_298_337# 0
C40897 net42 _652_/a_681_505# 0.00143f
C40898 _064_ _652_/a_843_236# 0.00295f
C40899 net178 net39 0.0098f
C40900 _155_ hold125/a_56_118# 0.01282f
C40901 _170_ net24 0.04256f
C40902 _227_ net175 0.00472f
C40903 rx_data[3] net16 0
C40904 _704_/a_1840_334# hold80/a_56_118# 0
C40905 _058_ _057_ 0.05535f
C40906 net15 rx_data[4] 0
C40907 clknet_4_5_0_clk _706_/a_1489_191# 0.00351f
C40908 net173 _143_ 0.00654f
C40909 hold172/a_326_118# _200_ 0
C40910 _159_ _236_ 0.00114f
C40911 FILLER_4_183/a_40_246# FILLER_2_183/a_32_246# 0
C40912 _286_ _683_/a_843_236# 0
C40913 net48 FILLER_29_145/a_40_246# 0.02457f
C40914 _635_/a_612_127# _266_ 0
C40915 _635_/a_550_127# net30 0
C40916 _068_ _339_/a_308_118# 0
C40917 tx_inst.data_reg\[3\] _339_/a_886_118# 0.0047f
C40918 hold130/a_56_118# _292_ 0.02336f
C40919 _404_/a_46_156# clknet_0_clk 0.00252f
C40920 FILLER_1_173/a_32_246# net55 0
C40921 _697_/a_741_93# net46 0.00211f
C40922 _029_ VPWR 0.19697f
C40923 _216_ _666_/a_1785_429# 0
C40924 _663_/a_612_127# clknet_4_6_0_clk 0.01769f
C40925 net183 _667_/a_1583_191# 0
C40926 net122 _652_/a_324_432# 0
C40927 net31 FILLER_16_154/a_32_246# 0
C40928 _541_/a_209_168# _296_ 0
C40929 net58 _702_/a_741_93# 0
C40930 _032_ _702_/a_38_114# 0
C40931 _316_ _702_/a_324_432# 0
C40932 _216_ clkbuf_4_5_0_clk/a_27_118# 0
C40933 _677_/a_1489_191# net152 0.00758f
C40934 rx_data[7] _047_ 0.00177f
C40935 FILLER_7_121/a_40_246# baud_inst.counter\[6\] 0
C40936 VPWR _682_/a_612_127# 0.01086f
C40937 clkbuf_4_8_0_clk/a_27_118# net90 0
C40938 FILLER_7_176/a_32_246# VPWR 0.08257f
C40939 _646_/a_1583_191# _264_ 0
C40940 _555_/a_209_168# net45 0
C40941 _676_/a_298_337# clkbuf_4_3_0_clk/a_27_118# 0.00222f
C40942 _102_ _688_/a_741_93# 0
C40943 _017_ _164_ 0.00166f
C40944 net102 _302_ 0
C40945 _022_ _692_/a_741_93# 0
C40946 tx_inst.bit_index\[1\] net145 0.00464f
C40947 baud_inst.counter\[28\] _701_/a_132_114# 0
C40948 _277_ net43 0.01088f
C40949 net2 _668_/a_843_236# 0
C40950 _697_/a_550_127# _309_ 0
C40951 clk net3 0.00246f
C40952 _705_/a_1583_191# _478_/a_27_156# 0
C40953 _645_/a_1583_191# _055_ 0.00206f
C40954 _661_/a_550_127# VPWR 0
C40955 _379_/a_268_412# VPWR 0
C40956 _422_/a_248_122# clknet_0_clk 0
C40957 rx_inst.bit_index\[1\] FILLER_19_139/a_40_246# 0
C40958 VPWR _702_/a_1583_191# 0.00731f
C40959 _677_/a_132_114# _035_ 0
C40960 hold56/a_326_118# _141_ 0
C40961 _372_/a_22_110# _667_/a_1583_191# 0
C40962 hold118/a_56_118# _264_ 0
C40963 _488_/a_209_168# _086_ 0.03482f
C40964 net123 _676_/a_843_236# 0
C40965 net80 net19 0
C40966 _640_/a_1489_191# VPWR 0.00304f
C40967 clk FILLER_11_144/a_32_246# 0.00286f
C40968 VPWR net63 0.1813f
C40969 hold127/a_56_118# _424_/a_142_412# 0
C40970 hold71/a_326_118# hold71/a_438_182# 0
C40971 hold67/a_326_118# clknet_4_11_0_clk 0.0215f
C40972 FILLER_5_207/a_32_246# _200_ 0
C40973 _650_/a_132_114# net30 0
C40974 net120 hold148/a_56_118# 0.00627f
C40975 baud_inst.counter\[2\] _181_ 0.15111f
C40976 hold68/a_326_118# net105 0.00624f
C40977 net148 _303_ 0.00562f
C40978 net66 _638_/a_612_127# 0
C40979 clk _142_ 0.03674f
C40980 baud_inst.counter\[25\] clknet_4_9_0_clk 0.00181f
C40981 _216_ _395_/a_146_122# 0
C40982 FILLER_17_94/a_40_246# _099_ 0
C40983 _143_ FILLER_7_146/a_32_246# 0.01835f
C40984 net42 clk 0.13991f
C40985 _669_/a_324_432# clknet_4_9_0_clk 0.03921f
C40986 _645_/a_741_93# rx_inst.data_reg\[2\] 0
C40987 FILLER_26_88/a_40_246# _032_ 0.03231f
C40988 _060_ rx_inst.data_reg\[6\] 0
C40989 _098_ _162_ 0.01258f
C40990 _053_ hold176/a_326_118# 0
C40991 _132_ hold176/a_56_118# 0.00182f
C40992 net44 _304_ 0.01228f
C40993 baud_inst.counter\[31\] FILLER_22_86/a_32_246# 0
C40994 hold57/a_326_118# net27 0
C40995 net44 _099_ 0.01304f
C40996 _240_ _223_ 0.04337f
C40997 _673_/a_2002_114# net60 0
C40998 _147_ tx_inst.data_reg\[1\] 0.00615f
C40999 hold177/a_438_182# VPWR 0.00473f
C41000 _227_ _161_ 0.00606f
C41001 hold133/a_438_182# _702_/a_324_432# 0
C41002 hold133/a_326_118# _702_/a_741_93# 0
C41003 hold165/a_438_182# net165 0.00124f
C41004 _651_/a_2002_114# _166_ 0
C41005 baud_inst.counter\[28\] _346_/a_150_412# 0.00796f
C41006 net64 _264_ 0.18332f
C41007 rx_data[6] net30 0
C41008 _665_/a_324_432# tx_inst.state\[3\] 0.00728f
C41009 _514_/a_155_412# _189_ 0
C41010 net82 _634_/a_324_432# 0
C41011 _217_ _653_/a_1489_191# 0
C41012 hold122/a_56_118# _220_ 0
C41013 net30 hold84/a_56_118# 0
C41014 _200_ _664_/a_2002_114# 0
C41015 fanout43/a_40_152# _667_/a_741_93# 0
C41016 net156 baud_inst.counter\[17\] 0.05943f
C41017 baud_inst.counter\[19\] net88 0
C41018 _421_/a_252_412# _237_ 0.00311f
C41019 tx_inst.data_reg\[6\] _392_/a_59_156# 0.0013f
C41020 _226_ _249_ 0.00157f
C41021 _680_/a_324_432# net136 0.04715f
C41022 output23/a_40_152# _704_/a_1583_191# 0
C41023 net23 _704_/a_843_236# 0.00161f
C41024 _636_/a_1840_334# _047_ -0
C41025 _195_ _477_/a_22_110# 0
C41026 _082_ net62 0
C41027 FILLER_2_81/a_32_246# VPWR 0.07117f
C41028 clknet_0_clk net46 0.22116f
C41029 FILLER_8_70/a_32_246# _282_ 0.00307f
C41030 _277_ _671_/a_681_505# 0
C41031 net30 rx_inst.data_reg\[5\] 0.01514f
C41032 clknet_4_8_0_clk _311_ 0.19925f
C41033 _069_ FILLER_3_141/a_40_246# 0
C41034 _116_ _703_/a_1583_191# 0
C41035 tx_inst.data_reg\[7\] _339_/a_382_118# 0.00863f
C41036 _644_/a_2250_412# _044_ -0
C41037 _693_/a_38_114# VPWR 0.01176f
C41038 baud_inst.counter\[4\] _096_ 0
C41039 _510_/a_146_122# net135 0.00465f
C41040 _457_/a_22_110# net80 0.00398f
C41041 rx_inst.data_reg\[4\] _157_ 0.01103f
C41042 _637_/a_1489_191# clknet_4_15_0_clk 0.0052f
C41043 _026_ baud_inst.counter\[25\] 0
C41044 net54 _200_ 0.02623f
C41045 _263_ net24 0.2486f
C41046 _677_/a_1583_191# _280_ 0.00121f
C41047 fanout40/a_40_152# net88 0
C41048 hold107/a_56_118# FILLER_27_46/a_32_246# 0.00123f
C41049 hold115/a_56_118# _010_ 0
C41050 output22/a_40_152# tx_busy 0
C41051 net62 clknet_0_clk 0.08227f
C41052 FILLER_16_166/a_32_246# net51 0
C41053 hold162/a_438_182# _310_ 0.03978f
C41054 output23/a_40_152# _707_/a_843_236# 0
C41055 FILLER_25_9/a_32_246# VPWR 0.065f
C41056 fanout28/a_40_152# _224_ 0
C41057 hold118/a_438_182# _639_/a_1583_191# 0.00282f
C41058 hold118/a_326_118# _639_/a_1840_334# 0
C41059 _674_/a_38_114# net61 0
C41060 hold60/a_56_118# net86 0
C41061 _283_ _677_/a_2250_412# 0
C41062 _392_/a_285_118# VPWR 0.00237f
C41063 _234_ _671_/a_324_432# 0
C41064 hold111/a_326_118# rx_inst.data_reg\[0\] 0.02466f
C41065 hold175/a_326_118# net24 0
C41066 _031_ _700_/a_843_236# 0
C41067 FILLER_20_177/a_32_246# _136_ 0.02751f
C41068 FILLER_13_100/a_40_246# net123 0
C41069 net37 _417_/a_22_110# 0
C41070 _237_ net24 0.00464f
C41071 _536_/a_341_118# net148 0
C41072 _536_/a_435_412# _021_ 0.00182f
C41073 _672_/a_1840_334# VPWR 0.00271f
C41074 VPWR FILLER_8_191/a_32_246# 0.06675f
C41075 net45 _107_ 0.11606f
C41076 net6 net86 0
C41077 _233_ net166 0
C41078 baud_inst.counter\[19\] _529_/a_45_160# 0.00796f
C41079 output12/a_40_152# rx_data[0] 0
C41080 hold98/a_326_118# _094_ 0
C41081 net147 _692_/a_298_337# 0
C41082 baud_inst.counter\[8\] _510_/a_248_122# 0
C41083 _242_ net175 0
C41084 _658_/a_1583_191# _212_ 0
C41085 _139_ _649_/a_38_114# 0
C41086 _653_/a_2250_412# _220_ 0
C41087 _653_/a_1840_334# _142_ 0
C41088 baud_inst.counter\[12\] _297_ 0.01541f
C41089 _535_/a_146_122# VPWR 0
C41090 hold135/a_56_118# net86 0.02815f
C41091 hold135/a_326_118# net181 0.00956f
C41092 _064_ _653_/a_1583_191# 0
C41093 _080_ _667_/a_741_93# 0
C41094 hold109/a_56_118# baud_inst.counter\[13\] 0
C41095 net8 _213_ 0.0121f
C41096 clk _150_ 0.02733f
C41097 FILLER_28_176/a_32_246# _159_ 0.00275f
C41098 _649_/a_741_93# rx_inst.data_reg\[6\] 0
C41099 _316_ _112_ 0
C41100 FILLER_0_117/a_32_246# _210_ 0.00515f
C41101 _093_ hold117/a_438_182# 0
C41102 hold166/a_438_182# net62 0
C41103 _099_ _685_/a_1583_191# 0
C41104 _672_/a_298_337# net60 0.0099f
C41105 _677_/a_324_432# clkbuf_4_3_0_clk/a_27_118# 0.00168f
C41106 baud_inst.counter\[8\] _182_ 0
C41107 hold97/a_56_118# _682_/a_2250_412# 0.00161f
C41108 hold161/a_56_118# hold158/a_326_118# 0.00494f
C41109 hold119/a_438_182# _140_ 0.00207f
C41110 _249_ _434_/a_252_412# 0
C41111 _031_ hold106/a_326_118# 0
C41112 net42 net2 0
C41113 _109_ _696_/a_843_236# 0
C41114 _695_/a_741_93# clknet_4_10_0_clk 0.02563f
C41115 _368_/a_155_412# _200_ 0.02529f
C41116 _518_/a_45_160# baud_inst.counter\[14\] 0.06483f
C41117 _640_/a_681_505# net45 0
C41118 _175_ _196_ 0.47045f
C41119 FILLER_12_82/a_32_246# net29 0.00303f
C41120 net88 _297_ 0.07507f
C41121 clknet_4_4_0_clk FILLER_3_141/a_40_246# 0.00148f
C41122 _691_/a_38_114# _531_/a_209_168# 0
C41123 _138_ _648_/a_550_127# 0
C41124 _659_/a_38_114# net137 0
C41125 _030_ _087_ 0.08978f
C41126 VPWR _494_/a_165_412# 0
C41127 rx_inst.state\[2\] net51 0.01553f
C41128 rx_inst.bit_index\[1\] _230_ 0.12339f
C41129 baud_inst.counter\[24\] clknet_4_9_0_clk 0.00187f
C41130 _002_ _191_ 0.02372f
C41131 rx_inst.bit_index\[1\] hold52/a_438_182# 0.00319f
C41132 _707_/a_324_432# net22 0
C41133 hold130/a_438_182# _190_ 0.01865f
C41134 _649_/a_298_337# _648_/a_324_432# 0
C41135 _640_/a_741_93# _224_ 0
C41136 _360_/a_1377_160# _208_ 0
C41137 _097_ _684_/a_741_93# -0
C41138 hold88/a_438_182# clkbuf_4_8_0_clk/a_27_118# 0
C41139 _048_ _633_/a_2250_412# 0
C41140 clknet_4_12_0_clk _156_ 0
C41141 net66 net47 0
C41142 _183_ _282_ 0.3191f
C41143 net45 _165_ 0.00408f
C41144 _304_ _302_ 0.03075f
C41145 _180_ _686_/a_1785_429# 0
C41146 net94 FILLER_8_70/a_32_246# 0
C41147 _310_ _543_/a_248_122# 0.00189f
C41148 _696_/a_741_93# VPWR 0.01492f
C41149 net47 _648_/a_1583_191# 0
C41150 _242_ _161_ 0.1572f
C41151 net182 FILLER_12_82/a_32_246# 0.01198f
C41152 hold102/a_438_182# net158 0
C41153 hold102/a_56_118# baud_inst.counter\[17\] 0.0183f
C41154 FILLER_28_176/a_32_246# _155_ 0
C41155 net35 net180 0
C41156 _310_ _025_ 0.01834f
C41157 rx_inst.bit_index\[2\] _228_ 0
C41158 _506_/a_257_140# net38 0
C41159 net94 _679_/a_550_127# 0
C41160 clknet_4_12_0_clk rx_inst.state\[2\] 0.02409f
C41161 net42 _652_/a_550_127# 0
C41162 hold69/a_326_118# _273_ 0.00191f
C41163 fanout48/a_40_152# _056_ 0.00446f
C41164 _313_ clknet_0_clk 0.15641f
C41165 clknet_4_5_0_clk _042_ 0.0992f
C41166 hold63/a_56_118# rx_inst.state\[3\] 0
C41167 _706_/a_741_93# VPWR 0.03811f
C41168 _680_/a_38_114# clknet_4_0_0_clk 0.00877f
C41169 hold169/a_326_118# _220_ 0
C41170 hold87/a_438_182# _013_ 0
C41171 net26 _000_ 0.12789f
C41172 hold139/a_326_118# VPWR 0.01021f
C41173 hold100/a_326_118# net45 0
C41174 FILLER_8_171/a_32_246# net184 0
C41175 net42 hold169/a_56_118# 0
C41176 hold122/a_326_118# _667_/a_1583_191# 0
C41177 hold122/a_56_118# _667_/a_1840_334# 0.00193f
C41178 _041_ _667_/a_741_93# 0
C41179 _050_ net51 0
C41180 hold128/a_438_182# net29 0.00408f
C41181 _646_/a_1583_191# _269_ 0
C41182 FILLER_20_57/a_32_246# _307_ 0.00168f
C41183 _444_/a_244_412# _255_ 0.01942f
C41184 _118_ net50 0.00542f
C41185 _045_ _633_/a_38_114# 0
C41186 _660_/a_741_93# tx_inst.data_reg\[2\] 0
C41187 net154 _282_ 0
C41188 hold129/a_326_118# _358_/a_72_436# 0.00132f
C41189 hold87/a_438_182# baud_inst.counter\[14\] 0
C41190 net58 _702_/a_1785_429# 0
C41191 _113_ _700_/a_38_114# 0.04181f
C41192 _370_/a_154_118# _201_ 0
C41193 _233_ _671_/a_324_432# 0
C41194 FILLER_19_149/a_40_246# _249_ 0
C41195 net121 _694_/a_38_114# 0.01618f
C41196 net55 _385_/a_46_156# 0.01282f
C41197 net92 hold96/a_438_182# 0.01447f
C41198 net33 _478_/a_27_156# 0.01488f
C41199 _091_ clkbuf_4_1_0_clk/a_27_118# 0
C41200 _169_ _667_/a_324_432# 0.0209f
C41201 _269_ hold118/a_56_118# 0
C41202 _026_ baud_inst.counter\[24\] 0.00133f
C41203 baud_inst.counter\[28\] _701_/a_1489_191# 0.00146f
C41204 net48 _633_/a_843_236# 0.00337f
C41205 _230_ FILLER_22_152/a_32_246# 0
C41206 _432_/a_146_122# _224_ 0
C41207 _256_ _439_/a_354_412# 0
C41208 _537_/a_155_160# VPWR 0
C41209 fanout41/a_40_152# _659_/a_324_432# 0
C41210 rx_data[1] _264_ 0
C41211 _019_ net40 0.02845f
C41212 FILLER_16_154/a_32_246# net62 0
C41213 rx_inst.bit_index\[0\] VPWR 0.05965f
C41214 _282_ net115 0
C41215 _117_ _663_/a_2250_412# 0.02611f
C41216 net182 hold128/a_438_182# 0
C41217 clknet_0_clk _685_/a_741_93# 0.00913f
C41218 net119 _459_/a_27_156# 0
C41219 _650_/a_1489_191# net30 0.00977f
C41220 _691_/a_1840_334# hold163/a_56_118# 0
C41221 _691_/a_1583_191# hold163/a_326_118# 0
C41222 hold175/a_56_118# VPWR 0.00808f
C41223 clknet_0_clk _666_/a_1840_334# 0.02845f
C41224 hold63/a_438_182# clknet_0_clk 0
C41225 _031_ _314_ 0.43635f
C41226 net66 net70 0.00385f
C41227 _651_/a_324_432# clknet_4_6_0_clk 0.01622f
C41228 net44 _530_/a_257_140# 0.00258f
C41229 _669_/a_2250_412# clknet_4_9_0_clk 0
C41230 _523_/a_257_140# net40 0.00242f
C41231 _696_/a_38_114# net162 0
C41232 FILLER_8_171/a_32_246# _651_/a_324_432# 0
C41233 _705_/a_324_432# _199_ 0
C41234 net15 _635_/a_324_432# 0
C41235 tx_data[7] _066_ 0
C41236 _195_ _651_/a_843_236# 0
C41237 _217_ _651_/a_741_93# 0
C41238 _284_ net39 0.15361f
C41239 baud_inst.counter\[26\] hold140/a_56_118# 0.00491f
C41240 _144_ net168 0
C41241 tx_data[1] input7/a_40_152# 0
C41242 FILLER_16_176/a_40_246# hold139/a_56_118# 0.00101f
C41243 _665_/a_2250_412# tx_inst.state\[3\] 0.0167f
C41244 _293_ _189_ 0
C41245 _310_ FILLER_17_79/a_40_246# 0.00338f
C41246 _640_/a_324_432# net49 0.00213f
C41247 net49 _667_/a_1583_191# 0
C41248 _169_ FILLER_11_144/a_32_246# 0.00135f
C41249 _693_/a_741_93# _106_ 0
C41250 _652_/a_324_432# FILLER_11_123/a_40_246# 0
C41251 _527_/a_341_118# _299_ 0.00171f
C41252 _680_/a_2250_412# net136 0
C41253 tx_done _704_/a_1785_429# 0
C41254 _551_/a_170_160# _313_ 0.00159f
C41255 _552_/a_155_412# _315_ 0
C41256 _447_/a_81_118# _223_ 0.01276f
C41257 _349_/a_146_122# net181 0.00125f
C41258 _217_ _007_ 0.02566f
C41259 tx_inst.bit_index\[1\] _220_ 0
C41260 net156 _688_/a_132_114# 0
C41261 net179 _706_/a_324_432# 0.00648f
C41262 net94 _183_ 0
C41263 _169_ _142_ 0
C41264 baud_inst.counter\[12\] _513_/a_435_412# 0
C41265 net128 _513_/a_192_429# 0
C41266 _519_/a_175_118# _163_ 0.00125f
C41267 hold104/a_438_182# VPWR 0.00377f
C41268 _234_ _157_ 0
C41269 clknet_4_15_0_clk hold72/a_56_118# 0.06034f
C41270 net42 _169_ 0.02266f
C41271 net37 hold122/a_438_182# 0
C41272 net2 _667_/a_2250_412# 0
C41273 _277_ _671_/a_550_127# 0
C41274 _244_ _252_ 0
C41275 _008_ _087_ 0
C41276 hold104/a_56_118# FILLER_17_24/a_32_246# 0
C41277 _549_/a_155_412# _547_/a_81_118# 0
C41278 hold184/a_326_118# VPWR 0.00937f
C41279 tx_inst.data_reg\[7\] _339_/a_810_118# 0
C41280 _678_/a_324_432# hold92/a_56_118# 0
C41281 hold172/a_56_118# net33 0
C41282 clknet_4_3_0_clk _282_ 0.14711f
C41283 FILLER_9_79/a_32_246# net39 0
C41284 _550_/a_209_168# _701_/a_324_432# 0
C41285 _178_ _305_ 0
C41286 _693_/a_1840_334# VPWR 0.02673f
C41287 hold165/a_56_118# _656_/a_1583_191# 0
C41288 _175_ tx_inst.data_reg\[0\] 0
C41289 _073_ hold168/a_326_118# 0.00277f
C41290 output21/a_40_152# _275_ 0
C41291 _644_/a_298_337# _159_ 0.0327f
C41292 _262_ _452_/a_155_412# 0.00154f
C41293 net37 _241_ 0.01582f
C41294 _545_/a_146_122# _308_ 0
C41295 net97 _287_ 0.00131f
C41296 _226_ clknet_4_12_0_clk 0.01328f
C41297 _697_/a_681_505# clknet_0_clk 0
C41298 net17 clknet_4_15_0_clk 0
C41299 hold132/a_326_118# VPWR 0
C41300 _360_/a_382_118# net41 0.00595f
C41301 net108 _509_/a_257_140# 0
C41302 net97 _509_/a_155_412# 0.0315f
C41303 hold139/a_326_118# _167_ 0.00525f
C41304 _178_ _116_ 0.00845f
C41305 output22/a_40_152# _704_/a_741_93# 0
C41306 hold89/a_438_182# _100_ 0.00452f
C41307 _227_ FILLER_18_148/a_40_246# 0
C41308 hold120/a_56_118# net46 0.00859f
C41309 hold113/a_326_118# net113 0
C41310 _038_ net181 0.01513f
C41311 _173_ FILLER_4_172/a_32_246# 0
C41312 _287_ net86 0.05306f
C41313 clknet_0_clk _262_ 0.01612f
C41314 _082_ rx_inst.state\[3\] 0
C41315 tx_done _707_/a_1583_191# 0
C41316 _053_ _669_/a_38_114# 0
C41317 _132_ _669_/a_298_337# 0.00158f
C41318 _641_/a_2250_412# _454_/a_155_412# 0
C41319 FILLER_4_183/a_40_246# net26 0.00253f
C41320 _351_/a_46_156# net152 0
C41321 _505_/a_76_160# net29 0
C41322 _704_/a_324_432# _121_ 0.00191f
C41323 _022_ _021_ 0.17289f
C41324 net20 _704_/a_1840_334# 0.00446f
C41325 rx_done _704_/a_1583_191# 0.00205f
C41326 FILLER_15_173/a_40_246# net51 0
C41327 net106 net45 0.00281f
C41328 net55 _654_/a_38_114# 0.02432f
C41329 tx_inst.data_reg\[0\] net165 0.00213f
C41330 _646_/a_2250_412# _474_/a_22_110# 0
C41331 net147 _692_/a_1583_191# 0
C41332 _663_/a_38_114# net27 0
C41333 _224_ FILLER_14_164/a_32_246# 0
C41334 hold118/a_326_118# net118 0.00391f
C41335 _003_ FILLER_12_128/a_40_246# 0.06181f
C41336 _637_/a_324_432# hold72/a_56_118# 0
C41337 _178_ _701_/a_741_93# 0
C41338 _056_ net47 0.36659f
C41339 net94 net115 0.00378f
C41340 net39 _513_/a_435_412# 0
C41341 rx_inst.state\[3\] clknet_0_clk 0.09375f
C41342 clknet_4_1_0_clk _066_ 0.02638f
C41343 _501_/a_154_118# net115 0
C41344 _036_ hold94/a_56_118# 0
C41345 _113_ net105 0
C41346 VPWR FILLER_24_19/a_40_246# 0.14608f
C41347 baud_inst.counter\[31\] _180_ 0.02199f
C41348 _424_/a_244_140# _238_ 0
C41349 hold128/a_56_118# hold90/a_56_118# 0
C41350 _691_/a_38_114# net104 0.02188f
C41351 _649_/a_1785_429# rx_inst.data_reg\[6\] 0
C41352 hold173/a_438_182# clknet_4_4_0_clk 0
C41353 _215_ _666_/a_1583_191# 0.00211f
C41354 _188_ net103 0
C41355 hold148/a_438_182# net147 0.00465f
C41356 _672_/a_1583_191# net60 0
C41357 hold148/a_438_182# net46 0
C41358 hold129/a_56_118# _162_ 0
C41359 _650_/a_38_114# _140_ 0.00122f
C41360 _637_/a_843_236# net72 0.00126f
C41361 net41 net9 0.02172f
C41362 tx_inst.bit_index\[1\] FILLER_6_151/a_40_246# 0.01489f
C41363 _109_ _696_/a_612_127# 0.00416f
C41364 net121 baud_inst.counter\[23\] 0
C41365 _313_ _700_/a_843_236# 0
C41366 _695_/a_1785_429# clknet_4_10_0_clk 0
C41367 tx_inst.bit_index\[0\] _274_ 0.00344f
C41368 hold177/a_438_182# _163_ 0
C41369 baud_inst.counter\[16\] _522_/a_177_436# 0.00526f
C41370 _119_ tx_inst.state\[2\] 0.06966f
C41371 tx_inst.state\[4\] _666_/a_741_93# 0
C41372 net42 _084_ 0.01742f
C41373 _121_ net19 0.00179f
C41374 VPWR FILLER_6_21/a_40_246# 0.1387f
C41375 _118_ _705_/a_38_114# 0.04359f
C41376 baud_inst.counter\[20\] _106_ 0.00454f
C41377 _691_/a_298_337# _020_ 0.00306f
C41378 _691_/a_324_432# net163 0.04906f
C41379 baud_inst.counter\[23\] _699_/a_324_432# 0
C41380 baud_inst.counter\[22\] _699_/a_38_114# 0
C41381 _659_/a_132_114# _149_ 0
C41382 _248_ FILLER_17_160/a_40_246# 0
C41383 net55 net5 0.01281f
C41384 _646_/a_324_432# net111 0
C41385 _092_ net29 0.01162f
C41386 tx_data[6] FILLER_0_154/a_40_246# 0.00575f
C41387 clknet_4_4_0_clk _664_/a_741_93# 0.02759f
C41388 _126_ _650_/a_2250_412# 0
C41389 FILLER_0_115/a_40_246# net171 0
C41390 _677_/a_38_114# VPWR 0
C41391 _649_/a_324_432# _648_/a_1583_191# 0
C41392 _640_/a_1785_429# _224_ 0
C41393 _530_/a_257_140# _302_ 0.00296f
C41394 _530_/a_155_412# _164_ 0.00585f
C41395 hold166/a_438_182# rx_inst.state\[3\] 0.02891f
C41396 clknet_4_12_0_clk _434_/a_252_412# 0
C41397 rx_inst.bit_index\[2\] _434_/a_150_412# 0
C41398 _164_ _690_/a_843_236# 0.00281f
C41399 _018_ _690_/a_324_432# 0.00188f
C41400 net62 net43 0.52904f
C41401 _344_/a_252_412# baud_inst.counter\[25\] 0
C41402 baud_inst.counter\[7\] _492_/a_170_412# 0
C41403 _121_ hold51/a_326_118# 0.00666f
C41404 _233_ _157_ 0
C41405 net31 _249_ 0.16665f
C41406 hold106/a_326_118# _313_ 0.00156f
C41407 FILLER_17_0/a_40_246# FILLER_15_0/a_40_246# 0
C41408 net92 net96 0.0297f
C41409 net94 clknet_4_3_0_clk 0.18438f
C41410 hold127/a_56_118# _258_ 0
C41411 VPWR _433_/a_244_140# 0
C41412 _302_ FILLER_22_22/a_32_246# 0.00183f
C41413 net74 hold84/a_438_182# 0
C41414 _691_/a_843_236# _104_ 0
C41415 _646_/a_38_114# _057_ 0.04054f
C41416 _678_/a_741_93# FILLER_8_92/a_32_246# 0.00112f
C41417 _017_ _688_/a_38_114# 0
C41418 net2 _650_/a_741_93# 0
C41419 _128_ clknet_4_15_0_clk 0.05407f
C41420 _206_ _380_/a_382_118# 0.05152f
C41421 _198_ _664_/a_38_114# 0.00126f
C41422 _170_ _428_/a_150_412# 0
C41423 _706_/a_1785_429# VPWR 0
C41424 _504_/a_209_168# net38 0.00111f
C41425 _680_/a_1840_334# clknet_4_0_0_clk 0.0318f
C41426 _517_/a_209_168# _013_ 0
C41427 _191_ _292_ 0
C41428 _110_ net46 0.04702f
C41429 net111 _473_/a_22_110# 0.00122f
C41430 hold60/a_56_118# net38 0
C41431 _410_/a_155_412# VPWR 0.00122f
C41432 _045_ _633_/a_1840_334# 0.00489f
C41433 _517_/a_177_436# baud_inst.counter\[15\] 0.00346f
C41434 _517_/a_209_168# baud_inst.counter\[14\] 0.03133f
C41435 net58 _115_ 0.00582f
C41436 net45 _693_/a_298_337# 0
C41437 hold178/a_56_118# _096_ 0
C41438 hold56/a_56_118# VPWR 0.04951f
C41439 net6 net38 0.24183f
C41440 hold136/a_326_118# _181_ 0
C41441 clkbuf_4_0_0_clk/a_27_118# net86 0.03078f
C41442 _169_ _667_/a_2250_412# 0.00631f
C41443 net120 clknet_4_10_0_clk 0.21984f
C41444 _662_/a_681_505# _206_ 0
C41445 clknet_0_clk _386_/a_285_412# 0.00215f
C41446 _480_/a_120_432# net27 0.00217f
C41447 _090_ _184_ 0
C41448 _661_/a_38_114# hold159/a_326_118# 0
C41449 net46 _686_/a_681_505# 0
C41450 _099_ _686_/a_843_236# 0.00271f
C41451 net48 _633_/a_612_127# 0.00657f
C41452 _256_ _253_ 0.01396f
C41453 _699_/a_324_432# net114 0.072f
C41454 hold67/a_56_118# net58 0
C41455 _638_/a_324_432# _264_ 0.00396f
C41456 hold160/a_56_118# _688_/a_2250_412# 0
C41457 hold160/a_326_118# _688_/a_1840_334# 0
C41458 hold160/a_438_182# _688_/a_1583_191# 0
C41459 hold135/a_56_118# net38 0.01551f
C41460 net51 hold80/a_326_118# 0
C41461 _428_/a_354_412# _244_ 0
C41462 rx_data[0] _632_/a_324_432# 0
C41463 hold65/a_438_182# clknet_4_15_0_clk 0.03139f
C41464 baud_inst.counter\[26\] _024_ 0.00158f
C41465 _660_/a_1489_191# _076_ 0
C41466 hold161/a_438_182# net158 0
C41467 hold161/a_56_118# baud_inst.counter\[17\] 0.0014f
C41468 clknet_0_clk _685_/a_1785_429# 0.00165f
C41469 _671_/a_843_236# _168_ 0.02366f
C41470 rx_inst.data_reg\[7\] net30 0.0269f
C41471 FILLER_17_199/a_40_246# _157_ 0.0121f
C41472 _691_/a_1489_191# hold163/a_438_182# 0
C41473 net55 tx_data[2] 0.00939f
C41474 clknet_4_12_0_clk FILLER_19_149/a_40_246# 0.0031f
C41475 _651_/a_2250_412# clknet_4_6_0_clk 0.0057f
C41476 _296_ _684_/a_38_114# 0
C41477 _277_ net51 0.00449f
C41478 _030_ _490_/a_45_160# 0.00102f
C41479 _674_/a_1489_191# _279_ 0
C41480 baud_inst.counter\[8\] hold117/a_326_118# 0
C41481 _270_ _635_/a_298_337# 0.00176f
C41482 hold101/a_438_182# hold157/a_438_182# 0
C41483 net26 _405_/a_229_118# 0.00381f
C41484 _679_/a_324_432# VPWR 0
C41485 _028_ _115_ 0.00961f
C41486 hold166/a_56_118# net166 0
C41487 _644_/a_741_93# _056_ 0.0012f
C41488 net15 _635_/a_2250_412# 0.00621f
C41489 hold133/a_326_118# _115_ 0
C41490 baud_inst.counter\[28\] hold68/a_326_118# 0
C41491 net49 _702_/a_741_93# 0
C41492 net105 hold114/a_326_118# 0.00306f
C41493 _265_ _668_/a_324_432# 0.00103f
C41494 _132_ FILLER_17_131/a_32_246# 0
C41495 _284_ _676_/a_843_236# 0
C41496 _640_/a_2250_412# net49 0
C41497 _242_ _418_/a_268_412# 0.00101f
C41498 net40 _681_/a_132_114# 0
C41499 hold176/a_326_118# VPWR 0.00541f
C41500 _211_ _149_ 0.02658f
C41501 hold154/a_438_182# net29 0.00166f
C41502 net44 _697_/a_1489_191# 0.00957f
C41503 _082_ _642_/a_298_337# 0
C41504 net44 _642_/a_38_114# 0.0085f
C41505 _314_ _313_ 0.18003f
C41506 _645_/a_324_432# _056_ 0.02968f
C41507 net156 _688_/a_1489_191# 0.00431f
C41508 _187_ net40 0
C41509 hold74/a_56_118# _639_/a_1583_191# 0
C41510 _497_/a_170_412# VPWR 0
C41511 _079_ net166 0.00144f
C41512 _479_/a_120_432# _166_ 0
C41513 hold103/a_326_118# _296_ 0.00365f
C41514 net126 _264_ 0.01088f
C41515 _661_/a_843_236# _148_ 0.02919f
C41516 _117_ _166_ 0.01379f
C41517 net79 _489_/a_358_436# 0.03288f
C41518 _667_/a_2250_412# _084_ 0
C41519 _109_ _545_/a_248_122# 0
C41520 net44 _686_/a_38_114# 0.00563f
C41521 _538_/a_175_118# baud_inst.counter\[21\] 0.00132f
C41522 hold146/a_438_182# clknet_0_clk 0.0014f
C41523 net55 _655_/a_38_114# 0
C41524 hold165/a_326_118# _656_/a_1489_191# 0
C41525 _644_/a_741_93# _134_ 0
C41526 _644_/a_1583_191# _159_ 0.00652f
C41527 baud_inst.counter\[26\] _695_/a_843_236# 0
C41528 VPWR FILLER_22_86/a_32_246# 0.07846f
C41529 hold115/a_56_118# _287_ 0
C41530 _344_/a_252_412# baud_inst.counter\[24\] 0.00344f
C41531 hold172/a_326_118# net22 0
C41532 _685_/a_298_337# net130 0
C41533 _690_/a_1583_191# baud_inst.counter\[15\] 0
C41534 _170_ _423_/a_279_412# 0
C41535 _697_/a_550_127# clknet_0_clk 0
C41536 tx_inst.data_reg\[1\] FILLER_3_123/a_32_246# 0.00232f
C41537 net97 _290_ 0.18874f
C41538 _180_ hold91/a_326_118# 0.00735f
C41539 _642_/a_298_337# clknet_0_clk 0.00394f
C41540 net173 hold173/a_56_118# 0.01082f
C41541 hold63/a_56_118# _205_ 0.0262f
C41542 FILLER_2_110/a_32_246# net6 0
C41543 tx_inst.data_reg\[6\] _174_ 0
C41544 net182 hold154/a_438_182# 0
C41545 hold107/a_326_118# hold107/a_438_182# 0
C41546 _255_ _441_/a_154_118# 0
C41547 _080_ FILLER_13_137/a_32_246# 0
C41548 FILLER_19_55/a_40_246# _308_ 0
C41549 _689_/a_298_337# net158 0.00459f
C41550 net166 fanout26/a_40_152# 0
C41551 _671_/a_298_337# clknet_0_clk 0.00675f
C41552 _132_ _669_/a_1583_191# 0.0016f
C41553 net43 _666_/a_1840_334# 0
C41554 net26 _417_/a_22_110# 0.00165f
C41555 clknet_4_14_0_clk _428_/a_354_412# 0
C41556 _641_/a_2250_412# _263_ 0.00241f
C41557 _092_ hold95/a_438_182# 0
C41558 output16/a_40_152# rx_data[4] 0.00454f
C41559 _645_/a_132_114# _159_ 0
C41560 _645_/a_324_432# _134_ 0
C41561 _640_/a_298_337# _698_/a_298_337# 0.00193f
C41562 VPWR _200_ 0.43823f
C41563 baud_inst.counter\[5\] _282_ 0
C41564 net125 _244_ 0
C41565 clknet_0_clk _686_/a_298_337# 0.00899f
C41566 VPWR hold180/a_56_118# 0.0363f
C41567 output15/a_40_152# hold84/a_56_118# 0
C41568 net34 _400_/a_192_429# 0.02485f
C41569 _191_ _669_/a_1583_191# 0.00164f
C41570 _410_/a_155_412# _225_ 0
C41571 _302_ _692_/a_741_93# 0
C41572 rx_inst.state\[2\] _449_/a_27_156# 0.0037f
C41573 net55 _654_/a_1840_334# 0.01751f
C41574 _651_/a_132_114# _220_ 0
C41575 _191_ FILLER_12_106/a_40_246# 0.00134f
C41576 _230_ _640_/a_741_93# 0
C41577 FILLER_0_54/a_40_246# _085_ 0
C41578 baud_inst.counter\[8\] hold115/a_438_182# 0.0073f
C41579 _036_ baud_inst.counter\[6\] 0.08516f
C41580 net42 _651_/a_681_505# 0
C41581 baud_inst.counter\[13\] _670_/a_298_337# 0.00111f
C41582 _292_ hold91/a_438_182# 0.00106f
C41583 net39 _011_ 0.01548f
C41584 net39 _684_/a_298_337# 0.00149f
C41585 _671_/a_132_114# _223_ 0
C41586 _463_/a_120_432# clknet_4_15_0_clk 0
C41587 net6 _655_/a_741_93# 0
C41588 tx_busy _707_/a_741_93# 0.00227f
C41589 hold129/a_56_118# hold91/a_56_118# 0
C41590 net89 net103 0.36136f
C41591 hold125/a_326_118# _264_ 0
C41592 hold178/a_326_118# _189_ 0
C41593 net177 _519_/a_175_118# 0.00165f
C41594 hold108/a_326_118# net108 0.00121f
C41595 net11 _665_/a_843_236# 0
C41596 _206_ _657_/a_324_432# 0
C41597 _672_/a_1489_191# _181_ 0.00338f
C41598 hold78/a_326_118# rx_data[1] 0
C41599 net116 _681_/a_741_93# 0.00513f
C41600 _288_ _681_/a_843_236# 0
C41601 _166_ net11 0
C41602 _229_ FILLER_18_169/a_40_246# 0
C41603 _634_/a_38_114# rx_inst.data_reg\[5\] 0
C41604 _637_/a_612_127# net72 0
C41605 _313_ _700_/a_612_127# 0.0026f
C41606 _637_/a_550_127# _048_ 0
C41607 _637_/a_2250_412# net17 0.01462f
C41608 _670_/a_1583_191# _169_ 0
C41609 _109_ _024_ 0.18086f
C41610 FILLER_20_65/a_32_246# baud_inst.counter\[25\] 0
C41611 _194_ tx_inst.bit_index\[2\] 0.04532f
C41612 _707_/a_132_114# _121_ 0
C41613 baud_inst.counter\[16\] _015_ 0.01683f
C41614 clknet_4_14_0_clk net45 0
C41615 _045_ rx_data[2] 0.00219f
C41616 _309_ _687_/a_1840_334# 0
C41617 _641_/a_324_432# hold176/a_438_182# 0
C41618 _439_/a_150_412# _251_ 0
C41619 baud_inst.counter\[21\] _694_/a_38_114# 0
C41620 _641_/a_843_236# hold176/a_56_118# 0.0028f
C41621 _641_/a_741_93# hold176/a_326_118# 0.00231f
C41622 net41 _653_/a_550_127# 0
C41623 _118_ _705_/a_1840_334# 0
C41624 net35 net37 0.0681f
C41625 _691_/a_2250_412# net163 0
C41626 hold112/a_56_118# _223_ 0.00495f
C41627 _697_/a_38_114# clknet_4_9_0_clk 0
C41628 _646_/a_2250_412# net111 0
C41629 _242_ _154_ 0
C41630 _058_ clknet_0_clk 0.00297f
C41631 net67 hold59/a_56_118# 0.02684f
C41632 fanout27/a_40_152# rx_inst.state\[4\] 0
C41633 _343_/a_155_412# net27 0.00168f
C41634 _643_/a_324_432# _264_ 0.00681f
C41635 fanout32/a_40_152# net2 0
C41636 _153_ _458_/a_165_412# 0.00197f
C41637 hold74/a_326_118# rx_inst.data_reg\[7\] 0
C41638 hold124/a_326_118# rx_inst.data_reg\[6\] 0
C41639 _677_/a_1840_334# VPWR 0.00135f
C41640 _164_ _018_ 0.58644f
C41641 _649_/a_1583_191# _648_/a_2250_412# 0
C41642 _649_/a_741_93# _648_/a_1489_191# 0
C41643 net92 hold135/a_438_182# 0
C41644 net167 VPWR 0.10709f
C41645 net30 _474_/a_120_432# 0
C41646 clknet_4_3_0_clk tx_inst.data_reg\[5\] 0
C41647 net49 net160 0
C41648 net31 net51 0
C41649 baud_inst.counter\[27\] _311_ 0.01906f
C41650 baud_inst.counter\[26\] baud_inst.counter\[25\] 0.09417f
C41651 _690_/a_741_93# _103_ 0.0021f
C41652 _690_/a_38_114# clknet_4_8_0_clk 0.00261f
C41653 net41 net171 0
C41654 clkload0/Y clknet_4_3_0_clk 0.00997f
C41655 _686_/a_298_337# _685_/a_1840_334# 0
C41656 net87 _687_/a_298_337# 0.00178f
C41657 _686_/a_1583_191# _685_/a_38_114# 0
C41658 _045_ _637_/a_843_236# 0
C41659 net132 _253_ 0
C41660 FILLER_18_65/a_40_246# clknet_4_8_0_clk 0.01496f
C41661 net46 _347_/a_248_122# 0
C41662 hold168/a_326_118# _171_ 0
C41663 _044_ _648_/a_38_114# 0
C41664 net179 net168 0.00165f
C41665 _425_/a_46_156# _224_ 0.00382f
C41666 hold160/a_438_182# _101_ 0
C41667 _466_/a_22_110# _650_/a_741_93# 0
C41668 hold146/a_326_118# _215_ 0
C41669 hold103/a_56_118# _529_/a_45_160# 0
C41670 _691_/a_612_127# _104_ 0
C41671 _646_/a_1840_334# _057_ 0
C41672 _076_ _664_/a_550_127# 0
C41673 _276_ _480_/a_22_110# 0.01549f
C41674 net109 _508_/a_380_412# 0
C41675 _292_ _508_/a_177_436# 0
C41676 _083_ hold128/a_56_118# 0.00334f
C41677 _126_ _264_ 0.01893f
C41678 net133 hold105/a_438_182# 0
C41679 _198_ _664_/a_1840_334# 0
C41680 hold101/a_438_182# net40 0
C41681 clknet_4_14_0_clk net125 0.00791f
C41682 _514_/a_155_412# clknet_0_clk 0.00107f
C41683 net69 net30 0.04477f
C41684 net19 VGND 0.97321f
C41685 baud_inst.counter\[29\] VGND 1.13534f
C41686 net139 VGND 0.31069f
C41687 _647_/a_2002_114# VGND 0.00341f
C41688 _647_/a_1489_191# VGND 0.10493f
C41689 _647_/a_550_127# VGND 0
C41690 _647_/a_612_127# VGND 0.03872f
C41691 _647_/a_1785_429# VGND 0
C41692 _647_/a_2250_412# VGND 0.44345f
C41693 _647_/a_1840_334# VGND 0.25043f
C41694 _647_/a_1583_191# VGND 0.55551f
C41695 _647_/a_132_114# VGND 0
C41696 _647_/a_681_505# VGND 0
C41697 _647_/a_843_236# VGND 0.3993f
C41698 _647_/a_741_93# VGND 0.87058f
C41699 _647_/a_324_432# VGND 1.633f
C41700 _647_/a_38_114# VGND 0.19695f
C41701 _647_/a_298_337# VGND 0.24471f
C41702 _150_ VGND 0.31655f
C41703 _208_ VGND 0.5563f
C41704 net170 VGND 0.50173f
C41705 _380_/a_496_118# VGND 0.00142f
C41706 _380_/a_285_118# VGND 0
C41707 _380_/a_382_118# VGND 0.71398f
C41708 _380_/a_59_156# VGND 0.38229f
C41709 FILLER_15_42/a_40_246# VGND 0.17823f
C41710 FILLER_25_141/a_32_246# VGND 0.13537f
C41711 FILLER_25_163/a_32_246# VGND 0.11961f
C41712 hold95/a_438_182# VGND 0.37631f
C41713 hold95/a_326_118# VGND 0.31858f
C41714 hold95/a_56_118# VGND 0.51806f
C41715 FILLER_4_237/a_40_246# VGND 0.18056f
C41716 tx_inst.state\[2\] VGND 0.45509f
C41717 _005_ VGND 0.31648f
C41718 _664_/a_2002_114# VGND 0.0036f
C41719 _664_/a_1489_191# VGND 0.09846f
C41720 _664_/a_550_127# VGND 0
C41721 _664_/a_612_127# VGND 0.03944f
C41722 _664_/a_1785_429# VGND 0
C41723 _664_/a_2250_412# VGND 0.44551f
C41724 _664_/a_1840_334# VGND 0.25155f
C41725 _664_/a_1583_191# VGND 0.55013f
C41726 _664_/a_132_114# VGND 0
C41727 _664_/a_681_505# VGND 0
C41728 _664_/a_843_236# VGND 0.40386f
C41729 _664_/a_741_93# VGND 0.8815f
C41730 _664_/a_324_432# VGND 1.63207f
C41731 _664_/a_38_114# VGND 0.20253f
C41732 _664_/a_298_337# VGND 0.24708f
C41733 _084_ VGND 0.81358f
C41734 rx_inst.state\[4\] VGND 0.44193f
C41735 hold62/a_438_182# VGND 0.37577f
C41736 hold62/a_326_118# VGND 0.31703f
C41737 hold62/a_56_118# VGND 0.50955f
C41738 hold51/a_438_182# VGND 0.37557f
C41739 hold51/a_326_118# VGND 0.31678f
C41740 hold51/a_56_118# VGND 0.48476f
C41741 hold73/a_438_182# VGND 0.37558f
C41742 hold73/a_326_118# VGND 0.31714f
C41743 hold73/a_56_118# VGND 0.48107f
C41744 hold84/a_438_182# VGND 0.37576f
C41745 hold84/a_326_118# VGND 0.31682f
C41746 hold84/a_56_118# VGND 0.48132f
C41747 FILLER_7_234/a_32_246# VGND 0.11907f
C41748 baud_inst.counter\[9\] VGND 1.05852f
C41749 net117 VGND 0.68583f
C41750 _681_/a_2002_114# VGND 0.0035f
C41751 _681_/a_1489_191# VGND 0.09561f
C41752 _681_/a_612_127# VGND 0.03692f
C41753 _681_/a_1785_429# VGND 0
C41754 _681_/a_2250_412# VGND 0.4446f
C41755 _681_/a_1840_334# VGND 0.25112f
C41756 _681_/a_1583_191# VGND 0.54802f
C41757 _681_/a_132_114# VGND 0
C41758 _681_/a_681_505# VGND 0
C41759 _681_/a_843_236# VGND 0.38027f
C41760 _681_/a_741_93# VGND 0.8478f
C41761 _681_/a_324_432# VGND 1.59951f
C41762 _681_/a_38_114# VGND 0.21888f
C41763 _681_/a_298_337# VGND 0.24718f
C41764 FILLER_12_208/a_32_246# VGND 0.1353f
C41765 FILLER_0_56/a_32_246# VGND 0.11948f
C41766 FILLER_12_42/a_32_246# VGND 0.1242f
C41767 net25 VGND 2.1701f
C41768 _416_/a_350_122# VGND 0.00277f
C41769 _416_/a_248_122# VGND 0.00785f
C41770 _416_/a_146_122# VGND 0.01214f
C41771 hold180/a_438_182# VGND 0.37562f
C41772 hold180/a_326_118# VGND 0.31772f
C41773 hold180/a_56_118# VGND 0.50626f
C41774 _347_/a_248_122# VGND 0.00723f
C41775 _347_/a_146_122# VGND 0.01198f
C41776 FILLER_8_191/a_32_246# VGND 0.11937f
C41777 FILLER_9_169/a_32_246# VGND 0.11921f
C41778 _197_ VGND 0.52735f
C41779 _196_ VGND 0.40572f
C41780 _364_/a_257_140# VGND 0.01135f
C41781 _364_/a_155_412# VGND 0.03925f
C41782 _502_/a_165_412# VGND 0
C41783 _137_ VGND 0.77956f
C41784 _247_ VGND 0.45242f
C41785 _156_ VGND 1.17088f
C41786 _433_/a_550_140# VGND 0.0015f
C41787 _433_/a_244_140# VGND 0.00159f
C41788 clkbuf_4_13_0_clk/a_27_118# VGND 2.35724f
C41789 _066_ VGND 0.88876f
C41790 rx_inst.data_reg\[5\] VGND 0.39815f
C41791 _648_/a_2002_114# VGND 0.0033f
C41792 _648_/a_1489_191# VGND 0.10757f
C41793 _648_/a_550_127# VGND -0
C41794 _648_/a_612_127# VGND 0.03858f
C41795 _648_/a_1785_429# VGND 0.00108f
C41796 _648_/a_2250_412# VGND 0.44518f
C41797 _648_/a_1840_334# VGND 0.2515f
C41798 _648_/a_1583_191# VGND 0.56484f
C41799 _648_/a_132_114# VGND 0
C41800 _648_/a_681_505# VGND 0
C41801 _648_/a_843_236# VGND 0.40091f
C41802 _648_/a_741_93# VGND 0.86185f
C41803 _648_/a_324_432# VGND 1.6331f
C41804 _648_/a_38_114# VGND 0.2208f
C41805 _648_/a_298_337# VGND 0.24478f
C41806 _209_ VGND 0.78242f
C41807 _381_/a_46_156# VGND 0.4113f
C41808 _161_ VGND 1.95256f
C41809 _450_/a_398_96# VGND 0.00557f
C41810 _450_/a_127_436# VGND 0.00163f
C41811 tx_inst.state\[3\] VGND 0.50037f
C41812 _665_/a_2002_114# VGND 0.0033f
C41813 _665_/a_1489_191# VGND 0.09572f
C41814 _665_/a_612_127# VGND 0.03733f
C41815 _665_/a_1785_429# VGND 0
C41816 _665_/a_2250_412# VGND 0.44167f
C41817 _665_/a_1840_334# VGND 0.24894f
C41818 _665_/a_1583_191# VGND 0.54628f
C41819 _665_/a_132_114# VGND 0
C41820 _665_/a_681_505# VGND 0
C41821 _665_/a_843_236# VGND 0.38175f
C41822 _665_/a_741_93# VGND 0.85013f
C41823 _665_/a_324_432# VGND 1.60323f
C41824 _665_/a_38_114# VGND 0.19793f
C41825 _665_/a_298_337# VGND 0.24531f
C41826 hold94/a_438_182# VGND 0.37778f
C41827 hold94/a_326_118# VGND 0.32035f
C41828 hold94/a_56_118# VGND 0.51952f
C41829 FILLER_6_98/a_40_246# VGND 0.16865f
C41830 FILLER_6_54/a_32_246# VGND 0.11972f
C41831 FILLER_6_21/a_40_246# VGND 0.18122f
C41832 _085_ VGND 0.94341f
C41833 net38 VGND 5.08549f
C41834 net61 VGND 0.70882f
C41835 _033_ VGND 0.42725f
C41836 hold61/a_438_182# VGND 0.38396f
C41837 hold61/a_326_118# VGND 0.32524f
C41838 hold61/a_56_118# VGND 0.48943f
C41839 hold50/a_438_182# VGND 0.37775f
C41840 hold50/a_326_118# VGND 0.31887f
C41841 hold50/a_56_118# VGND 0.48871f
C41842 hold72/a_438_182# VGND 0.37745f
C41843 hold72/a_326_118# VGND 0.31949f
C41844 hold72/a_56_118# VGND 0.48744f
C41845 hold83/a_438_182# VGND 0.37802f
C41846 hold83/a_326_118# VGND 0.32035f
C41847 hold83/a_56_118# VGND 0.4844f
C41848 clknet_4_2_0_clk VGND 2.5186f
C41849 _682_/a_2002_114# VGND 0.00496f
C41850 _682_/a_1489_191# VGND 0.09631f
C41851 _682_/a_612_127# VGND 0.03671f
C41852 _682_/a_1785_429# VGND 0
C41853 _682_/a_2250_412# VGND 0.46554f
C41854 _682_/a_1840_334# VGND 0.26846f
C41855 _682_/a_1583_191# VGND 0.56475f
C41856 _682_/a_132_114# VGND 0
C41857 _682_/a_843_236# VGND 0.38394f
C41858 _682_/a_741_93# VGND 0.8525f
C41859 _682_/a_324_432# VGND 1.60081f
C41860 _682_/a_38_114# VGND 0.19498f
C41861 _682_/a_298_337# VGND 0.24629f
C41862 FILLER_21_229/a_32_246# VGND 0.11886f
C41863 net86 VGND 1.94027f
C41864 net181 VGND 1.33884f
C41865 _348_/a_248_122# VGND 0.00717f
C41866 _348_/a_146_122# VGND 0.01191f
C41867 _140_ VGND 0.38861f
C41868 _235_ VGND 0.50834f
C41869 _417_/a_22_110# VGND 0.28053f
C41870 FILLER_10_145/a_40_246# VGND 0.17974f
C41871 FILLER_3_21/a_40_246# VGND 0.1802f
C41872 _365_/a_257_140# VGND 0.01167f
C41873 _365_/a_155_412# VGND 0.04199f
C41874 _037_ VGND 0.55644f
C41875 net95 VGND 0.41187f
C41876 net29 VGND 3.92878f
C41877 _503_/a_279_412# VGND 0
C41878 _503_/a_165_412# VGND 0
C41879 _434_/a_150_412# VGND 0
C41880 FILLER_22_175/a_32_246# VGND 0.12471f
C41881 _149_ VGND 0.27684f
C41882 net137 VGND 0.62031f
C41883 _382_/a_496_118# VGND 0.00167f
C41884 _382_/a_285_118# VGND 0
C41885 _382_/a_559_412# VGND 0.00118f
C41886 _382_/a_285_412# VGND 0
C41887 _382_/a_382_118# VGND 0.71856f
C41888 _382_/a_59_156# VGND 0.43616f
C41889 net24 VGND 3.10395f
C41890 net175 VGND 1.13852f
C41891 _451_/a_257_140# VGND 0.01118f
C41892 _451_/a_155_412# VGND 0.03831f
C41893 rx_inst.data_reg\[6\] VGND 0.36779f
C41894 net127 VGND 0.29697f
C41895 _649_/a_2002_114# VGND 0.00331f
C41896 _649_/a_1489_191# VGND 0.09665f
C41897 _649_/a_550_127# VGND 0
C41898 _649_/a_612_127# VGND 0.03911f
C41899 _649_/a_1785_429# VGND 0
C41900 _649_/a_2250_412# VGND 0.44343f
C41901 _649_/a_1840_334# VGND 0.2509f
C41902 _649_/a_1583_191# VGND 0.5479f
C41903 _649_/a_132_114# VGND 0
C41904 _649_/a_681_505# VGND 0
C41905 _649_/a_843_236# VGND 0.41147f
C41906 _649_/a_741_93# VGND 0.8789f
C41907 _649_/a_324_432# VGND 1.62444f
C41908 _649_/a_38_114# VGND 0.20013f
C41909 _649_/a_298_337# VGND 0.24876f
C41910 FILLER_25_150/a_32_246# VGND 0.12522f
C41911 _297_ VGND 0.36089f
C41912 _520_/a_257_140# VGND 0.01136f
C41913 _520_/a_155_412# VGND 0.0393f
C41914 _666_/a_2002_114# VGND 0.00489f
C41915 _666_/a_1489_191# VGND 0.10486f
C41916 _666_/a_612_127# VGND 0.03768f
C41917 _666_/a_1785_429# VGND 0.00238f
C41918 _666_/a_2250_412# VGND 0.44396f
C41919 _666_/a_1840_334# VGND 0.26689f
C41920 _666_/a_1583_191# VGND 0.5687f
C41921 _666_/a_132_114# VGND 0
C41922 _666_/a_843_236# VGND 0.38766f
C41923 _666_/a_741_93# VGND 0.84822f
C41924 _666_/a_324_432# VGND 1.60808f
C41925 _666_/a_38_114# VGND 0.19739f
C41926 _666_/a_298_337# VGND 0.24244f
C41927 hold93/a_438_182# VGND 0.37608f
C41928 hold93/a_326_118# VGND 0.317f
C41929 hold93/a_56_118# VGND 0.48238f
C41930 _086_ VGND 0.99182f
C41931 net40 VGND 3.77771f
C41932 hold60/a_438_182# VGND 0.37801f
C41933 hold60/a_326_118# VGND 0.3209f
C41934 hold60/a_56_118# VGND 0.48849f
C41935 clkbuf_4_14_0_clk/a_27_118# VGND 2.38537f
C41936 hold71/a_438_182# VGND 0.3774f
C41937 hold71/a_326_118# VGND 0.3197f
C41938 hold71/a_56_118# VGND 0.48379f
C41939 hold82/a_438_182# VGND 0.37561f
C41940 hold82/a_326_118# VGND 0.31681f
C41941 hold82/a_56_118# VGND 0.51702f
C41942 FILLER_20_95/a_40_246# VGND 0.16156f
C41943 baud_inst.counter\[11\] VGND 0.47334f
C41944 _096_ VGND 0.92491f
C41945 _683_/a_2002_114# VGND 0.00329f
C41946 _683_/a_1489_191# VGND 0.09495f
C41947 _683_/a_550_127# VGND 0
C41948 _683_/a_612_127# VGND 0.03715f
C41949 _683_/a_2250_412# VGND 0.44245f
C41950 _683_/a_1840_334# VGND 0.2473f
C41951 _683_/a_1583_191# VGND 0.54262f
C41952 _683_/a_132_114# VGND 0
C41953 _683_/a_681_505# VGND 0
C41954 _683_/a_843_236# VGND 0.37988f
C41955 _683_/a_741_93# VGND 0.8461f
C41956 _683_/a_324_432# VGND 1.60016f
C41957 _683_/a_38_114# VGND 0.21748f
C41958 _683_/a_298_337# VGND 0.24468f
C41959 FILLER_7_210/a_40_246# VGND 0.16379f
C41960 FILLER_0_54/a_40_246# VGND 0.1658f
C41961 FILLER_23_83/a_32_246# VGND 0.11888f
C41962 FILLER_5_192/a_40_246# VGND 0.16712f
C41963 FILLER_5_181/a_32_246# VGND 0.1197f
C41964 _182_ VGND 2.37244f
C41965 _349_/a_350_122# VGND 0.00285f
C41966 _349_/a_248_122# VGND 0.00788f
C41967 _349_/a_146_122# VGND 0.01199f
C41968 _236_ VGND 1.59415f
C41969 _418_/a_268_412# VGND 0
C41970 _418_/a_46_156# VGND 0.42156f
C41971 net11 VGND 0.73192f
C41972 _366_/a_170_412# VGND 0
C41973 _038_ VGND 0.49186f
C41974 _287_ VGND 2.11968f
C41975 net135 VGND 1.3653f
C41976 _504_/a_474_130# VGND 0.00938f
C41977 _504_/a_380_412# VGND 0.00785f
C41978 _504_/a_177_436# VGND 0.0015f
C41979 _504_/a_209_168# VGND 0.41468f
C41980 _435_/a_166_436# VGND 0
C41981 _435_/a_72_436# VGND 0.61856f
C41982 FILLER_22_152/a_32_246# VGND 0.1349f
C41983 _210_ VGND 0.59939f
C41984 _383_/a_268_412# VGND 0
C41985 _383_/a_46_156# VGND 0.41128f
C41986 FILLER_1_237/a_40_246# VGND 0.17932f
C41987 _014_ VGND 0.43578f
C41988 net88 VGND 0.55674f
C41989 _521_/a_170_412# VGND 0
C41990 _452_/a_257_140# VGND 0.01118f
C41991 _452_/a_155_412# VGND 0.03897f
C41992 _087_ VGND 0.85001f
C41993 net63 VGND 0.33915f
C41994 _667_/a_2002_114# VGND 0.00329f
C41995 _667_/a_1489_191# VGND 0.09495f
C41996 _667_/a_612_127# VGND 0.03673f
C41997 _667_/a_2250_412# VGND 0.44945f
C41998 _667_/a_1840_334# VGND 0.24739f
C41999 _667_/a_1583_191# VGND 0.54312f
C42000 _667_/a_132_114# VGND 0
C42001 _667_/a_843_236# VGND 0.37919f
C42002 _667_/a_741_93# VGND 0.84441f
C42003 _667_/a_324_432# VGND 1.59681f
C42004 _667_/a_38_114# VGND 0.1935f
C42005 _667_/a_298_337# VGND 0.24254f
C42006 FILLER_20_0/a_40_246# VGND 0.16236f
C42007 hold92/a_438_182# VGND 0.37554f
C42008 hold92/a_326_118# VGND 0.31795f
C42009 hold92/a_56_118# VGND 0.51269f
C42010 hold81/a_438_182# VGND 0.37559f
C42011 hold81/a_326_118# VGND 0.31783f
C42012 hold81/a_56_118# VGND 0.4821f
C42013 hold70/a_438_182# VGND 0.3777f
C42014 hold70/a_326_118# VGND 0.32108f
C42015 hold70/a_56_118# VGND 0.48548f
C42016 FILLER_29_179/a_40_246# VGND 0.16153f
C42017 _684_/a_2002_114# VGND 0.00329f
C42018 _684_/a_1489_191# VGND 0.0951f
C42019 _684_/a_550_127# VGND 0
C42020 _684_/a_612_127# VGND 0.0383f
C42021 _684_/a_1785_429# VGND 0
C42022 _684_/a_2250_412# VGND 0.44252f
C42023 _684_/a_1840_334# VGND 0.24725f
C42024 _684_/a_1583_191# VGND 0.54636f
C42025 _684_/a_132_114# VGND 0
C42026 _684_/a_681_505# VGND 0
C42027 _684_/a_843_236# VGND 0.38312f
C42028 _684_/a_741_93# VGND 0.84563f
C42029 _684_/a_324_432# VGND 1.60456f
C42030 _684_/a_38_114# VGND 0.21929f
C42031 _684_/a_298_337# VGND 0.24616f
C42032 FILLER_0_109/a_32_246# VGND 0.11962f
C42033 clknet_4_15_0_clk VGND 2.77779f
C42034 clkbuf_4_15_0_clk/a_27_118# VGND 2.42324f
C42035 FILLER_2_183/a_32_246# VGND 0.12469f
C42036 FILLER_0_42/a_32_246# VGND 0.12372f
C42037 _237_ VGND 0.40078f
C42038 _419_/a_154_118# VGND 0.00967f
C42039 FILLER_10_110/a_40_246# VGND 0.16154f
C42040 FILLER_8_19/a_40_246# VGND 0.16398f
C42041 FILLER_18_210/a_32_246# VGND 0.11932f
C42042 FILLER_27_210/a_40_246# VGND 0.16339f
C42043 _505_/a_272_160# VGND 0.00359f
C42044 _505_/a_170_160# VGND 0.00156f
C42045 _505_/a_76_160# VGND 0.36654f
C42046 _200_ VGND 1.91863f
C42047 net168 VGND 1.96434f
C42048 net172 VGND 1.50836f
C42049 _367_/a_170_412# VGND 0
C42050 _136_ VGND 0.90861f
C42051 _249_ VGND 0.78591f
C42052 _250_ VGND 0.42641f
C42053 _157_ VGND 1.01263f
C42054 _436_/a_550_140# VGND 0.00145f
C42055 _436_/a_244_140# VGND 0.00145f
C42056 _148_ VGND 0.39803f
C42057 net171 VGND 0.3727f
C42058 _384_/a_496_118# VGND 0.00142f
C42059 _384_/a_285_118# VGND 0
C42060 _384_/a_382_118# VGND 0.71369f
C42061 _384_/a_59_156# VGND 0.39006f
C42062 _015_ VGND 0.41029f
C42063 _296_ VGND 4.58589f
C42064 net160 VGND 0.95213f
C42065 _522_/a_474_130# VGND 0.0076f
C42066 _522_/a_380_412# VGND 0
C42067 _522_/a_177_436# VGND 0
C42068 _522_/a_209_168# VGND 0.38893f
C42069 _131_ VGND 0.458f
C42070 _262_ VGND 0.60591f
C42071 _261_ VGND 0.45984f
C42072 _453_/a_170_412# VGND 0
C42073 _088_ VGND 0.905f
C42074 rx_inst.state\[1\] VGND 0.46822f
C42075 _668_/a_2002_114# VGND 0.00344f
C42076 _668_/a_1489_191# VGND 0.09635f
C42077 _668_/a_550_127# VGND 0
C42078 _668_/a_612_127# VGND 0.047f
C42079 _668_/a_1785_429# VGND 0
C42080 _668_/a_2250_412# VGND 0.44175f
C42081 _668_/a_1840_334# VGND 0.24962f
C42082 _668_/a_1583_191# VGND 0.54674f
C42083 _668_/a_132_114# VGND 0
C42084 _668_/a_681_505# VGND 0.00125f
C42085 _668_/a_843_236# VGND 0.38812f
C42086 _668_/a_741_93# VGND 0.85802f
C42087 _668_/a_324_432# VGND 1.63419f
C42088 _668_/a_38_114# VGND 0.2162f
C42089 _668_/a_298_337# VGND 0.26459f
C42090 net80 VGND 0.62846f
C42091 hold80/a_438_182# VGND 0.37552f
C42092 hold80/a_326_118# VGND 0.31684f
C42093 hold80/a_56_118# VGND 0.4847f
C42094 net91 VGND 0.54039f
C42095 hold91/a_438_182# VGND 0.37575f
C42096 hold91/a_326_118# VGND 0.31679f
C42097 hold91/a_56_118# VGND 0.48127f
C42098 _124_ VGND 0.37363f
C42099 _271_ VGND 0.42324f
C42100 _470_/a_22_110# VGND 0.24401f
C42101 _470_/a_120_432# VGND 0.00106f
C42102 FILLER_29_145/a_40_246# VGND 0.17937f
C42103 clknet_4_9_0_clk VGND 2.86249f
C42104 net130 VGND 0.31521f
C42105 _685_/a_2002_114# VGND 0.00329f
C42106 _685_/a_1489_191# VGND 0.09496f
C42107 _685_/a_612_127# VGND 0.03671f
C42108 _685_/a_2250_412# VGND 0.45108f
C42109 _685_/a_1840_334# VGND 0.24794f
C42110 _685_/a_1583_191# VGND 0.55079f
C42111 _685_/a_132_114# VGND 0
C42112 _685_/a_843_236# VGND 0.37954f
C42113 _685_/a_741_93# VGND 0.84362f
C42114 _685_/a_324_432# VGND 1.59711f
C42115 _685_/a_38_114# VGND 0.19353f
C42116 _685_/a_298_337# VGND 0.24243f
C42117 FILLER_9_72/a_32_246# VGND 0.11886f
C42118 FILLER_12_82/a_32_246# VGND 0.11886f
C42119 _289_ VGND 0.38412f
C42120 net115 VGND 1.44054f
C42121 _506_/a_257_140# VGND 0.01177f
C42122 _506_/a_155_412# VGND 0.04096f
C42123 _199_ VGND 0.92363f
C42124 _368_/a_257_140# VGND 0.01166f
C42125 _368_/a_155_412# VGND 0.04288f
C42126 _437_/a_154_118# VGND 0.00982f
C42127 _211_ VGND 0.54034f
C42128 _385_/a_268_412# VGND 0
C42129 _385_/a_46_156# VGND 0.41037f
C42130 _298_ VGND 0.3088f
C42131 _523_/a_257_140# VGND 0.01118f
C42132 _523_/a_155_412# VGND 0.03831f
C42133 _263_ VGND 0.59594f
C42134 _454_/a_257_140# VGND 0.01128f
C42135 _454_/a_155_412# VGND 0.03852f
C42136 net90 VGND 0.9427f
C42137 hold90/a_438_182# VGND 0.3759f
C42138 hold90/a_326_118# VGND 0.3168f
C42139 hold90/a_56_118# VGND 0.50791f
C42140 _669_/a_2002_114# VGND 0.00329f
C42141 _669_/a_1489_191# VGND 0.09501f
C42142 _669_/a_612_127# VGND 0.03671f
C42143 _669_/a_2250_412# VGND 0.44854f
C42144 _669_/a_1840_334# VGND 0.24964f
C42145 _669_/a_1583_191# VGND 0.54757f
C42146 _669_/a_132_114# VGND 0
C42147 _669_/a_843_236# VGND 0.3831f
C42148 _669_/a_741_93# VGND 0.85294f
C42149 _669_/a_324_432# VGND 1.59723f
C42150 _669_/a_38_114# VGND 0.194f
C42151 _669_/a_298_337# VGND 0.24313f
C42152 _308_ VGND 1.72876f
C42153 _540_/a_139_160# VGND 0.00692f
C42154 _540_/a_45_160# VGND 0.34695f
C42155 _272_ VGND 0.33336f
C42156 net77 VGND 0.47156f
C42157 _471_/a_22_110# VGND 0.24644f
C42158 _471_/a_120_432# VGND 0.0013f
C42159 FILLER_15_0/a_40_246# VGND 0.16243f
C42160 _686_/a_2002_114# VGND 0.00329f
C42161 _686_/a_1489_191# VGND 0.095f
C42162 _686_/a_612_127# VGND 0.03671f
C42163 _686_/a_2250_412# VGND 0.44059f
C42164 _686_/a_1840_334# VGND 0.24737f
C42165 _686_/a_1583_191# VGND 0.54268f
C42166 _686_/a_132_114# VGND 0
C42167 _686_/a_843_236# VGND 0.38351f
C42168 _686_/a_741_93# VGND 0.84735f
C42169 _686_/a_324_432# VGND 1.59691f
C42170 _686_/a_38_114# VGND 0.19338f
C42171 _686_/a_298_337# VGND 0.24243f
C42172 FILLER_0_40/a_40_246# VGND 0.1781f
C42173 FILLER_24_4/a_40_246# VGND 0.17338f
C42174 FILLER_6_189/a_40_246# VGND 0.16626f
C42175 _039_ VGND 0.4406f
C42176 net116 VGND 0.64903f
C42177 _288_ VGND 1.63585f
C42178 _507_/a_170_412# VGND 0
C42179 _369_/a_248_122# VGND 0.0073f
C42180 _369_/a_146_122# VGND 0.01212f
C42181 _252_ VGND 0.4409f
C42182 _438_/a_350_122# VGND 0.00286f
C42183 _438_/a_248_122# VGND 0.0079f
C42184 _438_/a_146_122# VGND 0.01206f
C42185 _386_/a_496_118# VGND 0.00172f
C42186 _386_/a_285_118# VGND 0
C42187 _386_/a_559_412# VGND 0
C42188 _386_/a_285_412# VGND 0
C42189 _386_/a_382_118# VGND 0.71941f
C42190 _386_/a_59_156# VGND 0.3852f
C42191 baud_inst.counter\[16\] VGND 2.15814f
C42192 _524_/a_248_122# VGND 0.00713f
C42193 _524_/a_146_122# VGND 0.01188f
C42194 _130_ VGND 0.31498f
C42195 net52 VGND 0.60285f
C42196 _455_/a_257_140# VGND 0.01118f
C42197 _455_/a_155_412# VGND 0.03831f
C42198 FILLER_1_201/a_40_246# VGND 0.16412f
C42199 FILLER_1_212/a_32_246# VGND 0.11937f
C42200 FILLER_25_25/a_40_246# VGND 0.16878f
C42201 FILLER_25_36/a_32_246# VGND 0.1202f
C42202 _099_ VGND 1.00409f
C42203 net46 VGND 4.07866f
C42204 net162 VGND 0.81049f
C42205 _541_/a_474_130# VGND 0.0076f
C42206 _541_/a_380_412# VGND 0
C42207 _541_/a_177_436# VGND 0
C42208 _541_/a_209_168# VGND 0.38877f
C42209 _123_ VGND 0.33986f
C42210 _472_/a_22_110# VGND 0.24259f
C42211 FILLER_29_165/a_40_246# VGND 0.16764f
C42212 FILLER_29_198/a_40_246# VGND 0.18377f
C42213 _687_/a_2002_114# VGND 0.00329f
C42214 _687_/a_1489_191# VGND 0.09526f
C42215 _687_/a_550_127# VGND 0
C42216 _687_/a_612_127# VGND 0.03819f
C42217 _687_/a_2250_412# VGND 0.43976f
C42218 _687_/a_1840_334# VGND 0.24725f
C42219 _687_/a_1583_191# VGND 0.54334f
C42220 _687_/a_132_114# VGND 0
C42221 _687_/a_681_505# VGND 0
C42222 _687_/a_843_236# VGND 0.38305f
C42223 _687_/a_741_93# VGND 0.85023f
C42224 _687_/a_324_432# VGND 1.60285f
C42225 _687_/a_38_114# VGND 0.1997f
C42226 _687_/a_298_337# VGND 0.24613f
C42227 FILLER_9_70/a_40_246# VGND 0.162f
C42228 FILLER_0_117/a_32_246# VGND 0.11896f
C42229 FILLER_0_128/a_40_246# VGND 0.16152f
C42230 _508_/a_474_130# VGND 0.00823f
C42231 _508_/a_380_412# VGND 0.0069f
C42232 _508_/a_177_436# VGND 0.00401f
C42233 _508_/a_209_168# VGND 0.41276f
C42234 _253_ VGND 0.92348f
C42235 _251_ VGND 0.39497f
C42236 _439_/a_354_412# VGND 0
C42237 _439_/a_252_412# VGND 0
C42238 _439_/a_150_412# VGND 0
C42239 FILLER_14_148/a_40_246# VGND 0.16214f
C42240 _212_ VGND 0.56344f
C42241 net5 VGND 0.41263f
C42242 _387_/a_268_412# VGND 0
C42243 _387_/a_46_156# VGND 0.40152f
C42244 _016_ VGND 0.36605f
C42245 _299_ VGND 1.11693f
C42246 net157 VGND 0.64728f
C42247 _525_/a_268_412# VGND 0
C42248 _525_/a_46_156# VGND 0.40237f
C42249 _264_ VGND 3.23823f
C42250 _456_/a_257_140# VGND 0.01156f
C42251 _456_/a_155_412# VGND 0.04166f
C42252 _100_ VGND 0.82498f
C42253 _309_ VGND 0.45954f
C42254 baud_inst.counter\[24\] VGND 1.75431f
C42255 net140 VGND 0.75019f
C42256 _542_/a_257_140# VGND 0.01118f
C42257 _542_/a_155_412# VGND 0.03931f
C42258 _273_ VGND 0.60303f
C42259 net64 VGND 0.49795f
C42260 _473_/a_22_110# VGND 0.28577f
C42261 _473_/a_120_432# VGND 0.00118f
C42262 FILLER_8_238/a_32_246# VGND 0.11889f
C42263 clknet_0_clk VGND 19.13631f
C42264 clkbuf_4_0_0_clk/a_27_118# VGND 2.37979f
C42265 net161 VGND 0.41066f
C42266 _688_/a_2002_114# VGND 0.00351f
C42267 _688_/a_1489_191# VGND 0.09553f
C42268 _688_/a_612_127# VGND 0.03671f
C42269 _688_/a_1785_429# VGND 0
C42270 _688_/a_2250_412# VGND 0.45157f
C42271 _688_/a_1840_334# VGND 0.25085f
C42272 _688_/a_1583_191# VGND 0.54774f
C42273 _688_/a_132_114# VGND 0
C42274 _688_/a_843_236# VGND 0.3799f
C42275 _688_/a_741_93# VGND 0.8442f
C42276 _688_/a_324_432# VGND 1.5974f
C42277 _688_/a_38_114# VGND 0.19353f
C42278 _688_/a_298_337# VGND 0.24243f
C42279 _279_ VGND 0.44286f
C42280 _490_/a_139_160# VGND 0.00712f
C42281 _490_/a_45_160# VGND 0.34713f
C42282 FILLER_17_24/a_32_246# VGND 0.11886f
C42283 FILLER_17_79/a_40_246# VGND 0.16157f
C42284 FILLER_19_228/a_40_246# VGND 0.1615f
C42285 _290_ VGND 0.31254f
C42286 _509_/a_257_140# VGND 0.01153f
C42287 _509_/a_155_412# VGND 0.04091f
C42288 FILLER_20_106/a_32_246# VGND 0.11889f
C42289 _146_ VGND 0.30356f
C42290 net165 VGND 0.51674f
C42291 _388_/a_496_118# VGND 0.00142f
C42292 _388_/a_285_118# VGND 0
C42293 _388_/a_382_118# VGND 0.71391f
C42294 _388_/a_59_156# VGND 0.41142f
C42295 _457_/a_22_110# VGND 0.23931f
C42296 FILLER_23_158/a_40_246# VGND 0.1729f
C42297 _300_ VGND 0.49528f
C42298 net101 VGND 1.20847f
C42299 _526_/a_350_122# VGND 0.00269f
C42300 _526_/a_248_122# VGND 0.00777f
C42301 _526_/a_146_122# VGND 0.01185f
C42302 FILLER_17_199/a_40_246# VGND 0.19892f
C42303 _101_ VGND 0.95094f
C42304 _543_/a_248_122# VGND 0.00716f
C42305 _543_/a_146_122# VGND 0.0119f
C42306 _122_ VGND 0.32535f
C42307 net65 VGND 0.58371f
C42308 _474_/a_22_110# VGND 0.23977f
C42309 _474_/a_120_432# VGND 0
C42310 FILLER_5_207/a_32_246# VGND 0.11982f
C42311 FILLER_5_59/a_40_246# VGND 0.16338f
C42312 baud_inst.counter\[17\] VGND 1.26215f
C42313 net158 VGND 0.35539f
C42314 _689_/a_2002_114# VGND 0.00329f
C42315 _689_/a_1489_191# VGND 0.09495f
C42316 _689_/a_612_127# VGND 0.03672f
C42317 _689_/a_2250_412# VGND 0.44154f
C42318 _689_/a_1840_334# VGND 0.24725f
C42319 _689_/a_1583_191# VGND 0.54399f
C42320 _689_/a_132_114# VGND 0
C42321 _689_/a_843_236# VGND 0.37942f
C42322 _689_/a_741_93# VGND 0.84646f
C42323 _689_/a_324_432# VGND 1.59787f
C42324 _689_/a_38_114# VGND 0.2206f
C42325 _689_/a_298_337# VGND 0.2425f
C42326 _181_ VGND 1.9837f
C42327 net60 VGND 1.18069f
C42328 _491_/a_341_118# VGND 0.14069f
C42329 _491_/a_155_160# VGND 0.00126f
C42330 _491_/a_435_412# VGND 0
C42331 _491_/a_192_429# VGND 0.47178f
C42332 FILLER_0_115/a_40_246# VGND 0.16277f
C42333 _047_ VGND 0.85958f
C42334 FILLER_17_0/a_40_246# VGND 0.16287f
C42335 FILLER_3_123/a_32_246# VGND 0.13471f
C42336 FILLER_8_14/a_32_246# VGND 0.13478f
C42337 clkbuf_4_1_0_clk/a_27_118# VGND 2.38005f
C42338 _213_ VGND 0.51228f
C42339 _389_/a_46_156# VGND 0.4015f
C42340 _167_ VGND 1.47138f
C42341 _458_/a_165_412# VGND 0
C42342 _527_/a_341_118# VGND 0.13901f
C42343 _527_/a_155_160# VGND 0.00114f
C42344 _527_/a_192_429# VGND 0.467f
C42345 _001_ VGND 0.44111f
C42346 _475_/a_170_412# VGND 0
C42347 _025_ VGND 0.59625f
C42348 _310_ VGND 0.98929f
C42349 net141 VGND 0.58856f
C42350 _544_/a_268_412# VGND 0
C42351 _544_/a_46_156# VGND 0.40146f
C42352 _102_ VGND 1.00663f
C42353 _280_ VGND 1.05986f
C42354 _162_ VGND 1.06451f
C42355 _492_/a_170_412# VGND 0
C42356 FILLER_8_236/a_40_246# VGND 0.16224f
C42357 _120_ VGND 0.80313f
C42358 net43 VGND 4.03892f
C42359 FILLER_0_80/a_40_246# VGND 0.18393f
C42360 FILLER_0_103/a_32_246# VGND 0.11956f
C42361 FILLER_3_177/a_32_246# VGND 0.12601f
C42362 FILLER_17_22/a_40_246# VGND 0.16153f
C42363 FILLER_8_35/a_32_246# VGND 0.1195f
C42364 FILLER_22_22/a_32_246# VGND 0.11886f
C42365 FILLER_28_204/a_32_246# VGND 0.11953f
C42366 clkbuf_4_2_0_clk/a_27_118# VGND 2.35509f
C42367 FILLER_2_14/a_40_246# VGND 0.18247f
C42368 _266_ VGND 3.4086f
C42369 net30 VGND 3.66073f
C42370 _000_ VGND 0.9608f
C42371 _459_/a_229_118# VGND 0.00872f
C42372 _459_/a_27_156# VGND 0.43291f
C42373 _301_ VGND 1.45257f
C42374 net103 VGND 1.08452f
C42375 _528_/a_379_118# VGND 0.01381f
C42376 _528_/a_277_118# VGND 0.01361f
C42377 _528_/a_175_118# VGND 0.01019f
C42378 _528_/a_81_118# VGND 0.45917f
C42379 FILLER_17_131/a_32_246# VGND 0.13508f
C42380 FILLER_2_208/a_40_246# VGND 0.16928f
C42381 _274_ VGND 0.31225f
C42382 _476_/a_248_122# VGND 0.00716f
C42383 _476_/a_146_122# VGND 0.012f
C42384 _311_ VGND 0.47264f
C42385 baud_inst.counter\[25\] VGND 1.53366f
C42386 net99 VGND 1.28514f
C42387 _545_/a_350_122# VGND 0.00274f
C42388 _545_/a_248_122# VGND 0.00781f
C42389 _545_/a_146_122# VGND 0.01188f
C42390 _281_ VGND 0.486f
C42391 _493_/a_139_160# VGND 0.00643f
C42392 _493_/a_45_160# VGND 0.32943f
C42393 _121_ VGND 0.83567f
C42394 _049_ VGND 0.81346f
C42395 FILLER_28_53/a_32_246# VGND 0.12532f
C42396 net134 VGND 0.3338f
C42397 _700_/a_2002_114# VGND 0.00329f
C42398 _700_/a_1489_191# VGND 0.09495f
C42399 _700_/a_612_127# VGND 0.03671f
C42400 _700_/a_2250_412# VGND 0.43968f
C42401 _700_/a_1840_334# VGND 0.24725f
C42402 _700_/a_1583_191# VGND 0.54243f
C42403 _700_/a_132_114# VGND 0
C42404 _700_/a_843_236# VGND 0.37975f
C42405 _700_/a_741_93# VGND 0.84413f
C42406 _700_/a_324_432# VGND 1.59717f
C42407 _700_/a_38_114# VGND 0.1949f
C42408 _700_/a_298_337# VGND 0.24253f
C42409 FILLER_6_151/a_40_246# VGND 0.16273f
C42410 FILLER_11_125/a_32_246# VGND 0.12052f
C42411 FILLER_22_32/a_40_246# VGND 0.16271f
C42412 FILLER_22_43/a_40_246# VGND 0.16377f
C42413 FILLER_22_54/a_40_246# VGND 0.16334f
C42414 FILLER_2_46/a_40_246# VGND 0.16367f
C42415 FILLER_2_79/a_40_246# VGND 0.16244f
C42416 _529_/a_139_160# VGND 0.00745f
C42417 _529_/a_45_160# VGND 0.35016f
C42418 _221_ VGND 0.29737f
C42419 net183 VGND 1.36137f
C42420 _400_/a_341_118# VGND 0.13901f
C42421 _400_/a_155_160# VGND 0.00114f
C42422 _400_/a_192_429# VGND 0.46787f
C42423 _165_ VGND 0.42818f
C42424 FILLER_26_141/a_40_246# VGND 0.18049f
C42425 clkbuf_4_3_0_clk/a_27_118# VGND 2.35298f
C42426 _007_ VGND 0.38612f
C42427 net169 VGND 0.51508f
C42428 _166_ VGND 2.06034f
C42429 _477_/a_22_110# VGND 0.29984f
C42430 _477_/a_120_432# VGND 0
C42431 _104_ VGND 0.94955f
C42432 _026_ VGND 0.25462f
C42433 _546_/a_341_118# VGND 0.13906f
C42434 _546_/a_155_160# VGND 0.00114f
C42435 _546_/a_192_429# VGND 0.46726f
C42436 _494_/a_165_412# VGND 0
C42437 FILLER_0_156/a_32_246# VGND 0.11886f
C42438 _632_/a_2002_114# VGND 0.00329f
C42439 _632_/a_1489_191# VGND 0.09495f
C42440 _632_/a_612_127# VGND 0.03671f
C42441 _632_/a_2250_412# VGND 0.43978f
C42442 _632_/a_1840_334# VGND 0.24725f
C42443 _632_/a_1583_191# VGND 0.54231f
C42444 _632_/a_132_114# VGND 0
C42445 _632_/a_843_236# VGND 0.37915f
C42446 _632_/a_741_93# VGND 0.84322f
C42447 _632_/a_324_432# VGND 1.5986f
C42448 _632_/a_38_114# VGND 0.19523f
C42449 _632_/a_298_337# VGND 0.24363f
C42450 net107 VGND 0.63902f
C42451 _701_/a_2002_114# VGND 0.00353f
C42452 _701_/a_1489_191# VGND 0.09656f
C42453 _701_/a_550_127# VGND 0
C42454 _701_/a_612_127# VGND 0.03997f
C42455 _701_/a_1785_429# VGND 0
C42456 _701_/a_2250_412# VGND 0.44421f
C42457 _701_/a_1840_334# VGND 0.25398f
C42458 _701_/a_1583_191# VGND 0.55352f
C42459 _701_/a_132_114# VGND 0
C42460 _701_/a_681_505# VGND 0
C42461 _701_/a_843_236# VGND 0.39061f
C42462 _701_/a_741_93# VGND 0.85958f
C42463 _701_/a_324_432# VGND 1.63624f
C42464 _701_/a_38_114# VGND 0.22754f
C42465 _701_/a_298_337# VGND 0.26026f
C42466 FILLER_22_86/a_32_246# VGND 0.11889f
C42467 FILLER_11_32/a_32_246# VGND 0.12536f
C42468 FILLER_23_143/a_32_246# VGND 0.11886f
C42469 FILLER_17_162/a_32_246# VGND 0.11886f
C42470 _142_ VGND 0.44526f
C42471 _220_ VGND 0.41173f
C42472 _401_/a_22_110# VGND 0.23957f
C42473 FILLER_26_151/a_32_246# VGND 0.11911f
C42474 _478_/a_229_118# VGND 0.00848f
C42475 _478_/a_27_156# VGND 0.43088f
C42476 _105_ VGND 0.86224f
C42477 net113 VGND 0.79628f
C42478 _547_/a_379_118# VGND 0.01296f
C42479 _547_/a_277_118# VGND 0.00846f
C42480 _547_/a_175_118# VGND 0.00702f
C42481 _547_/a_81_118# VGND 0.45367f
C42482 _282_ VGND 1.01312f
C42483 baud_inst.counter\[4\] VGND 1.23881f
C42484 net152 VGND 0.98001f
C42485 _495_/a_154_118# VGND 0.00961f
C42486 _051_ VGND 0.87037f
C42487 net68 VGND 0.30472f
C42488 _115_ VGND 1.0939f
C42489 _702_/a_2002_114# VGND 0.00329f
C42490 _702_/a_1489_191# VGND 0.09499f
C42491 _702_/a_612_127# VGND 0.03682f
C42492 _702_/a_1785_429# VGND 0
C42493 _702_/a_2250_412# VGND 0.44939f
C42494 _702_/a_1840_334# VGND 0.24812f
C42495 _702_/a_1583_191# VGND 0.54574f
C42496 _702_/a_132_114# VGND 0
C42497 _702_/a_681_505# VGND 0
C42498 _702_/a_843_236# VGND 0.38171f
C42499 _702_/a_741_93# VGND 0.84594f
C42500 _702_/a_324_432# VGND 1.59814f
C42501 _702_/a_38_114# VGND 0.19559f
C42502 _702_/a_298_337# VGND 0.24401f
C42503 net78 VGND 0.36476f
C42504 _633_/a_2002_114# VGND 0.00496f
C42505 _633_/a_1489_191# VGND 0.09713f
C42506 _633_/a_612_127# VGND 0.03671f
C42507 _633_/a_1785_429# VGND 0
C42508 _633_/a_2250_412# VGND 0.45313f
C42509 _633_/a_1840_334# VGND 0.27282f
C42510 _633_/a_1583_191# VGND 0.56345f
C42511 _633_/a_132_114# VGND 0
C42512 _633_/a_843_236# VGND 0.38512f
C42513 _633_/a_741_93# VGND 0.84844f
C42514 _633_/a_324_432# VGND 1.59974f
C42515 _633_/a_38_114# VGND 0.20743f
C42516 _633_/a_298_337# VGND 0.24245f
C42517 clkbuf_4_4_0_clk/a_27_118# VGND 2.365f
C42518 FILLER_3_141/a_40_246# VGND 0.17948f
C42519 FILLER_17_96/a_32_246# VGND 0.11941f
C42520 FILLER_4_108/a_40_246# VGND 0.1645f
C42521 rx_inst.data_reg\[7\] VGND 0.35404f
C42522 net119 VGND 0.46279f
C42523 _061_ VGND 1.01861f
C42524 _650_/a_2002_114# VGND 0.0034f
C42525 _650_/a_1489_191# VGND 0.09577f
C42526 _650_/a_612_127# VGND 0.03739f
C42527 _650_/a_1785_429# VGND 0
C42528 _650_/a_2250_412# VGND 0.4421f
C42529 _650_/a_1840_334# VGND 0.25048f
C42530 _650_/a_1583_191# VGND 0.54718f
C42531 _650_/a_132_114# VGND 0
C42532 _650_/a_681_505# VGND 0
C42533 _650_/a_843_236# VGND 0.41398f
C42534 _650_/a_741_93# VGND 0.88482f
C42535 _650_/a_324_432# VGND 1.62103f
C42536 _650_/a_38_114# VGND 0.20066f
C42537 _650_/a_298_337# VGND 0.24634f
C42538 FILLER_8_21/a_32_246# VGND 0.11895f
C42539 FILLER_11_123/a_40_246# VGND 0.16187f
C42540 FILLER_11_134/a_32_246# VGND 0.12469f
C42541 FILLER_14_164/a_32_246# VGND 0.11973f
C42542 FILLER_23_186/a_40_246# VGND 0.16154f
C42543 _402_/a_154_118# VGND 0.00954f
C42544 FILLER_26_172/a_40_246# VGND 0.16921f
C42545 _006_ VGND 0.27786f
C42546 _275_ VGND 0.77804f
C42547 _479_/a_22_110# VGND 0.24659f
C42548 _479_/a_120_432# VGND 0.00108f
C42549 _313_ VGND 2.36382f
C42550 _312_ VGND 0.46625f
C42551 _548_/a_272_160# VGND 0.00339f
C42552 _548_/a_170_160# VGND 0
C42553 _548_/a_76_160# VGND 0.37895f
C42554 _106_ VGND 0.88611f
C42555 _183_ VGND 0.63454f
C42556 baud_inst.counter\[10\] VGND 0.81789f
C42557 _350_/a_279_412# VGND 0.00353f
C42558 _350_/a_165_412# VGND 0.00128f
C42559 FILLER_5_213/a_32_246# VGND 0.11998f
C42560 FILLER_5_32/a_40_246# VGND 0.17692f
C42561 FILLER_24_19/a_40_246# VGND 0.16282f
C42562 _496_/a_170_412# VGND 0
C42563 FILLER_0_154/a_40_246# VGND 0.16147f
C42564 net59 VGND 0.35316f
C42565 _703_/a_2002_114# VGND 0.0034f
C42566 _703_/a_1489_191# VGND 0.09557f
C42567 _703_/a_550_127# VGND 0
C42568 _703_/a_612_127# VGND 0.03732f
C42569 _703_/a_1785_429# VGND 0
C42570 _703_/a_2250_412# VGND 0.4521f
C42571 _703_/a_1840_334# VGND 0.2517f
C42572 _703_/a_1583_191# VGND 0.55475f
C42573 _703_/a_132_114# VGND 0
C42574 _703_/a_681_505# VGND 0
C42575 _703_/a_843_236# VGND 0.38959f
C42576 _703_/a_741_93# VGND 0.8521f
C42577 _703_/a_324_432# VGND 1.60372f
C42578 _703_/a_38_114# VGND 0.20027f
C42579 _703_/a_298_337# VGND 0.2477f
C42580 net83 VGND 0.29332f
C42581 _634_/a_2002_114# VGND 0.00329f
C42582 _634_/a_1489_191# VGND 0.09495f
C42583 _634_/a_550_127# VGND 0
C42584 _634_/a_612_127# VGND 0.03741f
C42585 _634_/a_2250_412# VGND 0.44265f
C42586 _634_/a_1840_334# VGND 0.24728f
C42587 _634_/a_1583_191# VGND 0.54562f
C42588 _634_/a_132_114# VGND 0
C42589 _634_/a_681_505# VGND 0
C42590 _634_/a_843_236# VGND 0.37937f
C42591 _634_/a_741_93# VGND 0.84273f
C42592 _634_/a_324_432# VGND 1.59986f
C42593 _634_/a_38_114# VGND 0.19746f
C42594 _634_/a_298_337# VGND 0.24463f
C42595 FILLER_13_228/a_40_246# VGND 0.1615f
C42596 clknet_4_6_0_clk VGND 2.83971f
C42597 _651_/a_2002_114# VGND 0.00329f
C42598 _651_/a_1489_191# VGND 0.09501f
C42599 _651_/a_612_127# VGND 0.03671f
C42600 _651_/a_2250_412# VGND 0.43992f
C42601 _651_/a_1840_334# VGND 0.24738f
C42602 _651_/a_1583_191# VGND 0.54328f
C42603 _651_/a_132_114# VGND 0
C42604 _651_/a_843_236# VGND 0.38455f
C42605 _651_/a_741_93# VGND 0.84825f
C42606 _651_/a_324_432# VGND 1.59712f
C42607 _651_/a_38_114# VGND 0.19486f
C42608 _651_/a_298_337# VGND 0.24629f
C42609 FILLER_16_203/a_32_246# VGND 0.12539f
C42610 clkbuf_4_5_0_clk/a_27_118# VGND 2.41634f
C42611 VPWR VGND 0.33714p
C42612 FILLER_11_144/a_32_246# VGND 0.11896f
C42613 FILLER_20_177/a_32_246# VGND 0.13495f
C42614 net21 VGND 0.59203f
C42615 FILLER_14_185/a_32_246# VGND 0.13479f
C42616 FILLER_17_160/a_40_246# VGND 0.16608f
C42617 _141_ VGND 0.31263f
C42618 _222_ VGND 0.37888f
C42619 net56 VGND 0.62985f
C42620 _403_/a_22_110# VGND 0.23851f
C42621 FILLER_2_237/a_40_246# VGND 0.16155f
C42622 _168_ VGND 1.45204f
C42623 net62 VGND 1.31986f
C42624 _027_ VGND 0.41187f
C42625 _549_/a_257_140# VGND 0.01118f
C42626 _549_/a_155_412# VGND 0.03831f
C42627 baud_inst.counter\[5\] VGND 0.75567f
C42628 _351_/a_46_156# VGND 0.40137f
C42629 _238_ VGND 0.43788f
C42630 _420_/a_350_122# VGND 0.00335f
C42631 _420_/a_248_122# VGND 0.00783f
C42632 _420_/a_146_122# VGND 0.01189f
C42633 _497_/a_170_412# VGND 0
C42634 _704_/a_2002_114# VGND 0.00329f
C42635 _704_/a_1489_191# VGND 0.09495f
C42636 _704_/a_612_127# VGND 0.03671f
C42637 _704_/a_2250_412# VGND 0.43945f
C42638 _704_/a_1840_334# VGND 0.2473f
C42639 _704_/a_1583_191# VGND 0.54244f
C42640 _704_/a_132_114# VGND 0
C42641 _704_/a_843_236# VGND 0.37922f
C42642 _704_/a_741_93# VGND 0.84219f
C42643 _704_/a_324_432# VGND 1.59809f
C42644 _704_/a_38_114# VGND 0.22375f
C42645 _704_/a_298_337# VGND 0.24352f
C42646 _635_/a_2002_114# VGND 0.00329f
C42647 _635_/a_1489_191# VGND 0.09495f
C42648 _635_/a_612_127# VGND 0.03671f
C42649 _635_/a_2250_412# VGND 0.43979f
C42650 _635_/a_1840_334# VGND 0.24727f
C42651 _635_/a_1583_191# VGND 0.54239f
C42652 _635_/a_132_114# VGND 0
C42653 _635_/a_843_236# VGND 0.37921f
C42654 _635_/a_741_93# VGND 0.84477f
C42655 _635_/a_324_432# VGND 1.59851f
C42656 _635_/a_38_114# VGND 0.19858f
C42657 _635_/a_298_337# VGND 0.24377f
C42658 FILLER_3_150/a_40_246# VGND 0.16916f
C42659 _063_ VGND 0.89887f
C42660 _652_/a_2002_114# VGND 0.00329f
C42661 _652_/a_1489_191# VGND 0.09498f
C42662 _652_/a_612_127# VGND 0.03671f
C42663 _652_/a_2250_412# VGND 0.44941f
C42664 _652_/a_1840_334# VGND 0.24734f
C42665 _652_/a_1583_191# VGND 0.54391f
C42666 _652_/a_132_114# VGND 0
C42667 _652_/a_843_236# VGND 0.37943f
C42668 _652_/a_741_93# VGND 0.84733f
C42669 _652_/a_324_432# VGND 1.59688f
C42670 _652_/a_38_114# VGND 0.1934f
C42671 _652_/a_298_337# VGND 0.24249f
C42672 _070_ VGND 0.83436f
C42673 FILLER_17_94/a_40_246# VGND 0.17993f
C42674 FILLER_8_63/a_40_246# VGND 0.16163f
C42675 FILLER_6_191/a_32_246# VGND 0.12105f
C42676 FILLER_20_198/a_40_246# VGND 0.18362f
C42677 _153_ VGND 0.75146f
C42678 net118 VGND 0.43158f
C42679 _169_ VGND 0.90422f
C42680 clkbuf_4_6_0_clk/a_27_118# VGND 2.3683f
C42681 _223_ VGND 1.34082f
C42682 _404_/a_268_412# VGND 0
C42683 _404_/a_46_156# VGND 0.40152f
C42684 FILLER_18_148/a_40_246# VGND 0.16156f
C42685 _185_ VGND 0.55702f
C42686 baud_inst.counter\[6\] VGND 0.93823f
C42687 _352_/a_268_412# VGND 0
C42688 _352_/a_46_156# VGND 0.40208f
C42689 net9 VGND 0.5165f
C42690 tx_data[6] VGND 1.32585f
C42691 input9/a_40_152# VGND 0.42535f
C42692 FILLER_14_72/a_32_246# VGND 0.11891f
C42693 _108_ VGND 0.88461f
C42694 _239_ VGND 0.80254f
C42695 _421_/a_150_412# VGND 0
C42696 net22 VGND 0.66875f
C42697 _705_/a_2002_114# VGND 0.00329f
C42698 _705_/a_1489_191# VGND 0.09495f
C42699 _705_/a_612_127# VGND 0.03671f
C42700 _705_/a_2250_412# VGND 0.43946f
C42701 _705_/a_1840_334# VGND 0.24729f
C42702 _705_/a_1583_191# VGND 0.54298f
C42703 _705_/a_132_114# VGND 0
C42704 _705_/a_843_236# VGND 0.37918f
C42705 _705_/a_741_93# VGND 0.84354f
C42706 _705_/a_324_432# VGND 1.59833f
C42707 _705_/a_38_114# VGND 0.19583f
C42708 _705_/a_298_337# VGND 0.24364f
C42709 _035_ VGND 0.54986f
C42710 net153 VGND 0.42572f
C42711 _498_/a_165_412# VGND 0
C42712 FILLER_5_74/a_32_246# VGND 0.12087f
C42713 _636_/a_2002_114# VGND 0.00329f
C42714 _636_/a_1489_191# VGND 0.09495f
C42715 _636_/a_612_127# VGND 0.03671f
C42716 _636_/a_2250_412# VGND 0.44173f
C42717 _636_/a_1840_334# VGND 0.24797f
C42718 _636_/a_1583_191# VGND 0.54397f
C42719 _636_/a_132_114# VGND 0
C42720 _636_/a_843_236# VGND 0.37954f
C42721 _636_/a_741_93# VGND 0.84332f
C42722 _636_/a_324_432# VGND 1.59715f
C42723 _636_/a_38_114# VGND 0.19333f
C42724 _636_/a_298_337# VGND 0.24246f
C42725 _054_ VGND 0.9422f
C42726 net47 VGND 5.20854f
C42727 FILLER_0_130/a_32_246# VGND 0.1189f
C42728 FILLER_0_163/a_32_246# VGND 0.11886f
C42729 FILLER_0_174/a_32_246# VGND 0.11887f
C42730 _653_/a_2002_114# VGND 0.00329f
C42731 _653_/a_1489_191# VGND 0.09495f
C42732 _653_/a_612_127# VGND 0.03671f
C42733 _653_/a_2250_412# VGND 0.44134f
C42734 _653_/a_1840_334# VGND 0.24741f
C42735 _653_/a_1583_191# VGND 0.54792f
C42736 _653_/a_132_114# VGND 0
C42737 _653_/a_843_236# VGND 0.38021f
C42738 _653_/a_741_93# VGND 0.84626f
C42739 _653_/a_324_432# VGND 1.59656f
C42740 _653_/a_38_114# VGND 0.21592f
C42741 _653_/a_298_337# VGND 0.24243f
C42742 _071_ VGND 0.83061f
C42743 net41 VGND 3.75203f
C42744 FILLER_7_146/a_32_246# VGND 0.13506f
C42745 FILLER_11_142/a_40_246# VGND 0.16608f
C42746 _670_/a_2002_114# VGND 0.00329f
C42747 _670_/a_1489_191# VGND 0.09495f
C42748 _670_/a_612_127# VGND 0.03671f
C42749 _670_/a_2250_412# VGND 0.4397f
C42750 _670_/a_1840_334# VGND 0.24764f
C42751 _670_/a_1583_191# VGND 0.544f
C42752 _670_/a_132_114# VGND 0
C42753 _670_/a_843_236# VGND 0.37982f
C42754 _670_/a_741_93# VGND 0.84754f
C42755 _670_/a_324_432# VGND 1.59733f
C42756 _670_/a_38_114# VGND 0.19413f
C42757 _670_/a_298_337# VGND 0.24247f
C42758 tx_start VGND 0.73475f
C42759 input11/a_40_152# VGND 0.42625f
C42760 _154_ VGND 0.99769f
C42761 net126 VGND 0.51764f
C42762 _224_ VGND 1.14315f
C42763 _405_/a_229_118# VGND 0.00848f
C42764 _405_/a_27_156# VGND 0.43321f
C42765 FILLER_18_158/a_40_246# VGND 0.16155f
C42766 FILLER_18_169/a_40_246# VGND 0.16198f
C42767 net8 VGND 0.54695f
C42768 tx_data[5] VGND 0.69226f
C42769 input8/a_40_152# VGND 0.42523f
C42770 _186_ VGND 0.97543f
C42771 _184_ VGND 0.53838f
C42772 _353_/a_350_122# VGND 0.00271f
C42773 _353_/a_248_122# VGND 0.00779f
C42774 _353_/a_146_122# VGND 0.01187f
C42775 _240_ VGND 1.39115f
C42776 _422_/a_248_122# VGND 0.00713f
C42777 _422_/a_146_122# VGND 0.01189f
C42778 _036_ VGND 0.48133f
C42779 _499_/a_474_130# VGND 0.0076f
C42780 _499_/a_380_412# VGND 0
C42781 _499_/a_177_436# VGND 0
C42782 _499_/a_209_168# VGND 0.39205f
C42783 FILLER_5_84/a_40_246# VGND 0.17239f
C42784 clkbuf_4_7_0_clk/a_27_118# VGND 2.42193f
C42785 _203_ VGND 0.46066f
C42786 _201_ VGND 0.40661f
C42787 _202_ VGND 0.44139f
C42788 _370_/a_154_118# VGND 0.01013f
C42789 _042_ VGND 0.8173f
C42790 _119_ VGND 0.54571f
C42791 _706_/a_2002_114# VGND 0.00329f
C42792 _706_/a_1489_191# VGND 0.09495f
C42793 _706_/a_612_127# VGND 0.03671f
C42794 _706_/a_2250_412# VGND 0.43946f
C42795 _706_/a_1840_334# VGND 0.24755f
C42796 _706_/a_1583_191# VGND 0.54467f
C42797 _706_/a_132_114# VGND 0
C42798 _706_/a_843_236# VGND 0.3795f
C42799 _706_/a_741_93# VGND 0.84833f
C42800 _706_/a_324_432# VGND 1.59781f
C42801 _706_/a_38_114# VGND 0.19552f
C42802 _706_/a_298_337# VGND 0.24332f
C42803 net17 VGND 0.82989f
C42804 net72 VGND 0.34505f
C42805 _048_ VGND 0.9411f
C42806 _637_/a_2002_114# VGND 0.00329f
C42807 _637_/a_1489_191# VGND 0.09496f
C42808 _637_/a_612_127# VGND 0.03692f
C42809 _637_/a_1785_429# VGND 0
C42810 _637_/a_2250_412# VGND 0.44062f
C42811 _637_/a_1840_334# VGND 0.24812f
C42812 _637_/a_1583_191# VGND 0.54418f
C42813 _637_/a_132_114# VGND 0
C42814 _637_/a_681_505# VGND 0
C42815 _637_/a_843_236# VGND 0.3813f
C42816 _637_/a_741_93# VGND 0.84415f
C42817 _637_/a_324_432# VGND 1.59995f
C42818 _637_/a_38_114# VGND 0.20152f
C42819 _637_/a_298_337# VGND 0.24534f
C42820 fanout29/a_40_152# VGND 0.4258f
C42821 tx_inst.data_reg\[0\] VGND 1.94698f
C42822 _144_ VGND 0.4188f
C42823 _065_ VGND 1.1521f
C42824 _654_/a_2002_114# VGND 0.00344f
C42825 _654_/a_1489_191# VGND 0.09635f
C42826 _654_/a_550_127# VGND 0
C42827 _654_/a_612_127# VGND 0.04781f
C42828 _654_/a_1785_429# VGND 0
C42829 _654_/a_2250_412# VGND 0.45256f
C42830 _654_/a_1840_334# VGND 0.24933f
C42831 _654_/a_1583_191# VGND 0.54619f
C42832 _654_/a_132_114# VGND 0
C42833 _654_/a_681_505# VGND 0.00125f
C42834 _654_/a_843_236# VGND 0.38611f
C42835 _654_/a_741_93# VGND 0.85145f
C42836 _654_/a_324_432# VGND 1.63355f
C42837 _654_/a_38_114# VGND 0.21962f
C42838 _654_/a_298_337# VGND 0.25949f
C42839 FILLER_17_81/a_32_246# VGND 0.11886f
C42840 _671_/a_2002_114# VGND 0.00329f
C42841 _671_/a_1489_191# VGND 0.09495f
C42842 _671_/a_612_127# VGND 0.03671f
C42843 _671_/a_2250_412# VGND 0.44361f
C42844 _671_/a_1840_334# VGND 0.24784f
C42845 _671_/a_1583_191# VGND 0.54865f
C42846 _671_/a_132_114# VGND 0
C42847 _671_/a_843_236# VGND 0.3792f
C42848 _671_/a_741_93# VGND 0.84418f
C42849 _671_/a_324_432# VGND 1.5967f
C42850 _671_/a_38_114# VGND 0.19333f
C42851 _671_/a_298_337# VGND 0.24248f
C42852 tx_data[7] VGND 0.57595f
C42853 input10/a_40_152# VGND 0.43523f
C42854 FILLER_15_127/a_32_246# VGND 0.11896f
C42855 FILLER_15_116/a_40_246# VGND 0.1699f
C42856 _406_/a_154_118# VGND 0.00972f
C42857 FILLER_27_135/a_32_246# VGND 0.12689f
C42858 net7 VGND 0.36502f
C42859 tx_data[4] VGND 1.11299f
C42860 input7/a_40_152# VGND 0.42518f
C42861 FILLER_14_70/a_40_246# VGND 0.16214f
C42862 baud_inst.counter\[14\] VGND 1.59723f
C42863 baud_inst.counter\[15\] VGND 0.74645f
C42864 _354_/a_170_412# VGND 0
C42865 _241_ VGND 0.9003f
C42866 _423_/a_165_412# VGND 0
C42867 FILLER_0_161/a_40_246# VGND 0.16147f
C42868 net51 VGND 2.03448f
C42869 _707_/a_2002_114# VGND 0.00329f
C42870 _707_/a_1489_191# VGND 0.09495f
C42871 _707_/a_612_127# VGND 0.03671f
C42872 _707_/a_2250_412# VGND 0.43945f
C42873 _707_/a_1840_334# VGND 0.24725f
C42874 _707_/a_1583_191# VGND 0.54241f
C42875 _707_/a_132_114# VGND 0
C42876 _707_/a_843_236# VGND 0.37922f
C42877 _707_/a_741_93# VGND 0.84214f
C42878 _707_/a_324_432# VGND 1.59828f
C42879 _707_/a_38_114# VGND 0.19607f
C42880 _707_/a_298_337# VGND 0.24365f
C42881 net18 VGND 1.04311f
C42882 net70 VGND 0.38793f
C42883 _638_/a_2002_114# VGND 0.00329f
C42884 _638_/a_1489_191# VGND 0.09495f
C42885 _638_/a_612_127# VGND 0.03671f
C42886 _638_/a_2250_412# VGND 0.43979f
C42887 _638_/a_1840_334# VGND 0.24726f
C42888 _638_/a_1583_191# VGND 0.54235f
C42889 _638_/a_132_114# VGND 0
C42890 _638_/a_843_236# VGND 0.37919f
C42891 _638_/a_741_93# VGND 0.84334f
C42892 _638_/a_324_432# VGND 1.59814f
C42893 _638_/a_38_114# VGND 0.21776f
C42894 _638_/a_298_337# VGND 0.24349f
C42895 _056_ VGND 1.14289f
C42896 _198_ VGND 0.76442f
C42897 _371_/a_170_412# VGND 0
C42898 fanout39/a_40_152# VGND 0.45841f
C42899 fanout28/a_40_152# VGND 0.43465f
C42900 _158_ VGND 1.67086f
C42901 _440_/a_550_140# VGND 0.00157f
C42902 _440_/a_244_140# VGND 0.00159f
C42903 _440_/a_244_412# VGND 0
C42904 _440_/a_142_412# VGND 0
C42905 tx_inst.data_reg\[1\] VGND 1.14023f
C42906 _145_ VGND 0.34775f
C42907 _655_/a_2002_114# VGND 0.00329f
C42908 _655_/a_1489_191# VGND 0.09496f
C42909 _655_/a_612_127# VGND 0.03671f
C42910 _655_/a_2250_412# VGND 0.44018f
C42911 _655_/a_1840_334# VGND 0.24795f
C42912 _655_/a_1583_191# VGND 0.54291f
C42913 _655_/a_132_114# VGND 0
C42914 _655_/a_843_236# VGND 0.38012f
C42915 _655_/a_741_93# VGND 0.84782f
C42916 _655_/a_324_432# VGND 1.5972f
C42917 _655_/a_38_114# VGND 0.19338f
C42918 _655_/a_298_337# VGND 0.24245f
C42919 _074_ VGND 0.88387f
C42920 FILLER_16_221/a_32_246# VGND 0.11886f
C42921 clkbuf_4_8_0_clk/a_27_118# VGND 2.35611f
C42922 baud_inst.counter\[0\] VGND 0.43964f
C42923 clknet_4_0_0_clk VGND 2.98438f
C42924 _672_/a_2002_114# VGND 0.00329f
C42925 _672_/a_1489_191# VGND 0.09593f
C42926 _672_/a_550_127# VGND 0
C42927 _672_/a_612_127# VGND 0.03817f
C42928 _672_/a_1785_429# VGND 0
C42929 _672_/a_2250_412# VGND 0.43974f
C42930 _672_/a_1840_334# VGND 0.24794f
C42931 _672_/a_1583_191# VGND 0.5445f
C42932 _672_/a_132_114# VGND 0
C42933 _672_/a_681_505# VGND 0
C42934 _672_/a_843_236# VGND 0.38379f
C42935 _672_/a_741_93# VGND 0.84786f
C42936 _672_/a_324_432# VGND 1.61157f
C42937 _672_/a_38_114# VGND 0.22222f
C42938 _672_/a_298_337# VGND 0.24868f
C42939 _407_/a_248_122# VGND 0.00716f
C42940 _407_/a_146_122# VGND 0.0119f
C42941 _043_ VGND 1.2225f
C42942 net6 VGND 0.69805f
C42943 tx_data[3] VGND 0.84547f
C42944 input6/a_40_152# VGND 0.42856f
C42945 baud_inst.counter\[19\] VGND 0.81638f
C42946 _355_/a_354_412# VGND 0
C42947 _355_/a_252_412# VGND 0
C42948 _355_/a_150_412# VGND 0
C42949 _139_ VGND 0.70807f
C42950 _424_/a_550_140# VGND 0.00152f
C42951 _424_/a_244_140# VGND 0.00154f
C42952 _424_/a_244_412# VGND 0.00111f
C42953 _424_/a_142_412# VGND 0.00108f
C42954 clknet_4_13_0_clk VGND 2.37705f
C42955 net81 VGND 0.41875f
C42956 _050_ VGND 0.96845f
C42957 _639_/a_2002_114# VGND 0.00329f
C42958 _639_/a_1489_191# VGND 0.09495f
C42959 _639_/a_612_127# VGND 0.03671f
C42960 _639_/a_2250_412# VGND 0.44149f
C42961 _639_/a_1840_334# VGND 0.24785f
C42962 _639_/a_1583_191# VGND 0.54391f
C42963 _639_/a_132_114# VGND 0
C42964 _639_/a_843_236# VGND 0.37967f
C42965 _639_/a_741_93# VGND 0.8421f
C42966 _639_/a_324_432# VGND 1.5967f
C42967 _639_/a_38_114# VGND 0.19333f
C42968 _639_/a_298_337# VGND 0.24249f
C42969 _291_ VGND 0.34136f
C42970 net97 VGND 1.42449f
C42971 net108 VGND 1.28645f
C42972 _510_/a_350_122# VGND 0.0027f
C42973 _510_/a_248_122# VGND 0.00789f
C42974 _510_/a_146_122# VGND 0.01215f
C42975 _372_/a_22_110# VGND 0.23856f
C42976 _441_/a_154_118# VGND 0.00993f
C42977 fanout38/a_40_152# VGND 0.43484f
C42978 fanout27/a_40_152# VGND 0.43904f
C42979 FILLER_12_0/a_32_246# VGND 0.11922f
C42980 net1 VGND 1.345f
C42981 fanout49/a_40_152# VGND 0.44028f
C42982 FILLER_4_102/a_32_246# VGND 0.11978f
C42983 tx_inst.data_reg\[2\] VGND 0.98977f
C42984 clknet_4_4_0_clk VGND 3.11963f
C42985 _067_ VGND 1.05062f
C42986 _656_/a_2002_114# VGND 0.00329f
C42987 _656_/a_1489_191# VGND 0.09495f
C42988 _656_/a_612_127# VGND 0.03671f
C42989 _656_/a_2250_412# VGND 0.44055f
C42990 _656_/a_1840_334# VGND 0.24735f
C42991 _656_/a_1583_191# VGND 0.54275f
C42992 _656_/a_132_114# VGND 0
C42993 _656_/a_843_236# VGND 0.37921f
C42994 _656_/a_741_93# VGND 0.84585f
C42995 _656_/a_324_432# VGND 1.59655f
C42996 _656_/a_38_114# VGND 0.19652f
C42997 _656_/a_298_337# VGND 0.24249f
C42998 FILLER_8_92/a_32_246# VGND 0.11886f
C42999 FILLER_8_70/a_32_246# VGND 0.11899f
C43000 FILLER_27_46/a_32_246# VGND 0.12364f
C43001 FILLER_7_176/a_32_246# VGND 0.1191f
C43002 FILLER_7_121/a_40_246# VGND 0.16856f
C43003 clknet_4_1_0_clk VGND 3.33502f
C43004 _673_/a_2002_114# VGND 0.00342f
C43005 _673_/a_1489_191# VGND 0.09495f
C43006 _673_/a_612_127# VGND 0.03671f
C43007 _673_/a_2250_412# VGND 0.4417f
C43008 _673_/a_1840_334# VGND 0.24846f
C43009 _673_/a_1583_191# VGND 0.54461f
C43010 _673_/a_132_114# VGND 0
C43011 _673_/a_843_236# VGND 0.37961f
C43012 _673_/a_741_93# VGND 0.84483f
C43013 _673_/a_324_432# VGND 1.59684f
C43014 _673_/a_38_114# VGND 0.19338f
C43015 _673_/a_298_337# VGND 0.24245f
C43016 FILLER_12_106/a_40_246# VGND 0.17934f
C43017 FILLER_12_117/a_40_246# VGND 0.16148f
C43018 FILLER_12_128/a_40_246# VGND 0.16182f
C43019 clkbuf_4_9_0_clk/a_27_118# VGND 2.38097f
C43020 clknet_4_8_0_clk VGND 2.66141f
C43021 _103_ VGND 0.86469f
C43022 _690_/a_2002_114# VGND 0.00329f
C43023 _690_/a_1489_191# VGND 0.09495f
C43024 _690_/a_612_127# VGND 0.03671f
C43025 _690_/a_2250_412# VGND 0.44663f
C43026 _690_/a_1840_334# VGND 0.24765f
C43027 _690_/a_1583_191# VGND 0.55086f
C43028 _690_/a_132_114# VGND 0
C43029 _690_/a_843_236# VGND 0.37953f
C43030 _690_/a_741_93# VGND 0.84214f
C43031 _690_/a_324_432# VGND 1.5967f
C43032 _690_/a_38_114# VGND 0.19378f
C43033 _690_/a_298_337# VGND 0.24246f
C43034 _172_ VGND 0.76984f
C43035 _339_/a_1023_118# VGND 0
C43036 _339_/a_810_118# VGND 0.0044f
C43037 _339_/a_500_118# VGND 0.00643f
C43038 _339_/a_308_118# VGND 0.00361f
C43039 _339_/a_1377_160# VGND 0.29391f
C43040 _339_/a_1109_431# VGND 0
C43041 _339_/a_886_118# VGND 0.69217f
C43042 _339_/a_589_385# VGND 0
C43043 _339_/a_382_118# VGND 0.0254f
C43044 _339_/a_295_385# VGND 0
C43045 _339_/a_805_385# VGND 0
C43046 _339_/a_1453_124# VGND 0.35834f
C43047 _339_/a_71_118# VGND 1.10654f
C43048 net180 VGND 0.41556f
C43049 _408_/a_154_118# VGND 0.0096f
C43050 tx_data[2] VGND 1.26022f
C43051 input5/a_40_152# VGND 0.42554f
C43052 baud_inst.counter\[13\] VGND 1.19349f
C43053 _187_ VGND 0.51293f
C43054 _188_ VGND 0.86485f
C43055 _356_/a_350_122# VGND 0.00288f
C43056 _356_/a_248_122# VGND 0.00793f
C43057 _356_/a_146_122# VGND 0.01221f
C43058 _242_ VGND 1.51811f
C43059 _425_/a_268_412# VGND 0
C43060 _425_/a_46_156# VGND 0.40789f
C43061 FILLER_1_28/a_40_246# VGND 0.18159f
C43062 _511_/a_150_412# VGND 0
C43063 _205_ VGND 1.21434f
C43064 _373_/a_170_412# VGND 0
C43065 _255_ VGND 0.48524f
C43066 _442_/a_350_122# VGND 0.00274f
C43067 _442_/a_248_122# VGND 0.00781f
C43068 _442_/a_146_122# VGND 0.01188f
C43069 fanout37/a_40_152# VGND 0.45838f
C43070 fanout26/a_40_152# VGND 0.4252f
C43071 fanout48/a_40_152# VGND 0.44121f
C43072 tx_inst.data_reg\[3\] VGND 0.8073f
C43073 _147_ VGND 0.43807f
C43074 _068_ VGND 0.9307f
C43075 _657_/a_2002_114# VGND 0.00339f
C43076 _657_/a_1489_191# VGND 0.0957f
C43077 _657_/a_550_127# VGND 0
C43078 _657_/a_612_127# VGND 0.03754f
C43079 _657_/a_1785_429# VGND 0
C43080 _657_/a_2250_412# VGND 0.45006f
C43081 _657_/a_1840_334# VGND 0.24913f
C43082 _657_/a_1583_191# VGND 0.5466f
C43083 _657_/a_132_114# VGND 0
C43084 _657_/a_681_505# VGND 0
C43085 _657_/a_843_236# VGND 0.38264f
C43086 _657_/a_741_93# VGND 0.84846f
C43087 _657_/a_324_432# VGND 1.60175f
C43088 _657_/a_38_114# VGND 0.21859f
C43089 _657_/a_298_337# VGND 0.2442f
C43090 _076_ VGND 1.12937f
C43091 net159 VGND 0.40643f
C43092 _390_/a_496_118# VGND 0.00142f
C43093 _390_/a_285_118# VGND 0
C43094 _390_/a_382_118# VGND 0.71859f
C43095 _390_/a_59_156# VGND 0.42841f
C43096 hold109/a_438_182# VGND 0.37902f
C43097 hold109/a_326_118# VGND 0.32143f
C43098 hold109/a_56_118# VGND 0.51883f
C43099 baud_inst.counter\[2\] VGND 0.44781f
C43100 _030_ VGND 0.68665f
C43101 _674_/a_2002_114# VGND 0.00351f
C43102 _674_/a_1489_191# VGND 0.10474f
C43103 _674_/a_550_127# VGND 0
C43104 _674_/a_612_127# VGND 0.03864f
C43105 _674_/a_1785_429# VGND 0
C43106 _674_/a_2250_412# VGND 0.44333f
C43107 _674_/a_1840_334# VGND 0.25064f
C43108 _674_/a_1583_191# VGND 0.55485f
C43109 _674_/a_132_114# VGND 0
C43110 _674_/a_681_505# VGND 0
C43111 _674_/a_843_236# VGND 0.39646f
C43112 _674_/a_741_93# VGND 0.87376f
C43113 _674_/a_324_432# VGND 1.63176f
C43114 _674_/a_38_114# VGND 0.19772f
C43115 _674_/a_298_337# VGND 0.24465f
C43116 _691_/a_2002_114# VGND 0.00329f
C43117 _691_/a_1489_191# VGND 0.09495f
C43118 _691_/a_612_127# VGND 0.03671f
C43119 _691_/a_2250_412# VGND 0.44624f
C43120 _691_/a_1840_334# VGND 0.24741f
C43121 _691_/a_1583_191# VGND 0.5445f
C43122 _691_/a_132_114# VGND 0
C43123 _691_/a_843_236# VGND 0.38023f
C43124 _691_/a_741_93# VGND 0.84714f
C43125 _691_/a_324_432# VGND 1.59669f
C43126 _691_/a_38_114# VGND 0.21847f
C43127 _691_/a_298_337# VGND 0.24249f
C43128 FILLER_2_81/a_32_246# VGND 0.11888f
C43129 _409_/a_73_118# VGND 0.68753f
C43130 FILLER_25_9/a_32_246# VGND 0.12017f
C43131 FILLER_10_14/a_40_246# VGND 0.18239f
C43132 net4 VGND 0.48328f
C43133 tx_data[1] VGND 1.44527f
C43134 input4/a_40_152# VGND 0.44265f
C43135 _190_ VGND 0.80922f
C43136 _189_ VGND 0.65616f
C43137 _180_ VGND 1.12709f
C43138 _357_/a_150_412# VGND 0
C43139 _243_ VGND 0.40521f
C43140 _426_/a_154_118# VGND 0.00987f
C43141 _010_ VGND 0.5779f
C43142 _292_ VGND 2.48636f
C43143 net109 VGND 0.62121f
C43144 _512_/a_279_412# VGND 0.00441f
C43145 _512_/a_165_412# VGND 0.00424f
C43146 _204_ VGND 0.33813f
C43147 _374_/a_550_140# VGND 0.00145f
C43148 _374_/a_244_140# VGND 0.00145f
C43149 _256_ VGND 0.89678f
C43150 _254_ VGND 0.45121f
C43151 _443_/a_354_412# VGND 0
C43152 _443_/a_252_412# VGND 0
C43153 _443_/a_150_412# VGND 0
C43154 FILLER_13_68/a_40_246# VGND 0.16163f
C43155 fanout25/a_40_152# VGND 0.44305f
C43156 fanout36/a_40_152# VGND 0.43484f
C43157 fanout47/a_40_152# VGND 0.43366f
C43158 _077_ VGND 0.93215f
C43159 FILLER_4_100/a_40_246# VGND 0.18495f
C43160 _069_ VGND 0.94139f
C43161 _658_/a_2002_114# VGND 0.00329f
C43162 _658_/a_1489_191# VGND 0.09495f
C43163 _658_/a_612_127# VGND 0.03671f
C43164 _658_/a_2250_412# VGND 0.44854f
C43165 _658_/a_1840_334# VGND 0.24774f
C43166 _658_/a_1583_191# VGND 0.54496f
C43167 _658_/a_132_114# VGND 0
C43168 _658_/a_843_236# VGND 0.3805f
C43169 _658_/a_741_93# VGND 0.84897f
C43170 _658_/a_324_432# VGND 1.59738f
C43171 _658_/a_38_114# VGND 0.19882f
C43172 _658_/a_298_337# VGND 0.24323f
C43173 _214_ VGND 0.54813f
C43174 net54 VGND 1.62897f
C43175 _391_/a_268_412# VGND 0
C43176 _391_/a_46_156# VGND 0.40145f
C43177 _129_ VGND 0.25756f
C43178 _265_ VGND 0.42056f
C43179 _460_/a_22_110# VGND 0.28553f
C43180 _460_/a_120_432# VGND 0
C43181 hold108/a_438_182# VGND 0.37614f
C43182 hold108/a_326_118# VGND 0.31748f
C43183 hold108/a_56_118# VGND 0.51683f
C43184 hold119/a_438_182# VGND 0.38097f
C43185 hold119/a_326_118# VGND 0.32363f
C43186 hold119/a_56_118# VGND 0.48113f
C43187 FILLER_26_229/a_32_246# VGND 0.11918f
C43188 baud_inst.counter\[3\] VGND 0.40833f
C43189 _675_/a_2002_114# VGND 0.00489f
C43190 _675_/a_1489_191# VGND 0.09681f
C43191 _675_/a_612_127# VGND 0.03671f
C43192 _675_/a_1785_429# VGND 0
C43193 _675_/a_2250_412# VGND 0.46539f
C43194 _675_/a_1840_334# VGND 0.26884f
C43195 _675_/a_1583_191# VGND 0.56454f
C43196 _675_/a_132_114# VGND 0
C43197 _675_/a_843_236# VGND 0.38286f
C43198 _675_/a_741_93# VGND 0.85003f
C43199 _675_/a_324_432# VGND 1.6f
C43200 _675_/a_38_114# VGND 0.1941f
C43201 _675_/a_298_337# VGND 0.24246f
C43202 FILLER_16_56/a_32_246# VGND 0.1193f
C43203 clknet_4_10_0_clk VGND 2.77898f
C43204 net164 VGND 0.49142f
C43205 _692_/a_2002_114# VGND 0.00329f
C43206 _692_/a_1489_191# VGND 0.09495f
C43207 _692_/a_612_127# VGND 0.03671f
C43208 _692_/a_2250_412# VGND 0.44044f
C43209 _692_/a_1840_334# VGND 0.24731f
C43210 _692_/a_1583_191# VGND 0.54245f
C43211 _692_/a_132_114# VGND 0
C43212 _692_/a_843_236# VGND 0.37993f
C43213 _692_/a_741_93# VGND 0.84556f
C43214 _692_/a_324_432# VGND 1.59655f
C43215 _692_/a_38_114# VGND 0.194f
C43216 _692_/a_298_337# VGND 0.24248f
C43217 FILLER_24_156/a_32_246# VGND 0.11946f
C43218 FILLER_19_55/a_40_246# VGND 0.18628f
C43219 FILLER_19_77/a_32_246# VGND 0.11886f
C43220 net3 VGND 0.8982f
C43221 tx_data[0] VGND 1.62501f
C43222 input3/a_40_152# VGND 0.425f
C43223 FILLER_6_205/a_40_246# VGND 0.16458f
C43224 _191_ VGND 1.23818f
C43225 _358_/a_166_436# VGND 0
C43226 _358_/a_72_436# VGND 0.62233f
C43227 _244_ VGND 0.40529f
C43228 _427_/a_350_122# VGND 0.00286f
C43229 _427_/a_248_122# VGND 0.00796f
C43230 _427_/a_146_122# VGND 0.01227f
C43231 _375_/a_170_412# VGND 0
C43232 _011_ VGND 0.26049f
C43233 _163_ VGND 1.19557f
C43234 _513_/a_341_118# VGND 0.13981f
C43235 _513_/a_155_160# VGND 0.00115f
C43236 _513_/a_435_412# VGND 0
C43237 _513_/a_192_429# VGND 0.47876f
C43238 _134_ VGND 0.8933f
C43239 _159_ VGND 1.02852f
C43240 _444_/a_550_140# VGND 0.00169f
C43241 _444_/a_244_140# VGND 0.00161f
C43242 _444_/a_244_412# VGND 0.00156f
C43243 _444_/a_142_412# VGND 0.00183f
C43244 FILLER_13_89/a_40_246# VGND 0.16147f
C43245 fanout35/a_40_152# VGND 0.45266f
C43246 fanout24/a_40_152# VGND 0.45559f
C43247 fanout46/a_40_152# VGND 0.44317f
C43248 tx_inst.data_reg\[5\] VGND 0.74307f
C43249 _659_/a_2002_114# VGND 0.0034f
C43250 _659_/a_1489_191# VGND 0.09573f
C43251 _659_/a_612_127# VGND 0.03775f
C43252 _659_/a_1785_429# VGND 0
C43253 _659_/a_2250_412# VGND 0.44279f
C43254 _659_/a_1840_334# VGND 0.25077f
C43255 _659_/a_1583_191# VGND 0.54701f
C43256 _659_/a_132_114# VGND 0
C43257 _659_/a_681_505# VGND 0
C43258 _659_/a_843_236# VGND 0.3855f
C43259 _659_/a_741_93# VGND 0.85042f
C43260 _659_/a_324_432# VGND 1.60301f
C43261 _659_/a_38_114# VGND 0.20003f
C43262 _659_/a_298_337# VGND 0.24698f
C43263 _392_/a_496_118# VGND 0.00195f
C43264 _392_/a_285_118# VGND 0
C43265 _392_/a_559_412# VGND 0
C43266 _392_/a_285_412# VGND 0
C43267 _392_/a_382_118# VGND 0.72679f
C43268 _392_/a_59_156# VGND 0.39985f
C43269 _018_ VGND 0.29587f
C43270 _164_ VGND 0.41497f
C43271 _302_ VGND 2.48822f
C43272 _530_/a_257_140# VGND 0.01118f
C43273 _530_/a_155_412# VGND 0.03831f
C43274 _461_/a_22_110# VGND 0.25488f
C43275 _461_/a_120_432# VGND 0.00113f
C43276 hold129/a_438_182# VGND 0.37565f
C43277 hold129/a_326_118# VGND 0.3169f
C43278 hold129/a_56_118# VGND 0.51243f
C43279 hold118/a_438_182# VGND 0.3773f
C43280 hold118/a_326_118# VGND 0.31827f
C43281 hold118/a_56_118# VGND 0.48257f
C43282 hold107/a_438_182# VGND 0.39521f
C43283 hold107/a_326_118# VGND 0.34016f
C43284 hold107/a_56_118# VGND 0.48837f
C43285 _034_ VGND 0.62759f
C43286 _676_/a_2002_114# VGND 0.00329f
C43287 _676_/a_1489_191# VGND 0.09495f
C43288 _676_/a_612_127# VGND 0.03671f
C43289 _676_/a_2250_412# VGND 0.4404f
C43290 _676_/a_1840_334# VGND 0.24734f
C43291 _676_/a_1583_191# VGND 0.54244f
C43292 _676_/a_132_114# VGND 0
C43293 _676_/a_843_236# VGND 0.37922f
C43294 _676_/a_741_93# VGND 0.84462f
C43295 _676_/a_324_432# VGND 1.59732f
C43296 _676_/a_38_114# VGND 0.19353f
C43297 _676_/a_298_337# VGND 0.24243f
C43298 FILLER_8_118/a_32_246# VGND 0.11956f
C43299 FILLER_21_147/a_40_246# VGND 0.17989f
C43300 FILLER_21_33/a_32_246# VGND 0.11953f
C43301 net149 VGND 0.42679f
C43302 _693_/a_2002_114# VGND 0.00329f
C43303 _693_/a_1489_191# VGND 0.09497f
C43304 _693_/a_612_127# VGND 0.03671f
C43305 _693_/a_2250_412# VGND 0.44134f
C43306 _693_/a_1840_334# VGND 0.24725f
C43307 _693_/a_1583_191# VGND 0.54307f
C43308 _693_/a_132_114# VGND 0
C43309 _693_/a_843_236# VGND 0.37923f
C43310 _693_/a_741_93# VGND 0.84399f
C43311 _693_/a_324_432# VGND 1.59658f
C43312 _693_/a_38_114# VGND 0.21592f
C43313 _693_/a_298_337# VGND 0.24245f
C43314 FILLER_24_133/a_32_246# VGND 0.13515f
C43315 FILLER_25_7/a_40_246# VGND 0.18262f
C43316 FILLER_10_78/a_32_246# VGND 0.11974f
C43317 FILLER_3_207/a_40_246# VGND 0.16381f
C43318 net2 VGND 1.73061f
C43319 rx VGND 0.49237f
C43320 input2/a_40_152# VGND 0.42613f
C43321 _192_ VGND 0.40106f
C43322 net27 VGND 3.34517f
C43323 _176_ VGND 0.35777f
C43324 _359_/a_22_110# VGND 0.27101f
C43325 _359_/a_120_432# VGND 0
C43326 _245_ VGND 0.8627f
C43327 _428_/a_354_412# VGND 0
C43328 _428_/a_252_412# VGND 0
C43329 _428_/a_150_412# VGND 0
C43330 FILLER_10_222/a_32_246# VGND 0.11886f
C43331 _376_/a_272_160# VGND 0.00362f
C43332 _376_/a_170_160# VGND 0.00108f
C43333 _376_/a_76_160# VGND 0.36269f
C43334 _257_ VGND 1.04913f
C43335 _445_/a_165_412# VGND 0
C43336 fanout34/a_40_152# VGND 0.42537f
C43337 _293_ VGND 0.31475f
C43338 _514_/a_257_140# VGND 0.01118f
C43339 _514_/a_155_412# VGND 0.03831f
C43340 fanout45/a_40_152# VGND 0.43411f
C43341 net50 VGND 1.18236f
C43342 net146 VGND 0.78902f
C43343 _393_/a_170_412# VGND 0
C43344 _089_ VGND 1.01902f
C43345 _020_ VGND 0.52622f
C43346 net163 VGND 1.20451f
C43347 _531_/a_474_130# VGND 0.0076f
C43348 _531_/a_380_412# VGND 0
C43349 _531_/a_177_436# VGND 0
C43350 _531_/a_209_168# VGND 0.38958f
C43351 _128_ VGND 0.29435f
C43352 _267_ VGND 0.3784f
C43353 _462_/a_22_110# VGND 0.24049f
C43354 _462_/a_120_432# VGND 0
C43355 FILLER_26_227/a_40_246# VGND 0.16301f
C43356 net154 VGND 0.36588f
C43357 _677_/a_2002_114# VGND 0.00329f
C43358 _677_/a_1489_191# VGND 0.09495f
C43359 _677_/a_612_127# VGND 0.03671f
C43360 _677_/a_2250_412# VGND 0.44327f
C43361 _677_/a_1840_334# VGND 0.24816f
C43362 _677_/a_1583_191# VGND 0.54885f
C43363 _677_/a_132_114# VGND 0
C43364 _677_/a_843_236# VGND 0.37983f
C43365 _677_/a_741_93# VGND 0.84588f
C43366 _677_/a_324_432# VGND 1.59655f
C43367 _677_/a_38_114# VGND 0.19447f
C43368 _677_/a_298_337# VGND 0.24247f
C43369 hold117/a_438_182# VGND 0.37612f
C43370 hold117/a_326_118# VGND 0.31856f
C43371 hold117/a_56_118# VGND 0.50118f
C43372 hold128/a_438_182# VGND 0.37571f
C43373 hold128/a_326_118# VGND 0.31689f
C43374 hold128/a_56_118# VGND 0.49275f
C43375 hold139/a_438_182# VGND 0.37554f
C43376 hold139/a_326_118# VGND 0.31692f
C43377 hold139/a_56_118# VGND 0.48124f
C43378 hold106/a_438_182# VGND 0.37962f
C43379 hold106/a_326_118# VGND 0.3221f
C43380 hold106/a_56_118# VGND 0.48596f
C43381 _107_ VGND 0.966f
C43382 _694_/a_2002_114# VGND 0.00489f
C43383 _694_/a_1489_191# VGND 0.104f
C43384 _694_/a_612_127# VGND 0.03686f
C43385 _694_/a_1785_429# VGND 0.00331f
C43386 _694_/a_2250_412# VGND 0.45427f
C43387 _694_/a_1840_334# VGND 0.27176f
C43388 _694_/a_1583_191# VGND 0.56946f
C43389 _694_/a_132_114# VGND 0
C43390 _694_/a_843_236# VGND 0.38605f
C43391 _694_/a_741_93# VGND 0.85016f
C43392 _694_/a_324_432# VGND 1.60489f
C43393 _694_/a_38_114# VGND 0.20204f
C43394 _694_/a_298_337# VGND 0.24338f
C43395 FILLER_19_75/a_40_246# VGND 0.16147f
C43396 FILLER_19_118/a_32_246# VGND 0.12469f
C43397 rst VGND 0.81217f
C43398 input1/a_40_152# VGND 0.43674f
C43399 _429_/a_550_140# VGND 0.00156f
C43400 _429_/a_244_140# VGND 0.00161f
C43401 _429_/a_244_412# VGND 0.00117f
C43402 _429_/a_142_412# VGND 0
C43403 _207_ VGND 0.45596f
C43404 net10 VGND 0.36554f
C43405 net55 VGND 3.66695f
C43406 _377_/a_268_412# VGND 0
C43407 _377_/a_46_156# VGND 0.40152f
C43408 _515_/a_272_160# VGND 0.00339f
C43409 _515_/a_170_160# VGND 0
C43410 _515_/a_76_160# VGND 0.3549f
C43411 _258_ VGND 0.44711f
C43412 _446_/a_248_122# VGND 0.00713f
C43413 _446_/a_146_122# VGND 0.01189f
C43414 net33 VGND 0.72535f
C43415 fanout33/a_40_152# VGND 0.44119f
C43416 fanout44/a_40_152# VGND 0.42558f
C43417 _394_/a_22_110# VGND 0.30825f
C43418 _394_/a_120_432# VGND 0.00642f
C43419 _303_ VGND 0.35306f
C43420 _532_/a_257_140# VGND 0.01118f
C43421 _532_/a_155_412# VGND 0.03931f
C43422 _268_ VGND 0.34155f
C43423 net71 VGND 0.71884f
C43424 _463_/a_22_110# VGND 0.28614f
C43425 _463_/a_120_432# VGND 0.00148f
C43426 _090_ VGND 0.86185f
C43427 net39 VGND 4.62919f
C43428 hold116/a_438_182# VGND 0.39017f
C43429 hold116/a_326_118# VGND 0.32151f
C43430 hold116/a_56_118# VGND 0.48811f
C43431 net93 VGND 0.38826f
C43432 _678_/a_2002_114# VGND 0.00329f
C43433 _678_/a_1489_191# VGND 0.09495f
C43434 _678_/a_612_127# VGND 0.03682f
C43435 _678_/a_1785_429# VGND 0
C43436 _678_/a_2250_412# VGND 0.44899f
C43437 _678_/a_1840_334# VGND 0.24882f
C43438 _678_/a_1583_191# VGND 0.54465f
C43439 _678_/a_132_114# VGND 0
C43440 _678_/a_681_505# VGND 0
C43441 _678_/a_843_236# VGND 0.38136f
C43442 _678_/a_741_93# VGND 0.8469f
C43443 _678_/a_324_432# VGND 1.59768f
C43444 _678_/a_38_114# VGND 0.20219f
C43445 _678_/a_298_337# VGND 0.2436f
C43446 net138 VGND 0.47632f
C43447 rx_inst.data_reg\[4\] VGND 0.3905f
C43448 hold138/a_438_182# VGND 0.37601f
C43449 hold138/a_326_118# VGND 0.31682f
C43450 hold138/a_56_118# VGND 0.48104f
C43451 hold149/a_438_182# VGND 0.3777f
C43452 hold149/a_326_118# VGND 0.31916f
C43453 hold149/a_56_118# VGND 0.48723f
C43454 hold127/a_438_182# VGND 0.37667f
C43455 hold127/a_326_118# VGND 0.3199f
C43456 hold127/a_56_118# VGND 0.5029f
C43457 hold105/a_438_182# VGND 0.37769f
C43458 hold105/a_326_118# VGND 0.31954f
C43459 hold105/a_56_118# VGND 0.50178f
C43460 FILLER_8_116/a_40_246# VGND 0.17986f
C43461 _480_/a_22_110# VGND 0.23942f
C43462 FILLER_21_31/a_40_246# VGND 0.16381f
C43463 net76 VGND 0.40262f
C43464 _695_/a_2002_114# VGND 0.00345f
C43465 _695_/a_1489_191# VGND 0.09629f
C43466 _695_/a_550_127# VGND 0
C43467 _695_/a_612_127# VGND 0.04862f
C43468 _695_/a_1785_429# VGND 0
C43469 _695_/a_2250_412# VGND 0.4508f
C43470 _695_/a_1840_334# VGND 0.24989f
C43471 _695_/a_1583_191# VGND 0.54951f
C43472 _695_/a_132_114# VGND 0
C43473 _695_/a_681_505# VGND 0
C43474 _695_/a_843_236# VGND 0.39567f
C43475 _695_/a_741_93# VGND 0.85684f
C43476 _695_/a_324_432# VGND 1.6308f
C43477 _695_/a_38_114# VGND 0.22406f
C43478 _695_/a_298_337# VGND 0.26f
C43479 FILLER_19_139/a_40_246# VGND 0.16153f
C43480 FILLER_27_194/a_40_246# VGND 0.16346f
C43481 FILLER_1_67/a_40_246# VGND 0.16639f
C43482 _151_ VGND 0.28372f
C43483 net155 VGND 0.59897f
C43484 _206_ VGND 5.68662f
C43485 _378_/a_496_118# VGND 0.00142f
C43486 _378_/a_285_118# VGND 0
C43487 _378_/a_382_118# VGND 0.71385f
C43488 _378_/a_59_156# VGND 0.41184f
C43489 _012_ VGND 0.61121f
C43490 _294_ VGND 1.40823f
C43491 net129 VGND 0.36741f
C43492 _516_/a_165_412# VGND 0
C43493 _259_ VGND 0.40739f
C43494 _447_/a_379_118# VGND 0.01295f
C43495 _447_/a_277_118# VGND 0.00844f
C43496 _447_/a_175_118# VGND 0.00698f
C43497 _447_/a_81_118# VGND 0.43577f
C43498 net49 VGND 3.86125f
C43499 fanout43/a_40_152# VGND 0.4261f
C43500 net32 VGND 3.19514f
C43501 fanout32/a_40_152# VGND 0.42554f
C43502 _215_ VGND 0.85701f
C43503 _395_/a_248_122# VGND 0.00742f
C43504 _395_/a_146_122# VGND 0.01216f
C43505 _091_ VGND 0.95291f
C43506 _304_ VGND 0.80937f
C43507 net147 VGND 0.73843f
C43508 _533_/a_248_122# VGND 0.00713f
C43509 _533_/a_146_122# VGND 0.01188f
C43510 _127_ VGND 0.37672f
C43511 _464_/a_22_110# VGND 0.24073f
C43512 _464_/a_120_432# VGND 0.00103f
C43513 hold137/a_438_182# VGND 0.37786f
C43514 hold137/a_326_118# VGND 0.31838f
C43515 hold137/a_56_118# VGND 0.51751f
C43516 baud_inst.counter\[7\] VGND 0.68959f
C43517 clknet_4_3_0_clk VGND 2.73943f
C43518 net96 VGND 0.30389f
C43519 _679_/a_2002_114# VGND 0.00339f
C43520 _679_/a_1489_191# VGND 0.0957f
C43521 _679_/a_550_127# VGND 0
C43522 _679_/a_612_127# VGND 0.03745f
C43523 _679_/a_1785_429# VGND 0
C43524 _679_/a_2250_412# VGND 0.44291f
C43525 _679_/a_1840_334# VGND 0.2488f
C43526 _679_/a_1583_191# VGND 0.5466f
C43527 _679_/a_132_114# VGND 0
C43528 _679_/a_681_505# VGND 0
C43529 _679_/a_843_236# VGND 0.38121f
C43530 _679_/a_741_93# VGND 0.84932f
C43531 _679_/a_324_432# VGND 1.60035f
C43532 _679_/a_38_114# VGND 0.19719f
C43533 _679_/a_298_337# VGND 0.24399f
C43534 hold115/a_438_182# VGND 0.3821f
C43535 hold115/a_326_118# VGND 0.32542f
C43536 hold115/a_56_118# VGND 0.5018f
C43537 hold159/a_438_182# VGND 0.37815f
C43538 hold159/a_326_118# VGND 0.31693f
C43539 hold159/a_56_118# VGND 0.51688f
C43540 net104 VGND 0.48754f
C43541 hold104/a_438_182# VGND 0.37599f
C43542 hold104/a_326_118# VGND 0.31678f
C43543 hold104/a_56_118# VGND 0.48504f
C43544 hold148/a_438_182# VGND 0.3764f
C43545 hold148/a_326_118# VGND 0.31678f
C43546 hold148/a_56_118# VGND 0.48326f
C43547 hold126/a_438_182# VGND 0.38034f
C43548 hold126/a_326_118# VGND 0.32319f
C43549 hold126/a_56_118# VGND 0.48502f
C43550 _276_ VGND 0.45045f
C43551 net26 VGND 3.61358f
C43552 _171_ VGND 1.43384f
C43553 _481_/a_22_110# VGND 0.25569f
C43554 _481_/a_120_432# VGND 0
C43555 FILLER_12_166/a_40_246# VGND 0.16809f
C43556 _028_ VGND 0.82456f
C43557 net133 VGND 1.10065f
C43558 _550_/a_474_130# VGND 0.00777f
C43559 _550_/a_380_412# VGND 0.00246f
C43560 _550_/a_177_436# VGND 0.00119f
C43561 _550_/a_209_168# VGND 0.39309f
C43562 FILLER_15_185/a_32_246# VGND 0.11886f
C43563 _024_ VGND 0.39883f
C43564 _696_/a_2002_114# VGND 0.00329f
C43565 _696_/a_1489_191# VGND 0.09495f
C43566 _696_/a_612_127# VGND 0.03671f
C43567 _696_/a_2250_412# VGND 0.43961f
C43568 _696_/a_1840_334# VGND 0.24729f
C43569 _696_/a_1583_191# VGND 0.5431f
C43570 _696_/a_132_114# VGND 0
C43571 _696_/a_843_236# VGND 0.38022f
C43572 _696_/a_741_93# VGND 0.84291f
C43573 _696_/a_324_432# VGND 1.5967f
C43574 _696_/a_38_114# VGND 0.19399f
C43575 _696_/a_298_337# VGND 0.24244f
C43576 rx_data[7] VGND 0.39561f
C43577 output19/a_40_152# VGND 0.42725f
C43578 FILLER_21_96/a_40_246# VGND 0.16156f
C43579 FILLER_18_160/a_32_246# VGND 0.11901f
C43580 FILLER_19_149/a_40_246# VGND 0.16161f
C43581 _379_/a_46_156# VGND 0.4013f
C43582 _013_ VGND 0.48796f
C43583 _517_/a_474_130# VGND 0.0076f
C43584 _517_/a_380_412# VGND 0
C43585 _517_/a_177_436# VGND 0
C43586 _517_/a_209_168# VGND 0.38862f
C43587 _133_ VGND 0.73865f
C43588 _232_ VGND 2.26247f
C43589 _160_ VGND 0.9878f
C43590 _448_/a_550_140# VGND 0.00145f
C43591 _448_/a_244_140# VGND 0.00145f
C43592 _448_/a_244_412# VGND 0
C43593 _448_/a_142_412# VGND 0
C43594 fanout42/a_40_152# VGND 0.42834f
C43595 fanout31/a_40_152# VGND 0.44f
C43596 FILLER_4_183/a_40_246# VGND 0.16164f
C43597 FILLER_4_172/a_32_246# VGND 0.11996f
C43598 _396_/a_257_140# VGND 0.0112f
C43599 _396_/a_155_412# VGND 0.03903f
C43600 _092_ VGND 0.8384f
C43601 _269_ VGND 0.33821f
C43602 net73 VGND 0.39474f
C43603 _465_/a_22_110# VGND 0.28439f
C43604 _021_ VGND 0.6593f
C43605 net148 VGND 0.51149f
C43606 _534_/a_46_156# VGND 0.4013f
C43607 hold169/a_438_182# VGND 0.37561f
C43608 hold169/a_326_118# VGND 0.31811f
C43609 hold169/a_56_118# VGND 0.48176f
C43610 net136 VGND 0.51421f
C43611 hold136/a_438_182# VGND 0.38568f
C43612 hold136/a_326_118# VGND 0.33642f
C43613 hold136/a_56_118# VGND 0.53271f
C43614 hold158/a_438_182# VGND 0.37554f
C43615 hold158/a_326_118# VGND 0.3171f
C43616 hold158/a_56_118# VGND 0.48169f
C43617 hold103/a_438_182# VGND 0.41857f
C43618 hold103/a_326_118# VGND 0.35408f
C43619 hold103/a_56_118# VGND 0.49127f
C43620 hold147/a_438_182# VGND 0.37553f
C43621 hold147/a_326_118# VGND 0.31689f
C43622 hold147/a_56_118# VGND 0.48652f
C43623 hold114/a_438_182# VGND 0.38541f
C43624 hold114/a_326_118# VGND 0.31914f
C43625 hold114/a_56_118# VGND 0.51193f
C43626 net125 VGND 0.31694f
C43627 _138_ VGND 0.88751f
C43628 hold125/a_438_182# VGND 0.37573f
C43629 hold125/a_326_118# VGND 0.31703f
C43630 hold125/a_56_118# VGND 0.52262f
C43631 _234_ VGND 1.06643f
C43632 _482_/a_154_118# VGND 0.00973f
C43633 _109_ VGND 0.98986f
C43634 FILLER_21_165/a_40_246# VGND 0.17058f
C43635 _314_ VGND 1.34888f
C43636 net105 VGND 0.98371f
C43637 _551_/a_272_160# VGND 0.00352f
C43638 _551_/a_170_160# VGND 0
C43639 _551_/a_76_160# VGND 0.36086f
C43640 FILLER_29_221/a_32_246# VGND 0.11889f
C43641 FILLER_15_162/a_40_246# VGND 0.16202f
C43642 FILLER_15_173/a_40_246# VGND 0.16218f
C43643 net142 VGND 0.4637f
C43644 _110_ VGND 0.84728f
C43645 _697_/a_2002_114# VGND 0.00329f
C43646 _697_/a_1489_191# VGND 0.095f
C43647 _697_/a_612_127# VGND 0.03671f
C43648 _697_/a_2250_412# VGND 0.44854f
C43649 _697_/a_1840_334# VGND 0.24737f
C43650 _697_/a_1583_191# VGND 0.54288f
C43651 _697_/a_132_114# VGND 0
C43652 _697_/a_843_236# VGND 0.38351f
C43653 _697_/a_741_93# VGND 0.84719f
C43654 _697_/a_324_432# VGND 1.59669f
C43655 _697_/a_38_114# VGND 0.1965f
C43656 _697_/a_298_337# VGND 0.24259f
C43657 rx_data[6] VGND 1.05926f
C43658 output18/a_40_152# VGND 0.42505f
C43659 net87 VGND 1.10424f
C43660 _518_/a_139_160# VGND 0.00776f
C43661 _518_/a_45_160# VGND 0.33957f
C43662 _260_ VGND 0.39554f
C43663 _225_ VGND 1.20481f
C43664 _449_/a_229_118# VGND 0.00852f
C43665 _449_/a_27_156# VGND 0.43789f
C43666 fanout41/a_40_152# VGND 0.42648f
C43667 fanout30/a_40_152# VGND 0.42624f
C43668 _155_ VGND 1.42836f
C43669 net124 VGND 0.62229f
C43670 FILLER_23_204/a_40_246# VGND 0.16408f
C43671 _219_ VGND 0.56433f
C43672 _218_ VGND 0.37751f
C43673 _217_ VGND 1.19671f
C43674 _195_ VGND 0.88907f
C43675 _397_/a_279_412# VGND 0
C43676 _397_/a_165_412# VGND 0
C43677 _093_ VGND 0.86377f
C43678 FILLER_17_201/a_32_246# VGND 0.12143f
C43679 _466_/a_22_110# VGND 0.2576f
C43680 _466_/a_120_432# VGND 0
C43681 _535_/a_350_122# VGND 0.00306f
C43682 _535_/a_248_122# VGND 0.00816f
C43683 _535_/a_146_122# VGND 0.01225f
C43684 tx_inst.state\[4\] VGND 0.3915f
C43685 hold146/a_438_182# VGND 0.3779f
C43686 hold146/a_326_118# VGND 0.31947f
C43687 hold146/a_56_118# VGND 0.50794f
C43688 hold168/a_438_182# VGND 0.39695f
C43689 hold168/a_326_118# VGND 0.36058f
C43690 hold168/a_56_118# VGND 0.54585f
C43691 baud_inst.counter\[8\] VGND 1.40212f
C43692 hold135/a_438_182# VGND 0.38073f
C43693 hold135/a_326_118# VGND 0.3242f
C43694 hold135/a_56_118# VGND 0.50563f
C43695 net179 VGND 1.73046f
C43696 hold179/a_438_182# VGND 0.37991f
C43697 hold179/a_326_118# VGND 0.32087f
C43698 hold179/a_56_118# VGND 0.50103f
C43699 hold157/a_438_182# VGND 0.37572f
C43700 hold157/a_326_118# VGND 0.31686f
C43701 hold157/a_56_118# VGND 0.49815f
C43702 net102 VGND 0.36302f
C43703 _017_ VGND 0.38531f
C43704 hold102/a_438_182# VGND 0.37554f
C43705 hold102/a_326_118# VGND 0.31695f
C43706 hold102/a_56_118# VGND 0.48456f
C43707 hold113/a_438_182# VGND 0.37595f
C43708 hold113/a_326_118# VGND 0.31809f
C43709 hold113/a_56_118# VGND 0.48236f
C43710 hold124/a_438_182# VGND 0.37889f
C43711 hold124/a_326_118# VGND 0.32321f
C43712 hold124/a_56_118# VGND 0.48671f
C43713 _004_ VGND 0.30419f
C43714 _277_ VGND 0.52997f
C43715 net28 VGND 1.58266f
C43716 _483_/a_22_110# VGND 0.23912f
C43717 FILLER_21_175/a_32_246# VGND 0.12017f
C43718 _315_ VGND 0.30996f
C43719 _552_/a_257_140# VGND 0.01195f
C43720 _552_/a_155_412# VGND 0.04094f
C43721 _698_/a_2002_114# VGND 0.00329f
C43722 _698_/a_1489_191# VGND 0.09495f
C43723 _698_/a_612_127# VGND 0.03671f
C43724 _698_/a_2250_412# VGND 0.44002f
C43725 _698_/a_1840_334# VGND 0.24725f
C43726 _698_/a_1583_191# VGND 0.54239f
C43727 _698_/a_132_114# VGND 0
C43728 _698_/a_843_236# VGND 0.3804f
C43729 _698_/a_741_93# VGND 0.84679f
C43730 _698_/a_324_432# VGND 1.59718f
C43731 _698_/a_38_114# VGND 0.22844f
C43732 _698_/a_298_337# VGND 0.2434f
C43733 rx_data[5] VGND 1.02102f
C43734 output17/a_40_152# VGND 0.43839f
C43735 _295_ VGND 0.41149f
C43736 net128 VGND 0.96467f
C43737 baud_inst.counter\[12\] VGND 1.59119f
C43738 _519_/a_379_118# VGND 0.01327f
C43739 _519_/a_277_118# VGND 0.0088f
C43740 _519_/a_175_118# VGND 0.00731f
C43741 _519_/a_81_118# VGND 0.41781f
C43742 FILLER_1_173/a_32_246# VGND 0.11902f
C43743 fanout40/a_40_152# VGND 0.44235f
C43744 _143_ VGND 0.70102f
C43745 _216_ VGND 1.73758f
C43746 _398_/a_494_160# VGND 0.01071f
C43747 _398_/a_358_436# VGND 0.05691f
C43748 _398_/a_115_308# VGND 0.53959f
C43749 _094_ VGND 0.93027f
C43750 net84 VGND 0.41227f
C43751 _467_/a_22_110# VGND 0.24463f
C43752 _022_ VGND 0.35764f
C43753 net120 VGND 0.73289f
C43754 _536_/a_341_118# VGND 0.13902f
C43755 _536_/a_155_160# VGND 0.00114f
C43756 _536_/a_192_429# VGND 0.46718f
C43757 net178 VGND 0.39653f
C43758 hold178/a_438_182# VGND 0.37919f
C43759 hold178/a_326_118# VGND 0.3219f
C43760 hold178/a_56_118# VGND 0.48586f
C43761 net145 VGND 0.56299f
C43762 hold145/a_438_182# VGND 0.38415f
C43763 hold145/a_326_118# VGND 0.3257f
C43764 hold145/a_56_118# VGND 0.52449f
C43765 net156 VGND 1.90797f
C43766 hold156/a_438_182# VGND 0.39566f
C43767 hold156/a_326_118# VGND 0.32485f
C43768 hold156/a_56_118# VGND 0.48657f
C43769 net123 VGND 0.37115f
C43770 hold123/a_438_182# VGND 0.37655f
C43771 hold123/a_326_118# VGND 0.31679f
C43772 hold123/a_56_118# VGND 0.48496f
C43773 baud_inst.counter\[18\] VGND 1.11644f
C43774 hold101/a_438_182# VGND 0.3755f
C43775 hold101/a_326_118# VGND 0.31688f
C43776 hold101/a_56_118# VGND 0.48108f
C43777 net167 VGND 0.53977f
C43778 _002_ VGND 0.39288f
C43779 hold167/a_438_182# VGND 0.37868f
C43780 hold167/a_326_118# VGND 0.32461f
C43781 hold167/a_56_118# VGND 0.48901f
C43782 hold112/a_438_182# VGND 0.37648f
C43783 hold112/a_326_118# VGND 0.32371f
C43784 hold112/a_56_118# VGND 0.50497f
C43785 hold134/a_438_182# VGND 0.38099f
C43786 hold134/a_326_118# VGND 0.31748f
C43787 hold134/a_56_118# VGND 0.50787f
C43788 FILLER_8_189/a_40_246# VGND 0.16393f
C43789 _278_ VGND 0.6108f
C43790 rx_inst.state\[3\] VGND 1.70737f
C43791 _484_/a_154_118# VGND 0.00974f
C43792 _111_ VGND 1.0144f
C43793 net45 VGND 3.88906f
C43794 _029_ VGND 0.61972f
C43795 net106 VGND 0.53999f
C43796 _553_/a_170_412# VGND 0
C43797 FILLER_7_40/a_32_246# VGND 0.12221f
C43798 clk VGND 5.1115f
C43799 clkbuf_0_clk/a_116_82# VGND 4.54306f
C43800 net114 VGND 0.49914f
C43801 _699_/a_2002_114# VGND 0.00329f
C43802 _699_/a_1489_191# VGND 0.09495f
C43803 _699_/a_612_127# VGND 0.03671f
C43804 _699_/a_2250_412# VGND 0.43985f
C43805 _699_/a_1840_334# VGND 0.24726f
C43806 _699_/a_1583_191# VGND 0.54249f
C43807 _699_/a_132_114# VGND 0
C43808 _699_/a_843_236# VGND 0.37958f
C43809 _699_/a_741_93# VGND 0.84369f
C43810 _699_/a_324_432# VGND 1.59768f
C43811 _699_/a_38_114# VGND 0.19521f
C43812 _699_/a_298_337# VGND 0.24297f
C43813 FILLER_0_237/a_40_246# VGND 0.16764f
C43814 FILLER_15_17/a_40_246# VGND 0.16156f
C43815 rx_data[4] VGND 0.20346f
C43816 net16 VGND 0.66453f
C43817 output16/a_40_152# VGND 0.43862f
C43818 _057_ VGND 0.88225f
C43819 hold59/a_438_182# VGND 0.38116f
C43820 hold59/a_326_118# VGND 0.31936f
C43821 hold59/a_56_118# VGND 0.48669f
C43822 FILLER_1_30/a_32_246# VGND 0.1208f
C43823 clkload3/Y VGND 0.22413f
C43824 FILLER_14_202/a_40_246# VGND 0.18169f
C43825 _095_ VGND 0.88852f
C43826 _399_/a_154_118# VGND 0.00954f
C43827 _125_ VGND 0.34065f
C43828 _270_ VGND 0.48796f
C43829 _468_/a_22_110# VGND 0.23981f
C43830 _468_/a_120_432# VGND 0
C43831 _023_ VGND 0.81256f
C43832 _305_ VGND 0.64925f
C43833 net75 VGND 1.39006f
C43834 _537_/a_341_118# VGND 0.13902f
C43835 _537_/a_155_160# VGND 0.00114f
C43836 _537_/a_192_429# VGND 0.46711f
C43837 hold155/a_438_182# VGND 0.38119f
C43838 hold155/a_326_118# VGND 0.32379f
C43839 hold155/a_56_118# VGND 0.48109f
C43840 _041_ VGND 1.31681f
C43841 hold122/a_438_182# VGND 0.37563f
C43842 hold122/a_326_118# VGND 0.31689f
C43843 hold122/a_56_118# VGND 0.5163f
C43844 hold177/a_438_182# VGND 0.37558f
C43845 hold177/a_326_118# VGND 0.31692f
C43846 hold177/a_56_118# VGND 0.4857f
C43847 net166 VGND 0.3632f
C43848 hold166/a_438_182# VGND 0.37558f
C43849 hold166/a_326_118# VGND 0.3176f
C43850 hold166/a_56_118# VGND 0.48297f
C43851 hold144/a_438_182# VGND 0.38379f
C43852 hold144/a_326_118# VGND 0.31687f
C43853 hold144/a_56_118# VGND 0.50356f
C43854 net100 VGND 0.61322f
C43855 hold100/a_438_182# VGND 0.37575f
C43856 hold100/a_326_118# VGND 0.31687f
C43857 hold100/a_56_118# VGND 0.48141f
C43858 rx_inst.data_reg\[0\] VGND 0.42295f
C43859 hold111/a_438_182# VGND 0.37763f
C43860 hold111/a_326_118# VGND 0.31965f
C43861 hold111/a_56_118# VGND 0.48317f
C43862 hold133/a_438_182# VGND 0.37989f
C43863 hold133/a_326_118# VGND 0.31688f
C43864 hold133/a_56_118# VGND 0.51624f
C43865 _003_ VGND 0.29416f
C43866 net37 VGND 3.2338f
C43867 net122 VGND 0.97369f
C43868 _485_/a_22_110# VGND 0.23903f
C43869 FILLER_12_173/a_32_246# VGND 0.11886f
C43870 FILLER_16_70/a_40_246# VGND 0.16172f
C43871 _112_ VGND 0.92503f
C43872 _554_/a_350_122# VGND 0.00287f
C43873 _554_/a_248_122# VGND 0.00798f
C43874 _554_/a_146_122# VGND 0.01203f
C43875 FILLER_22_118/a_32_246# VGND 0.1248f
C43876 _058_ VGND 0.81842f
C43877 rx_data[3] VGND 0.75126f
C43878 net15 VGND 0.85331f
C43879 output15/a_40_152# VGND 0.42496f
C43880 rx_inst.bit_index\[0\] VGND 0.38175f
C43881 clknet_4_14_0_clk VGND 2.98424f
C43882 _640_/a_2002_114# VGND 0.00329f
C43883 _640_/a_1489_191# VGND 0.09498f
C43884 _640_/a_612_127# VGND 0.03671f
C43885 _640_/a_2250_412# VGND 0.4413f
C43886 _640_/a_1840_334# VGND 0.2481f
C43887 _640_/a_1583_191# VGND 0.54306f
C43888 _640_/a_132_114# VGND 0
C43889 _640_/a_843_236# VGND 0.38051f
C43890 _640_/a_741_93# VGND 0.8481f
C43891 _640_/a_324_432# VGND 1.59697f
C43892 _640_/a_38_114# VGND 0.19399f
C43893 _640_/a_298_337# VGND 0.24243f
C43894 FILLER_19_178/a_40_246# VGND 0.16151f
C43895 net69 VGND 0.38299f
C43896 hold69/a_438_182# VGND 0.37766f
C43897 hold69/a_326_118# VGND 0.31929f
C43898 hold69/a_56_118# VGND 0.48317f
C43899 hold58/a_438_182# VGND 0.37754f
C43900 hold58/a_326_118# VGND 0.32f
C43901 hold58/a_56_118# VGND 0.5202f
C43902 clkload2/Y VGND 0.21805f
C43903 clknet_4_11_0_clk VGND 3.05842f
C43904 net150 VGND 0.51794f
C43905 net82 VGND 0.73053f
C43906 _469_/a_22_110# VGND 0.24189f
C43907 _469_/a_120_432# VGND 0
C43908 _306_ VGND 0.73127f
C43909 baud_inst.counter\[22\] VGND 1.96028f
C43910 baud_inst.counter\[23\] VGND 1.28568f
C43911 baud_inst.counter\[21\] VGND 1.37361f
C43912 _538_/a_379_118# VGND 0.01797f
C43913 _538_/a_277_118# VGND 0.00915f
C43914 _538_/a_175_118# VGND 0.00769f
C43915 _538_/a_81_118# VGND 0.44304f
C43916 net110 VGND 0.38609f
C43917 hold110/a_438_182# VGND 0.37833f
C43918 hold110/a_326_118# VGND 0.32023f
C43919 hold110/a_56_118# VGND 0.51982f
C43920 hold165/a_438_182# VGND 0.3799f
C43921 hold165/a_326_118# VGND 0.31678f
C43922 hold165/a_56_118# VGND 0.48713f
C43923 hold154/a_438_182# VGND 0.37556f
C43924 hold154/a_326_118# VGND 0.31774f
C43925 hold154/a_56_118# VGND 0.48213f
C43926 hold176/a_438_182# VGND 0.37717f
C43927 hold176/a_326_118# VGND 0.31746f
C43928 hold176/a_56_118# VGND 0.51289f
C43929 net143 VGND 0.49317f
C43930 hold143/a_438_182# VGND 0.38002f
C43931 hold143/a_326_118# VGND 0.32021f
C43932 hold143/a_56_118# VGND 0.48599f
C43933 net121 VGND 0.4196f
C43934 hold121/a_438_182# VGND 0.37557f
C43935 hold121/a_326_118# VGND 0.31783f
C43936 hold121/a_56_118# VGND 0.48494f
C43937 hold132/a_438_182# VGND 0.37712f
C43938 hold132/a_326_118# VGND 0.31906f
C43939 hold132/a_56_118# VGND 0.51998f
C43940 _486_/a_494_160# VGND 0.01069f
C43941 _486_/a_358_436# VGND 0.05587f
C43942 _486_/a_115_308# VGND 0.53648f
C43943 net67 VGND 0.92943f
C43944 _555_/a_474_130# VGND 0.00768f
C43945 _555_/a_380_412# VGND 0
C43946 _555_/a_177_436# VGND 0
C43947 _555_/a_209_168# VGND 0.40044f
C43948 _113_ VGND 0.86333f
C43949 FILLER_21_194/a_32_246# VGND 0.11958f
C43950 FILLER_7_82/a_32_246# VGND 0.11929f
C43951 net176 VGND 0.55611f
C43952 _052_ VGND 0.88678f
C43953 _641_/a_2002_114# VGND 0.00329f
C43954 _641_/a_1489_191# VGND 0.095f
C43955 _641_/a_612_127# VGND 0.03671f
C43956 _641_/a_2250_412# VGND 0.4396f
C43957 _641_/a_1840_334# VGND 0.24783f
C43958 _641_/a_1583_191# VGND 0.54832f
C43959 _641_/a_132_114# VGND 0
C43960 _641_/a_843_236# VGND 0.38421f
C43961 _641_/a_741_93# VGND 0.85094f
C43962 _641_/a_324_432# VGND 1.59669f
C43963 _641_/a_38_114# VGND 0.19691f
C43964 _641_/a_298_337# VGND 0.24248f
C43965 _059_ VGND 0.91172f
C43966 rx_data[2] VGND 1.06214f
C43967 net14 VGND 0.88731f
C43968 output14/a_40_152# VGND 0.4253f
C43969 net57 VGND 0.40345f
C43970 hold57/a_438_182# VGND 0.37582f
C43971 hold57/a_326_118# VGND 0.31689f
C43972 hold57/a_56_118# VGND 0.48109f
C43973 hold79/a_438_182# VGND 0.37691f
C43974 hold79/a_326_118# VGND 0.31773f
C43975 hold79/a_56_118# VGND 0.51624f
C43976 _031_ VGND 0.40669f
C43977 hold68/a_438_182# VGND 0.37651f
C43978 hold68/a_326_118# VGND 0.31836f
C43979 hold68/a_56_118# VGND 0.50834f
C43980 clkload1/Y VGND 0.27193f
C43981 FILLER_5_156/a_32_246# VGND 0.13552f
C43982 _097_ VGND 0.82864f
C43983 _307_ VGND 0.92273f
C43984 _539_/a_139_160# VGND 0.0071f
C43985 _539_/a_45_160# VGND 0.35593f
C43986 _284_ VGND 0.42899f
C43987 hold153/a_438_182# VGND 0.37574f
C43988 hold153/a_326_118# VGND 0.31783f
C43989 hold153/a_56_118# VGND 0.48138f
C43990 tx_inst.bit_index\[2\] VGND 2.09595f
C43991 _341_/a_1023_118# VGND 0
C43992 _341_/a_810_118# VGND 0.00435f
C43993 _341_/a_500_118# VGND 0.00651f
C43994 _341_/a_308_118# VGND 0.00361f
C43995 _341_/a_1377_160# VGND 0.293f
C43996 _341_/a_1109_431# VGND 0
C43997 _341_/a_886_118# VGND 0.69223f
C43998 _341_/a_589_385# VGND 0
C43999 _341_/a_382_118# VGND 0.02447f
C44000 _341_/a_295_385# VGND 0.00105f
C44001 _341_/a_805_385# VGND 0
C44002 _341_/a_1453_124# VGND 0.35844f
C44003 _341_/a_71_118# VGND 1.11483f
C44004 _229_ VGND 0.42193f
C44005 rx_inst.state\[2\] VGND 2.52446f
C44006 _228_ VGND 1.24311f
C44007 _410_/a_257_140# VGND 0.01118f
C44008 _410_/a_155_412# VGND 0.03831f
C44009 hold164/a_438_182# VGND 0.38388f
C44010 hold164/a_326_118# VGND 0.31699f
C44011 hold164/a_56_118# VGND 0.51632f
C44012 hold142/a_438_182# VGND 0.37551f
C44013 hold142/a_326_118# VGND 0.317f
C44014 hold142/a_56_118# VGND 0.4812f
C44015 hold175/a_438_182# VGND 0.37839f
C44016 hold175/a_326_118# VGND 0.31694f
C44017 hold175/a_56_118# VGND 0.48118f
C44018 hold120/a_438_182# VGND 0.37887f
C44019 hold120/a_326_118# VGND 0.3292f
C44020 hold120/a_56_118# VGND 0.54787f
C44021 net131 VGND 0.53219f
C44022 hold131/a_438_182# VGND 0.37645f
C44023 hold131/a_326_118# VGND 0.31854f
C44024 hold131/a_56_118# VGND 0.48263f
C44025 _152_ VGND 0.29456f
C44026 _487_/a_248_122# VGND 0.00728f
C44027 _487_/a_146_122# VGND 0.01186f
C44028 FILLER_12_171/a_40_246# VGND 0.1622f
C44029 _032_ VGND 0.40356f
C44030 _316_ VGND 0.53396f
C44031 net58 VGND 0.94802f
C44032 _556_/a_341_118# VGND 0.1396f
C44033 _556_/a_155_160# VGND 0.00119f
C44034 _556_/a_435_412# VGND 0
C44035 _556_/a_192_429# VGND 0.46986f
C44036 _114_ VGND 0.87192f
C44037 FILLER_26_35/a_32_246# VGND 0.13593f
C44038 rx_inst.bit_index\[2\] VGND 1.67749f
C44039 clknet_4_12_0_clk VGND 2.91086f
C44040 _132_ VGND 0.52013f
C44041 _053_ VGND 0.87375f
C44042 _642_/a_2002_114# VGND 0.00329f
C44043 _642_/a_1489_191# VGND 0.09495f
C44044 _642_/a_612_127# VGND 0.03671f
C44045 _642_/a_2250_412# VGND 0.44056f
C44046 _642_/a_1840_334# VGND 0.24761f
C44047 _642_/a_1583_191# VGND 0.54304f
C44048 _642_/a_132_114# VGND 0
C44049 _642_/a_843_236# VGND 0.38012f
C44050 _642_/a_741_93# VGND 0.84537f
C44051 _642_/a_324_432# VGND 1.59743f
C44052 _642_/a_38_114# VGND 0.19416f
C44053 _642_/a_298_337# VGND 0.24264f
C44054 _060_ VGND 1.06021f
C44055 rx_data[1] VGND 1.06888f
C44056 net13 VGND 0.77247f
C44057 output13/a_40_152# VGND 0.45817f
C44058 FILLER_19_132/a_40_246# VGND 0.16281f
C44059 tx_inst.bit_index\[0\] VGND 0.52019f
C44060 hold56/a_438_182# VGND 0.37597f
C44061 hold56/a_326_118# VGND 0.31731f
C44062 hold56/a_56_118# VGND 0.48102f
C44063 _078_ VGND 0.83171f
C44064 net89 VGND 0.34461f
C44065 hold89/a_438_182# VGND 0.37917f
C44066 hold89/a_326_118# VGND 0.32101f
C44067 hold89/a_56_118# VGND 0.48616f
C44068 hold67/a_438_182# VGND 0.37687f
C44069 hold67/a_326_118# VGND 0.32379f
C44070 hold67/a_56_118# VGND 0.52105f
C44071 FILLER_28_176/a_32_246# VGND 0.11891f
C44072 hold78/a_438_182# VGND 0.37549f
C44073 hold78/a_326_118# VGND 0.31678f
C44074 hold78/a_56_118# VGND 0.48205f
C44075 clkload0/Y VGND 0.25279f
C44076 net111 VGND 0.4857f
C44077 _098_ VGND 0.93141f
C44078 hold152/a_438_182# VGND 0.37723f
C44079 hold152/a_326_118# VGND 0.31734f
C44080 hold152/a_56_118# VGND 0.48116f
C44081 net174 VGND 0.36864f
C44082 hold174/a_438_182# VGND 0.37716f
C44083 hold174/a_326_118# VGND 0.31987f
C44084 hold174/a_56_118# VGND 0.48354f
C44085 _175_ VGND 0.72837f
C44086 _174_ VGND 0.71499f
C44087 net34 VGND 3.05247f
C44088 _342_/a_170_412# VGND 0
C44089 hold130/a_438_182# VGND 0.3756f
C44090 hold130/a_326_118# VGND 0.31701f
C44091 hold130/a_56_118# VGND 0.48456f
C44092 _230_ VGND 2.97533f
C44093 _411_/a_494_160# VGND 0.01069f
C44094 _411_/a_358_436# VGND 0.05587f
C44095 _411_/a_115_308# VGND 0.53681f
C44096 baud_inst.counter\[20\] VGND 2.44541f
C44097 hold163/a_438_182# VGND 0.38409f
C44098 hold163/a_326_118# VGND 0.31686f
C44099 hold163/a_56_118# VGND 0.51727f
C44100 hold141/a_438_182# VGND 0.37562f
C44101 hold141/a_326_118# VGND 0.31678f
C44102 hold141/a_56_118# VGND 0.48245f
C44103 _019_ VGND 0.4382f
C44104 _488_/a_474_130# VGND 0.0076f
C44105 _488_/a_380_412# VGND 0
C44106 _488_/a_177_436# VGND 0
C44107 _488_/a_209_168# VGND 0.38921f
C44108 FILLER_13_137/a_32_246# VGND 0.11888f
C44109 FILLER_21_192/a_40_246# VGND 0.16612f
C44110 _044_ VGND 0.8324f
C44111 net48 VGND 4.41219f
C44112 net112 VGND 0.2998f
C44113 _643_/a_2002_114# VGND 0.0033f
C44114 _643_/a_1489_191# VGND 0.09658f
C44115 _643_/a_550_127# VGND 0
C44116 _643_/a_612_127# VGND 0.03904f
C44117 _643_/a_1785_429# VGND 0
C44118 _643_/a_2250_412# VGND 0.44187f
C44119 _643_/a_1840_334# VGND 0.24937f
C44120 _643_/a_1583_191# VGND 0.54666f
C44121 _643_/a_132_114# VGND 0
C44122 _643_/a_681_505# VGND 0
C44123 _643_/a_843_236# VGND 0.40124f
C44124 _643_/a_741_93# VGND 0.8769f
C44125 _643_/a_324_432# VGND 1.62347f
C44126 _643_/a_38_114# VGND 0.19844f
C44127 _643_/a_298_337# VGND 0.24677f
C44128 tx_done VGND 0.33928f
C44129 net23 VGND 0.49709f
C44130 output23/a_40_152# VGND 0.42505f
C44131 rx_data[0] VGND 0.87562f
C44132 output12/a_40_152# VGND 0.42884f
C44133 hold55/a_438_182# VGND 0.37556f
C44134 hold55/a_326_118# VGND 0.31682f
C44135 hold55/a_56_118# VGND 0.48494f
C44136 clknet_4_5_0_clk VGND 3.2368f
C44137 _660_/a_2002_114# VGND 0.00351f
C44138 _660_/a_1489_191# VGND 0.09617f
C44139 _660_/a_612_127# VGND 0.03671f
C44140 _660_/a_1785_429# VGND 0
C44141 _660_/a_2250_412# VGND 0.46663f
C44142 _660_/a_1840_334# VGND 0.25121f
C44143 _660_/a_1583_191# VGND 0.5531f
C44144 _660_/a_132_114# VGND 0
C44145 _660_/a_843_236# VGND 0.38077f
C44146 _660_/a_741_93# VGND 0.84759f
C44147 _660_/a_324_432# VGND 1.59915f
C44148 _660_/a_38_114# VGND 0.19485f
C44149 _660_/a_298_337# VGND 0.24249f
C44150 _080_ VGND 0.93175f
C44151 hold88/a_438_182# VGND 0.37668f
C44152 hold88/a_326_118# VGND 0.31755f
C44153 hold88/a_56_118# VGND 0.4856f
C44154 FILLER_20_57/a_32_246# VGND 0.13512f
C44155 hold99/a_438_182# VGND 0.37551f
C44156 hold99/a_326_118# VGND 0.31749f
C44157 hold99/a_56_118# VGND 0.50798f
C44158 net66 VGND 0.42918f
C44159 hold66/a_438_182# VGND 0.37559f
C44160 hold66/a_326_118# VGND 0.31678f
C44161 hold66/a_56_118# VGND 0.48237f
C44162 hold77/a_438_182# VGND 0.4011f
C44163 hold77/a_326_118# VGND 0.34304f
C44164 hold77/a_56_118# VGND 0.48866f
C44165 hold184/a_438_182# VGND 0.37761f
C44166 hold184/a_326_118# VGND 0.31935f
C44167 hold184/a_56_118# VGND 0.51665f
C44168 hold173/a_438_182# VGND 0.37661f
C44169 hold173/a_326_118# VGND 0.31846f
C44170 hold173/a_56_118# VGND 0.50727f
C44171 _343_/a_257_140# VGND 0.01134f
C44172 _343_/a_155_412# VGND 0.04107f
C44173 _231_ VGND 0.58663f
C44174 _227_ VGND 1.26101f
C44175 _170_ VGND 3.20531f
C44176 _412_/a_22_110# VGND 0.2406f
C44177 FILLER_12_46/a_32_246# VGND 0.11969f
C44178 hold162/a_438_182# VGND 0.37561f
C44179 hold162/a_326_118# VGND 0.31678f
C44180 hold162/a_56_118# VGND 0.48209f
C44181 hold140/a_438_182# VGND 0.37556f
C44182 hold140/a_326_118# VGND 0.31696f
C44183 hold140/a_56_118# VGND 0.48239f
C44184 net151 VGND 0.51279f
C44185 _135_ VGND 0.72255f
C44186 hold151/a_438_182# VGND 0.37754f
C44187 hold151/a_326_118# VGND 0.31962f
C44188 hold151/a_56_118# VGND 0.48279f
C44189 _489_/a_494_160# VGND 0.01103f
C44190 _489_/a_358_436# VGND 0.06289f
C44191 _489_/a_115_308# VGND 0.54536f
C44192 _116_ VGND 0.92004f
C44193 _045_ VGND 0.89104f
C44194 _193_ VGND 0.70197f
C44195 net184 VGND 0.9471f
C44196 tx_inst.bit_index\[1\] VGND 3.29006f
C44197 _360_/a_1023_118# VGND 0
C44198 _360_/a_810_118# VGND 0.00424f
C44199 _360_/a_500_118# VGND 0.00614f
C44200 _360_/a_308_118# VGND 0.00348f
C44201 _360_/a_1377_160# VGND 0.30045f
C44202 _360_/a_886_118# VGND 0.68709f
C44203 _360_/a_382_118# VGND 0.01962f
C44204 _360_/a_1453_124# VGND 0.35666f
C44205 _360_/a_71_118# VGND 1.08921f
C44206 FILLER_26_88/a_40_246# VGND 0.16255f
C44207 _062_ VGND 0.92851f
C44208 tx_busy VGND 0.47725f
C44209 output22/a_40_152# VGND 0.42546f
C44210 FILLER_15_67/a_40_246# VGND 0.16157f
C44211 FILLER_15_89/a_32_246# VGND 0.11886f
C44212 FILLER_16_166/a_32_246# VGND 0.13477f
C44213 clkbuf_4_10_0_clk/a_27_118# VGND 2.38144f
C44214 FILLER_25_177/a_40_246# VGND 0.16304f
C44215 rx_inst.data_reg\[1\] VGND 0.37473f
C44216 net132 VGND 0.35239f
C44217 _055_ VGND 0.91141f
C44218 _644_/a_2002_114# VGND 0.00329f
C44219 _644_/a_1489_191# VGND 0.09502f
C44220 _644_/a_612_127# VGND 0.03692f
C44221 _644_/a_1785_429# VGND 0
C44222 _644_/a_2250_412# VGND 0.44073f
C44223 _644_/a_1840_334# VGND 0.24927f
C44224 _644_/a_1583_191# VGND 0.54899f
C44225 _644_/a_132_114# VGND 0
C44226 _644_/a_681_505# VGND 0
C44227 _644_/a_843_236# VGND 0.38559f
C44228 _644_/a_741_93# VGND 0.84955f
C44229 _644_/a_324_432# VGND 1.59829f
C44230 _644_/a_38_114# VGND 0.19844f
C44231 _644_/a_298_337# VGND 0.24395f
C44232 net98 VGND 0.70551f
C44233 _009_ VGND 0.52518f
C44234 hold98/a_438_182# VGND 0.38586f
C44235 hold98/a_326_118# VGND 0.32243f
C44236 hold98/a_56_118# VGND 0.51228f
C44237 hold54/a_438_182# VGND 0.38336f
C44238 hold54/a_326_118# VGND 0.32578f
C44239 hold54/a_56_118# VGND 0.48948f
C44240 tx_inst.data_reg\[7\] VGND 1.23469f
C44241 _072_ VGND 1.03223f
C44242 _661_/a_2002_114# VGND 0.00329f
C44243 _661_/a_1489_191# VGND 0.09497f
C44244 _661_/a_612_127# VGND 0.03673f
C44245 _661_/a_2250_412# VGND 0.43961f
C44246 _661_/a_1840_334# VGND 0.24739f
C44247 _661_/a_1583_191# VGND 0.54257f
C44248 _661_/a_132_114# VGND 0
C44249 _661_/a_843_236# VGND 0.37944f
C44250 _661_/a_741_93# VGND 0.84563f
C44251 _661_/a_324_432# VGND 1.59662f
C44252 _661_/a_38_114# VGND 0.19339f
C44253 _661_/a_298_337# VGND 0.24246f
C44254 _081_ VGND 0.9999f
C44255 hold87/a_438_182# VGND 0.37568f
C44256 hold87/a_326_118# VGND 0.31696f
C44257 hold87/a_56_118# VGND 0.48754f
C44258 hold76/a_438_182# VGND 0.38006f
C44259 hold76/a_326_118# VGND 0.33164f
C44260 hold76/a_56_118# VGND 0.5267f
C44261 hold65/a_438_182# VGND 0.37721f
C44262 hold65/a_326_118# VGND 0.31829f
C44263 hold65/a_56_118# VGND 0.48515f
C44264 FILLER_9_79/a_32_246# VGND 0.11912f
C44265 _008_ VGND 0.42585f
C44266 net79 VGND 2.66408f
C44267 FILLER_5_164/a_40_246# VGND 0.16973f
C44268 _177_ VGND 0.97759f
C44269 baud_inst.counter\[26\] VGND 0.75481f
C44270 baud_inst.counter\[27\] VGND 0.76299f
C44271 _344_/a_150_412# VGND 0
C44272 _413_/a_170_412# VGND 0
C44273 hold183/a_438_182# VGND 0.37559f
C44274 hold183/a_326_118# VGND 0.31713f
C44275 hold183/a_56_118# VGND 0.51193f
C44276 hold172/a_438_182# VGND 0.37678f
C44277 hold172/a_326_118# VGND 0.31792f
C44278 hold172/a_56_118# VGND 0.48215f
C44279 FILLER_12_89/a_40_246# VGND 0.16147f
C44280 hold161/a_438_182# VGND 0.37562f
C44281 hold161/a_326_118# VGND 0.31684f
C44282 hold161/a_56_118# VGND 0.49955f
C44283 hold150/a_438_182# VGND 0.3756f
C44284 hold150/a_326_118# VGND 0.31688f
C44285 hold150/a_56_118# VGND 0.48126f
C44286 _117_ VGND 0.85208f
C44287 _046_ VGND 0.9114f
C44288 FILLER_7_9/a_32_246# VGND 0.12097f
C44289 net173 VGND 1.03764f
C44290 _361_/a_248_122# VGND 0.00723f
C44291 _361_/a_146_122# VGND 0.01208f
C44292 FILLER_13_102/a_32_246# VGND 0.11896f
C44293 net36 VGND 2.80165f
C44294 rx_inst.bit_index\[1\] VGND 1.72457f
C44295 _430_/a_170_412# VGND 0
C44296 tx VGND 0.51844f
C44297 output21/a_40_152# VGND 0.42513f
C44298 FILLER_16_154/a_32_246# VGND 0.11909f
C44299 FILLER_16_176/a_40_246# VGND 0.16158f
C44300 rx_inst.data_reg\[2\] VGND 0.40299f
C44301 _645_/a_2002_114# VGND 0.00329f
C44302 _645_/a_1489_191# VGND 0.09498f
C44303 _645_/a_612_127# VGND 0.03671f
C44304 _645_/a_2250_412# VGND 0.44035f
C44305 _645_/a_1840_334# VGND 0.2499f
C44306 _645_/a_1583_191# VGND 0.54335f
C44307 _645_/a_132_114# VGND 0
C44308 _645_/a_843_236# VGND 0.38036f
C44309 _645_/a_741_93# VGND 0.8518f
C44310 _645_/a_324_432# VGND 1.59686f
C44311 _645_/a_38_114# VGND 0.20534f
C44312 _645_/a_298_337# VGND 0.24245f
C44313 FILLER_25_198/a_32_246# VGND 0.14002f
C44314 _082_ VGND 1.01576f
C44315 net44 VGND 5.03052f
C44316 hold97/a_438_182# VGND 0.3784f
C44317 hold97/a_326_118# VGND 0.3219f
C44318 hold97/a_56_118# VGND 0.4942f
C44319 _040_ VGND 1.22068f
C44320 _073_ VGND 1.01649f
C44321 _662_/a_2002_114# VGND 0.00329f
C44322 _662_/a_1489_191# VGND 0.09496f
C44323 _662_/a_612_127# VGND 0.03703f
C44324 _662_/a_2250_412# VGND 0.43958f
C44325 _662_/a_1840_334# VGND 0.24788f
C44326 _662_/a_1583_191# VGND 0.54333f
C44327 _662_/a_132_114# VGND 0
C44328 _662_/a_681_505# VGND 0
C44329 _662_/a_843_236# VGND 0.37921f
C44330 _662_/a_741_93# VGND 0.84645f
C44331 _662_/a_324_432# VGND 1.59917f
C44332 _662_/a_38_114# VGND 0.20909f
C44333 _662_/a_298_337# VGND 0.24452f
C44334 FILLER_1_90/a_32_246# VGND 0.12482f
C44335 baud_inst.counter\[1\] VGND 0.39207f
C44336 hold86/a_438_182# VGND 0.37618f
C44337 hold86/a_326_118# VGND 0.31681f
C44338 hold86/a_56_118# VGND 0.48462f
C44339 net12 VGND 0.97896f
C44340 hold64/a_438_182# VGND 0.37582f
C44341 hold64/a_326_118# VGND 0.31678f
C44342 hold64/a_56_118# VGND 0.48132f
C44343 hold75/a_438_182# VGND 0.379f
C44344 hold75/a_326_118# VGND 0.32388f
C44345 hold75/a_56_118# VGND 0.50747f
C44346 net53 VGND 0.49317f
C44347 hold53/a_438_182# VGND 0.37822f
C44348 hold53/a_326_118# VGND 0.31683f
C44349 hold53/a_56_118# VGND 0.49842f
C44350 clkbuf_4_11_0_clk/a_27_118# VGND 2.36492f
C44351 FILLER_18_65/a_40_246# VGND 0.17934f
C44352 net182 VGND 0.52825f
C44353 _233_ VGND 0.57899f
C44354 net31 VGND 3.06702f
C44355 _414_/a_165_412# VGND 0
C44356 _178_ VGND 0.94637f
C44357 _345_/a_354_412# VGND 0
C44358 _345_/a_252_412# VGND 0
C44359 _345_/a_150_412# VGND 0.00111f
C44360 FILLER_24_218/a_40_246# VGND 0.16241f
C44361 FILLER_24_229/a_32_246# VGND 0.11923f
C44362 tx_inst.data_reg\[4\] VGND 1.11122f
C44363 hold171/a_438_182# VGND 0.37558f
C44364 hold171/a_326_118# VGND 0.31733f
C44365 hold171/a_56_118# VGND 0.48102f
C44366 hold182/a_438_182# VGND 0.37681f
C44367 hold182/a_326_118# VGND 0.31685f
C44368 hold182/a_56_118# VGND 0.4845f
C44369 hold160/a_438_182# VGND 0.37841f
C44370 hold160/a_326_118# VGND 0.32231f
C44371 hold160/a_56_118# VGND 0.52459f
C44372 _118_ VGND 0.87898f
C44373 FILLER_8_171/a_32_246# VGND 0.11921f
C44374 _285_ VGND 0.35935f
C44375 _283_ VGND 1.58228f
C44376 net92 VGND 1.71349f
C44377 net94 VGND 0.92871f
C44378 _500_/a_257_140# VGND 0.01152f
C44379 _500_/a_155_412# VGND 0.04406f
C44380 net35 VGND 2.71005f
C44381 _431_/a_379_118# VGND 0.01293f
C44382 _431_/a_277_118# VGND 0.00842f
C44383 _431_/a_175_118# VGND 0.00695f
C44384 _431_/a_81_118# VGND 0.41901f
C44385 _064_ VGND 0.89331f
C44386 net42 VGND 3.86446f
C44387 rx_done VGND 0.63389f
C44388 net20 VGND 0.54889f
C44389 output20/a_40_152# VGND 0.42618f
C44390 rx_inst.data_reg\[3\] VGND 0.4773f
C44391 net144 VGND 0.45165f
C44392 _646_/a_2002_114# VGND 0.00351f
C44393 _646_/a_1489_191# VGND 0.10582f
C44394 _646_/a_550_127# VGND 0
C44395 _646_/a_612_127# VGND 0.03858f
C44396 _646_/a_1785_429# VGND 0
C44397 _646_/a_2250_412# VGND 0.44309f
C44398 _646_/a_1840_334# VGND 0.25079f
C44399 _646_/a_1583_191# VGND 0.55788f
C44400 _646_/a_132_114# VGND 0
C44401 _646_/a_681_505# VGND 0
C44402 _646_/a_843_236# VGND 0.3969f
C44403 _646_/a_741_93# VGND 0.87065f
C44404 _646_/a_324_432# VGND 1.63211f
C44405 _646_/a_38_114# VGND 0.19734f
C44406 _646_/a_298_337# VGND 0.24428f
C44407 FILLER_6_23/a_32_246# VGND 0.11971f
C44408 hold96/a_438_182# VGND 0.37651f
C44409 hold96/a_326_118# VGND 0.31999f
C44410 hold96/a_56_118# VGND 0.4818f
C44411 tx_inst.state\[1\] VGND 0.39719f
C44412 clknet_4_7_0_clk VGND 2.54379f
C44413 _075_ VGND 0.87049f
C44414 _663_/a_2002_114# VGND 0.00349f
C44415 _663_/a_1489_191# VGND 0.09635f
C44416 _663_/a_550_127# VGND 0
C44417 _663_/a_612_127# VGND 0.039f
C44418 _663_/a_1785_429# VGND 0
C44419 _663_/a_2250_412# VGND 0.44191f
C44420 _663_/a_1840_334# VGND 0.25045f
C44421 _663_/a_1583_191# VGND 0.54868f
C44422 _663_/a_132_114# VGND 0
C44423 _663_/a_681_505# VGND 0
C44424 _663_/a_843_236# VGND 0.41355f
C44425 _663_/a_741_93# VGND 0.8769f
C44426 _663_/a_324_432# VGND 1.62269f
C44427 _663_/a_38_114# VGND 0.22588f
C44428 _663_/a_298_337# VGND 0.24623f
C44429 _083_ VGND 0.83404f
C44430 _079_ VGND 0.66549f
C44431 hold63/a_438_182# VGND 0.37581f
C44432 hold63/a_326_118# VGND 0.3174f
C44433 hold63/a_56_118# VGND 0.48231f
C44434 net74 VGND 0.4748f
C44435 _126_ VGND 0.30431f
C44436 hold74/a_438_182# VGND 0.3761f
C44437 hold74/a_326_118# VGND 0.31862f
C44438 hold74/a_56_118# VGND 0.48509f
C44439 net85 VGND 0.3937f
C44440 hold85/a_438_182# VGND 0.3767f
C44441 hold85/a_326_118# VGND 0.31826f
C44442 hold85/a_56_118# VGND 0.48135f
C44443 FILLER_20_65/a_32_246# VGND 0.11891f
C44444 hold52/a_438_182# VGND 0.37611f
C44445 hold52/a_326_118# VGND 0.31848f
C44446 hold52/a_56_118# VGND 0.48249f
C44447 _680_/a_2002_114# VGND 0.00345f
C44448 _680_/a_1489_191# VGND 0.10067f
C44449 _680_/a_550_127# VGND 0
C44450 _680_/a_612_127# VGND 0.03835f
C44451 _680_/a_1785_429# VGND 0
C44452 _680_/a_2250_412# VGND 0.44509f
C44453 _680_/a_1840_334# VGND 0.25169f
C44454 _680_/a_1583_191# VGND 0.55187f
C44455 _680_/a_132_114# VGND 0
C44456 _680_/a_681_505# VGND 0
C44457 _680_/a_843_236# VGND 0.39493f
C44458 _680_/a_741_93# VGND 0.87727f
C44459 _680_/a_324_432# VGND 1.63022f
C44460 _680_/a_38_114# VGND 0.19992f
C44461 _680_/a_298_337# VGND 0.247f
C44462 FILLER_0_35/a_40_246# VGND 0.18192f
C44463 FILLER_2_110/a_32_246# VGND 0.12469f
C44464 net177 VGND 0.51609f
C44465 clkbuf_4_12_0_clk/a_27_118# VGND 2.3548f
C44466 hold181/a_438_182# VGND 0.37965f
C44467 hold181/a_326_118# VGND 0.31999f
C44468 hold181/a_56_118# VGND 0.5189f
C44469 tx_inst.data_reg\[6\] VGND 1.2632f
C44470 hold170/a_438_182# VGND 0.37603f
C44471 hold170/a_326_118# VGND 0.31807f
C44472 hold170/a_56_118# VGND 0.48611f
C44473 FILLER_10_147/a_32_246# VGND 0.11944f
C44474 _226_ VGND 1.1237f
C44475 _415_/a_170_412# VGND 0
C44476 _179_ VGND 0.83562f
C44477 baud_inst.counter\[30\] VGND 1.26695f
C44478 baud_inst.counter\[31\] VGND 1.29545f
C44479 baud_inst.counter\[28\] VGND 1.87402f
C44480 _346_/a_354_412# VGND 0
C44481 _346_/a_252_412# VGND 0
C44482 _346_/a_150_412# VGND 0
C44483 _286_ VGND 0.69494f
C44484 _501_/a_154_118# VGND 0.00994f
C44485 _194_ VGND 0.99575f
C44486 _173_ VGND 0.81877f
C44487 _363_/a_22_110# VGND 0.23997f
C44488 _363_/a_120_432# VGND 0.00117f
C44489 FILLER_13_100/a_40_246# VGND 0.16608f
C44490 _248_ VGND 0.31621f
C44491 _246_ VGND 0.89602f
C44492 _432_/a_350_122# VGND 0.00277f
C44493 _432_/a_248_122# VGND 0.00782f
C44494 _432_/a_146_122# VGND 0.01189f
C44495 FILLER_7_7/a_40_246# VGND 0.18334f
C44496 FILLER_22_133/a_40_246# VGND 0.16291f
.ends
